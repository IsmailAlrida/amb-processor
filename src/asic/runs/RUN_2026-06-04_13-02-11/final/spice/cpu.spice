* NGSPICE file created from cpu.ext - technology: sky130A

* Black-box entry subcircuit for sky130_fd_sc_hd__fill_1 abstract view
.subckt sky130_fd_sc_hd__fill_1 VGND VNB VPB VPWR
.ends

* Black-box entry subcircuit for sky130_fd_sc_hd__fill_2 abstract view
.subckt sky130_fd_sc_hd__fill_2 VGND VNB VPB VPWR
.ends

* Black-box entry subcircuit for sky130_fd_sc_hd__a22o_1 abstract view
.subckt sky130_fd_sc_hd__a22o_1 A1 A2 B1 B2 VGND VNB VPB VPWR X
.ends

* Black-box entry subcircuit for sky130_fd_sc_hd__decap_6 abstract view
.subckt sky130_fd_sc_hd__decap_6 VGND VNB VPB VPWR
.ends

* Black-box entry subcircuit for sky130_ef_sc_hd__decap_12 abstract view
.subckt sky130_ef_sc_hd__decap_12 VPWR VGND VPB VNB
.ends

* Black-box entry subcircuit for sky130_fd_sc_hd__a21o_1 abstract view
.subckt sky130_fd_sc_hd__a21o_1 A1 A2 B1 VGND VNB VPB VPWR X
.ends

* Black-box entry subcircuit for sky130_fd_sc_hd__tapvpwrvgnd_1 abstract view
.subckt sky130_fd_sc_hd__tapvpwrvgnd_1 VGND VPWR
.ends

* Black-box entry subcircuit for sky130_fd_sc_hd__nand2_1 abstract view
.subckt sky130_fd_sc_hd__nand2_1 A B VGND VNB VPB VPWR Y
.ends

* Black-box entry subcircuit for sky130_fd_sc_hd__inv_2 abstract view
.subckt sky130_fd_sc_hd__inv_2 A VGND VNB VPB VPWR Y
.ends

* Black-box entry subcircuit for sky130_fd_sc_hd__mux2_1 abstract view
.subckt sky130_fd_sc_hd__mux2_1 A0 A1 S VGND VNB VPB VPWR X
.ends

* Black-box entry subcircuit for sky130_fd_sc_hd__decap_3 abstract view
.subckt sky130_fd_sc_hd__decap_3 VGND VNB VPB VPWR
.ends

* Black-box entry subcircuit for sky130_fd_sc_hd__decap_4 abstract view
.subckt sky130_fd_sc_hd__decap_4 VGND VNB VPB VPWR
.ends

* Black-box entry subcircuit for sky130_fd_sc_hd__decap_8 abstract view
.subckt sky130_fd_sc_hd__decap_8 VGND VNB VPB VPWR
.ends

* Black-box entry subcircuit for sky130_fd_sc_hd__a2bb2o_1 abstract view
.subckt sky130_fd_sc_hd__a2bb2o_1 A1_N A2_N B1 B2 VGND VNB VPB VPWR X
.ends

* Black-box entry subcircuit for sky130_fd_sc_hd__a22o_4 abstract view
.subckt sky130_fd_sc_hd__a22o_4 A1 A2 B1 B2 VGND VNB VPB VPWR X
.ends

* Black-box entry subcircuit for sky130_fd_sc_hd__a221o_1 abstract view
.subckt sky130_fd_sc_hd__a221o_1 A1 A2 B1 B2 C1 VGND VNB VPB VPWR X
.ends

* Black-box entry subcircuit for sky130_fd_sc_hd__a21oi_1 abstract view
.subckt sky130_fd_sc_hd__a21oi_1 A1 A2 B1 VGND VNB VPB VPWR Y
.ends

* Black-box entry subcircuit for sky130_fd_sc_hd__dfrtp_1 abstract view
.subckt sky130_fd_sc_hd__dfrtp_1 CLK D RESET_B VGND VNB VPB VPWR Q
.ends

* Black-box entry subcircuit for sky130_fd_sc_hd__and2_1 abstract view
.subckt sky130_fd_sc_hd__and2_1 A B VGND VNB VPB VPWR X
.ends

* Black-box entry subcircuit for sky130_fd_sc_hd__xnor2_1 abstract view
.subckt sky130_fd_sc_hd__xnor2_1 A B VGND VNB VPB VPWR Y
.ends

* Black-box entry subcircuit for sky130_fd_sc_hd__o32a_2 abstract view
.subckt sky130_fd_sc_hd__o32a_2 A1 A2 A3 B1 B2 VGND VNB VPB VPWR X
.ends

* Black-box entry subcircuit for sky130_fd_sc_hd__nor3_4 abstract view
.subckt sky130_fd_sc_hd__nor3_4 A B C VGND VNB VPB VPWR Y
.ends

* Black-box entry subcircuit for sky130_fd_sc_hd__o32a_1 abstract view
.subckt sky130_fd_sc_hd__o32a_1 A1 A2 A3 B1 B2 VGND VNB VPB VPWR X
.ends

* Black-box entry subcircuit for sky130_fd_sc_hd__and4_1 abstract view
.subckt sky130_fd_sc_hd__and4_1 A B C D VGND VNB VPB VPWR X
.ends

* Black-box entry subcircuit for sky130_fd_sc_hd__or2_1 abstract view
.subckt sky130_fd_sc_hd__or2_1 A B VGND VNB VPB VPWR X
.ends

* Black-box entry subcircuit for sky130_fd_sc_hd__o21ba_1 abstract view
.subckt sky130_fd_sc_hd__o21ba_1 A1 A2 B1_N VGND VNB VPB VPWR X
.ends

* Black-box entry subcircuit for sky130_fd_sc_hd__and3_1 abstract view
.subckt sky130_fd_sc_hd__and3_1 A B C VGND VNB VPB VPWR X
.ends

* Black-box entry subcircuit for sky130_fd_sc_hd__o22a_2 abstract view
.subckt sky130_fd_sc_hd__o22a_2 A1 A2 B1 B2 VGND VNB VPB VPWR X
.ends

* Black-box entry subcircuit for sky130_fd_sc_hd__or3b_4 abstract view
.subckt sky130_fd_sc_hd__or3b_4 A B C_N VGND VNB VPB VPWR X
.ends

* Black-box entry subcircuit for sky130_fd_sc_hd__a211o_1 abstract view
.subckt sky130_fd_sc_hd__a211o_1 A1 A2 B1 C1 VGND VNB VPB VPWR X
.ends

* Black-box entry subcircuit for sky130_fd_sc_hd__a31o_1 abstract view
.subckt sky130_fd_sc_hd__a31o_1 A1 A2 A3 B1 VGND VNB VPB VPWR X
.ends

* Black-box entry subcircuit for sky130_fd_sc_hd__o22ai_1 abstract view
.subckt sky130_fd_sc_hd__o22ai_1 A1 A2 B1 B2 VGND VNB VPB VPWR Y
.ends

* Black-box entry subcircuit for sky130_fd_sc_hd__dfrtp_2 abstract view
.subckt sky130_fd_sc_hd__dfrtp_2 CLK D RESET_B VGND VNB VPB VPWR Q
.ends

* Black-box entry subcircuit for sky130_fd_sc_hd__nor2_1 abstract view
.subckt sky130_fd_sc_hd__nor2_1 A B VGND VNB VPB VPWR Y
.ends

* Black-box entry subcircuit for sky130_fd_sc_hd__a31o_2 abstract view
.subckt sky130_fd_sc_hd__a31o_2 A1 A2 A3 B1 VGND VNB VPB VPWR X
.ends

* Black-box entry subcircuit for sky130_fd_sc_hd__dfrtp_4 abstract view
.subckt sky130_fd_sc_hd__dfrtp_4 CLK D RESET_B VGND VNB VPB VPWR Q
.ends

* Black-box entry subcircuit for sky130_fd_sc_hd__diode_2 abstract view
.subckt sky130_fd_sc_hd__diode_2 DIODE VGND VNB VPB VPWR
.ends

* Black-box entry subcircuit for sky130_fd_sc_hd__or2_4 abstract view
.subckt sky130_fd_sc_hd__or2_4 A B VGND VNB VPB VPWR X
.ends

* Black-box entry subcircuit for sky130_fd_sc_hd__o21a_4 abstract view
.subckt sky130_fd_sc_hd__o21a_4 A1 A2 B1 VGND VNB VPB VPWR X
.ends

* Black-box entry subcircuit for sky130_fd_sc_hd__nand2_2 abstract view
.subckt sky130_fd_sc_hd__nand2_2 A B VGND VNB VPB VPWR Y
.ends

* Black-box entry subcircuit for sky130_fd_sc_hd__o221a_1 abstract view
.subckt sky130_fd_sc_hd__o221a_1 A1 A2 B1 B2 C1 VGND VNB VPB VPWR X
.ends

* Black-box entry subcircuit for sky130_fd_sc_hd__o22a_1 abstract view
.subckt sky130_fd_sc_hd__o22a_1 A1 A2 B1 B2 VGND VNB VPB VPWR X
.ends

* Black-box entry subcircuit for sky130_fd_sc_hd__nand3_1 abstract view
.subckt sky130_fd_sc_hd__nand3_1 A B C VGND VNB VPB VPWR Y
.ends

* Black-box entry subcircuit for sky130_fd_sc_hd__buf_1 abstract view
.subckt sky130_fd_sc_hd__buf_1 A VGND VNB VPB VPWR X
.ends

* Black-box entry subcircuit for sky130_fd_sc_hd__nor2_8 abstract view
.subckt sky130_fd_sc_hd__nor2_8 A B VGND VNB VPB VPWR Y
.ends

* Black-box entry subcircuit for sky130_fd_sc_hd__nand2b_1 abstract view
.subckt sky130_fd_sc_hd__nand2b_1 A_N B VGND VNB VPB VPWR Y
.ends

* Black-box entry subcircuit for sky130_fd_sc_hd__and2_4 abstract view
.subckt sky130_fd_sc_hd__and2_4 A B VGND VNB VPB VPWR X
.ends

* Black-box entry subcircuit for sky130_fd_sc_hd__o21a_1 abstract view
.subckt sky130_fd_sc_hd__o21a_1 A1 A2 B1 VGND VNB VPB VPWR X
.ends

* Black-box entry subcircuit for sky130_fd_sc_hd__clkbuf_16 abstract view
.subckt sky130_fd_sc_hd__clkbuf_16 A VGND VNB VPB VPWR X
.ends

* Black-box entry subcircuit for sky130_fd_sc_hd__a2111o_1 abstract view
.subckt sky130_fd_sc_hd__a2111o_1 A1 A2 B1 C1 D1 VGND VNB VPB VPWR X
.ends

* Black-box entry subcircuit for sky130_fd_sc_hd__o21ai_1 abstract view
.subckt sky130_fd_sc_hd__o21ai_1 A1 A2 B1 VGND VNB VPB VPWR Y
.ends

* Black-box entry subcircuit for sky130_fd_sc_hd__or3_1 abstract view
.subckt sky130_fd_sc_hd__or3_1 A B C VGND VNB VPB VPWR X
.ends

* Black-box entry subcircuit for sky130_fd_sc_hd__or4_1 abstract view
.subckt sky130_fd_sc_hd__or4_1 A B C D VGND VNB VPB VPWR X
.ends

* Black-box entry subcircuit for sky130_fd_sc_hd__and3_4 abstract view
.subckt sky130_fd_sc_hd__and3_4 A B C VGND VNB VPB VPWR X
.ends

* Black-box entry subcircuit for sky130_fd_sc_hd__o22ai_4 abstract view
.subckt sky130_fd_sc_hd__o22ai_4 A1 A2 B1 B2 VGND VNB VPB VPWR Y
.ends

* Black-box entry subcircuit for sky130_fd_sc_hd__mux2_4 abstract view
.subckt sky130_fd_sc_hd__mux2_4 A0 A1 S VGND VNB VPB VPWR X
.ends

* Black-box entry subcircuit for sky130_fd_sc_hd__clkbuf_8 abstract view
.subckt sky130_fd_sc_hd__clkbuf_8 A VGND VNB VPB VPWR X
.ends

* Black-box entry subcircuit for sky130_fd_sc_hd__xor2_1 abstract view
.subckt sky130_fd_sc_hd__xor2_1 A B VGND VNB VPB VPWR X
.ends

* Black-box entry subcircuit for sky130_fd_sc_hd__o221ai_4 abstract view
.subckt sky130_fd_sc_hd__o221ai_4 A1 A2 B1 B2 C1 VGND VNB VPB VPWR Y
.ends

* Black-box entry subcircuit for sky130_fd_sc_hd__or4_2 abstract view
.subckt sky130_fd_sc_hd__or4_2 A B C D VGND VNB VPB VPWR X
.ends

* Black-box entry subcircuit for sky130_fd_sc_hd__nor3b_4 abstract view
.subckt sky130_fd_sc_hd__nor3b_4 A B C_N VGND VNB VPB VPWR Y
.ends

* Black-box entry subcircuit for sky130_fd_sc_hd__o31a_2 abstract view
.subckt sky130_fd_sc_hd__o31a_2 A1 A2 A3 B1 VGND VNB VPB VPWR X
.ends

* Black-box entry subcircuit for sky130_fd_sc_hd__a32o_1 abstract view
.subckt sky130_fd_sc_hd__a32o_1 A1 A2 A3 B1 B2 VGND VNB VPB VPWR X
.ends

* Black-box entry subcircuit for sky130_fd_sc_hd__or3_4 abstract view
.subckt sky130_fd_sc_hd__or3_4 A B C VGND VNB VPB VPWR X
.ends

* Black-box entry subcircuit for sky130_fd_sc_hd__o31a_1 abstract view
.subckt sky130_fd_sc_hd__o31a_1 A1 A2 A3 B1 VGND VNB VPB VPWR X
.ends

* Black-box entry subcircuit for sky130_fd_sc_hd__a31oi_1 abstract view
.subckt sky130_fd_sc_hd__a31oi_1 A1 A2 A3 B1 VGND VNB VPB VPWR Y
.ends

* Black-box entry subcircuit for sky130_fd_sc_hd__o211a_1 abstract view
.subckt sky130_fd_sc_hd__o211a_1 A1 A2 B1 C1 VGND VNB VPB VPWR X
.ends

* Black-box entry subcircuit for sky130_fd_sc_hd__a21o_4 abstract view
.subckt sky130_fd_sc_hd__a21o_4 A1 A2 B1 VGND VNB VPB VPWR X
.ends

* Black-box entry subcircuit for sky130_fd_sc_hd__nand2_4 abstract view
.subckt sky130_fd_sc_hd__nand2_4 A B VGND VNB VPB VPWR Y
.ends

* Black-box entry subcircuit for sky130_fd_sc_hd__mux2_2 abstract view
.subckt sky130_fd_sc_hd__mux2_2 A0 A1 S VGND VNB VPB VPWR X
.ends

* Black-box entry subcircuit for sky130_fd_sc_hd__or4b_1 abstract view
.subckt sky130_fd_sc_hd__or4b_1 A B C D_N VGND VNB VPB VPWR X
.ends

* Black-box entry subcircuit for sky130_fd_sc_hd__o32ai_4 abstract view
.subckt sky130_fd_sc_hd__o32ai_4 A1 A2 A3 B1 B2 VGND VNB VPB VPWR Y
.ends

* Black-box entry subcircuit for sky130_fd_sc_hd__nand3_4 abstract view
.subckt sky130_fd_sc_hd__nand3_4 A B C VGND VNB VPB VPWR Y
.ends

* Black-box entry subcircuit for sky130_fd_sc_hd__o2bb2a_1 abstract view
.subckt sky130_fd_sc_hd__o2bb2a_1 A1_N A2_N B1 B2 VGND VNB VPB VPWR X
.ends

* Black-box entry subcircuit for sky130_fd_sc_hd__a311o_1 abstract view
.subckt sky130_fd_sc_hd__a311o_1 A1 A2 A3 B1 C1 VGND VNB VPB VPWR X
.ends

* Black-box entry subcircuit for sky130_fd_sc_hd__o32a_4 abstract view
.subckt sky130_fd_sc_hd__o32a_4 A1 A2 A3 B1 B2 VGND VNB VPB VPWR X
.ends

* Black-box entry subcircuit for sky130_fd_sc_hd__nand4_1 abstract view
.subckt sky130_fd_sc_hd__nand4_1 A B C D VGND VNB VPB VPWR Y
.ends

* Black-box entry subcircuit for sky130_fd_sc_hd__inv_6 abstract view
.subckt sky130_fd_sc_hd__inv_6 A VGND VNB VPB VPWR Y
.ends

* Black-box entry subcircuit for sky130_fd_sc_hd__o31ai_2 abstract view
.subckt sky130_fd_sc_hd__o31ai_2 A1 A2 A3 B1 VGND VNB VPB VPWR Y
.ends

* Black-box entry subcircuit for sky130_fd_sc_hd__a211o_2 abstract view
.subckt sky130_fd_sc_hd__a211o_2 A1 A2 B1 C1 VGND VNB VPB VPWR X
.ends

* Black-box entry subcircuit for sky130_fd_sc_hd__or4_4 abstract view
.subckt sky130_fd_sc_hd__or4_4 A B C D VGND VNB VPB VPWR X
.ends

* Black-box entry subcircuit for sky130_fd_sc_hd__o41a_1 abstract view
.subckt sky130_fd_sc_hd__o41a_1 A1 A2 A3 A4 B1 VGND VNB VPB VPWR X
.ends

* Black-box entry subcircuit for sky130_fd_sc_hd__o22a_4 abstract view
.subckt sky130_fd_sc_hd__o22a_4 A1 A2 B1 B2 VGND VNB VPB VPWR X
.ends

* Black-box entry subcircuit for sky130_fd_sc_hd__and2b_2 abstract view
.subckt sky130_fd_sc_hd__and2b_2 A_N B VGND VNB VPB VPWR X
.ends

* Black-box entry subcircuit for sky130_fd_sc_hd__o211a_4 abstract view
.subckt sky130_fd_sc_hd__o211a_4 A1 A2 B1 C1 VGND VNB VPB VPWR X
.ends

* Black-box entry subcircuit for sky130_fd_sc_hd__nor2_4 abstract view
.subckt sky130_fd_sc_hd__nor2_4 A B VGND VNB VPB VPWR Y
.ends

* Black-box entry subcircuit for sky130_fd_sc_hd__bufinv_16 abstract view
.subckt sky130_fd_sc_hd__bufinv_16 A VGND VNB VPB VPWR Y
.ends

* Black-box entry subcircuit for sky130_fd_sc_hd__and2b_1 abstract view
.subckt sky130_fd_sc_hd__and2b_1 A_N B VGND VNB VPB VPWR X
.ends

* Black-box entry subcircuit for sky130_fd_sc_hd__and3b_1 abstract view
.subckt sky130_fd_sc_hd__and3b_1 A_N B C VGND VNB VPB VPWR X
.ends

* Black-box entry subcircuit for sky130_fd_sc_hd__a2111oi_2 abstract view
.subckt sky130_fd_sc_hd__a2111oi_2 A1 A2 B1 C1 D1 VGND VNB VPB VPWR Y
.ends

* Black-box entry subcircuit for sky130_fd_sc_hd__and4_4 abstract view
.subckt sky130_fd_sc_hd__and4_4 A B C D VGND VNB VPB VPWR X
.ends

* Black-box entry subcircuit for sky130_fd_sc_hd__clkinvlp_4 abstract view
.subckt sky130_fd_sc_hd__clkinvlp_4 A VGND VNB VPB VPWR Y
.ends

* Black-box entry subcircuit for sky130_fd_sc_hd__clkbuf_2 abstract view
.subckt sky130_fd_sc_hd__clkbuf_2 A VGND VNB VPB VPWR X
.ends

* Black-box entry subcircuit for sky130_fd_sc_hd__nor2_2 abstract view
.subckt sky130_fd_sc_hd__nor2_2 A B VGND VNB VPB VPWR Y
.ends

* Black-box entry subcircuit for sky130_fd_sc_hd__a2bb2o_2 abstract view
.subckt sky130_fd_sc_hd__a2bb2o_2 A1_N A2_N B1 B2 VGND VNB VPB VPWR X
.ends

* Black-box entry subcircuit for sky130_fd_sc_hd__xnor2_2 abstract view
.subckt sky130_fd_sc_hd__xnor2_2 A B VGND VNB VPB VPWR Y
.ends

* Black-box entry subcircuit for sky130_fd_sc_hd__a221oi_1 abstract view
.subckt sky130_fd_sc_hd__a221oi_1 A1 A2 B1 B2 C1 VGND VNB VPB VPWR Y
.ends

* Black-box entry subcircuit for sky130_fd_sc_hd__a31oi_2 abstract view
.subckt sky130_fd_sc_hd__a31oi_2 A1 A2 A3 B1 VGND VNB VPB VPWR Y
.ends

* Black-box entry subcircuit for sky130_fd_sc_hd__or3b_1 abstract view
.subckt sky130_fd_sc_hd__or3b_1 A B C_N VGND VNB VPB VPWR X
.ends

* Black-box entry subcircuit for sky130_fd_sc_hd__o211ai_2 abstract view
.subckt sky130_fd_sc_hd__o211ai_2 A1 A2 B1 C1 VGND VNB VPB VPWR Y
.ends

* Black-box entry subcircuit for sky130_fd_sc_hd__inv_8 abstract view
.subckt sky130_fd_sc_hd__inv_8 A VGND VNB VPB VPWR Y
.ends

* Black-box entry subcircuit for sky130_fd_sc_hd__nor4_1 abstract view
.subckt sky130_fd_sc_hd__nor4_1 A B C D VGND VNB VPB VPWR Y
.ends

* Black-box entry subcircuit for sky130_fd_sc_hd__nor3_2 abstract view
.subckt sky130_fd_sc_hd__nor3_2 A B C VGND VNB VPB VPWR Y
.ends

* Black-box entry subcircuit for sky130_fd_sc_hd__o2111a_1 abstract view
.subckt sky130_fd_sc_hd__o2111a_1 A1 A2 B1 C1 D1 VGND VNB VPB VPWR X
.ends

* Black-box entry subcircuit for sky130_fd_sc_hd__clkbuf_4 abstract view
.subckt sky130_fd_sc_hd__clkbuf_4 A VGND VNB VPB VPWR X
.ends

* Black-box entry subcircuit for sky130_fd_sc_hd__nand2_8 abstract view
.subckt sky130_fd_sc_hd__nand2_8 A B VGND VNB VPB VPWR Y
.ends

* Black-box entry subcircuit for sky130_fd_sc_hd__a21bo_1 abstract view
.subckt sky130_fd_sc_hd__a21bo_1 A1 A2 B1_N VGND VNB VPB VPWR X
.ends

* Black-box entry subcircuit for sky130_fd_sc_hd__a21oi_4 abstract view
.subckt sky130_fd_sc_hd__a21oi_4 A1 A2 B1 VGND VNB VPB VPWR Y
.ends

* Black-box entry subcircuit for sky130_fd_sc_hd__clkinv_4 abstract view
.subckt sky130_fd_sc_hd__clkinv_4 A VGND VNB VPB VPWR Y
.ends

* Black-box entry subcircuit for sky130_fd_sc_hd__and4bb_4 abstract view
.subckt sky130_fd_sc_hd__and4bb_4 A_N B_N C D VGND VNB VPB VPWR X
.ends

* Black-box entry subcircuit for sky130_fd_sc_hd__o21bai_4 abstract view
.subckt sky130_fd_sc_hd__o21bai_4 A1 A2 B1_N VGND VNB VPB VPWR Y
.ends

* Black-box entry subcircuit for sky130_fd_sc_hd__or4b_2 abstract view
.subckt sky130_fd_sc_hd__or4b_2 A B C D_N VGND VNB VPB VPWR X
.ends

* Black-box entry subcircuit for sky130_fd_sc_hd__a211oi_1 abstract view
.subckt sky130_fd_sc_hd__a211oi_1 A1 A2 B1 C1 VGND VNB VPB VPWR Y
.ends

* Black-box entry subcircuit for sky130_fd_sc_hd__clkinv_8 abstract view
.subckt sky130_fd_sc_hd__clkinv_8 A VGND VNB VPB VPWR Y
.ends

* Black-box entry subcircuit for sky130_fd_sc_hd__clkinv_2 abstract view
.subckt sky130_fd_sc_hd__clkinv_2 A VGND VNB VPB VPWR Y
.ends

* Black-box entry subcircuit for sky130_fd_sc_hd__nor4b_1 abstract view
.subckt sky130_fd_sc_hd__nor4b_1 A B C D_N VGND VNB VPB VPWR Y
.ends

* Black-box entry subcircuit for sky130_fd_sc_hd__o2bb2a_2 abstract view
.subckt sky130_fd_sc_hd__o2bb2a_2 A1_N A2_N B1 B2 VGND VNB VPB VPWR X
.ends

* Black-box entry subcircuit for sky130_fd_sc_hd__o211ai_4 abstract view
.subckt sky130_fd_sc_hd__o211ai_4 A1 A2 B1 C1 VGND VNB VPB VPWR Y
.ends

* Black-box entry subcircuit for sky130_fd_sc_hd__o21bai_2 abstract view
.subckt sky130_fd_sc_hd__o21bai_2 A1 A2 B1_N VGND VNB VPB VPWR Y
.ends

* Black-box entry subcircuit for sky130_fd_sc_hd__o211ai_1 abstract view
.subckt sky130_fd_sc_hd__o211ai_1 A1 A2 B1 C1 VGND VNB VPB VPWR Y
.ends

* Black-box entry subcircuit for sky130_fd_sc_hd__a22oi_1 abstract view
.subckt sky130_fd_sc_hd__a22oi_1 A1 A2 B1 B2 VGND VNB VPB VPWR Y
.ends

* Black-box entry subcircuit for sky130_fd_sc_hd__clkbuf_1 abstract view
.subckt sky130_fd_sc_hd__clkbuf_1 A VGND VNB VPB VPWR X
.ends

* Black-box entry subcircuit for sky130_fd_sc_hd__or3_2 abstract view
.subckt sky130_fd_sc_hd__or3_2 A B C VGND VNB VPB VPWR X
.ends

* Black-box entry subcircuit for sky130_fd_sc_hd__o21ai_4 abstract view
.subckt sky130_fd_sc_hd__o21ai_4 A1 A2 B1 VGND VNB VPB VPWR Y
.ends

* Black-box entry subcircuit for sky130_fd_sc_hd__clkinv_16 abstract view
.subckt sky130_fd_sc_hd__clkinv_16 A VGND VNB VPB VPWR Y
.ends

* Black-box entry subcircuit for sky130_fd_sc_hd__and4_2 abstract view
.subckt sky130_fd_sc_hd__and4_2 A B C D VGND VNB VPB VPWR X
.ends

* Black-box entry subcircuit for sky130_fd_sc_hd__or4b_4 abstract view
.subckt sky130_fd_sc_hd__or4b_4 A B C D_N VGND VNB VPB VPWR X
.ends

* Black-box entry subcircuit for sky130_fd_sc_hd__a21boi_1 abstract view
.subckt sky130_fd_sc_hd__a21boi_1 A1 A2 B1_N VGND VNB VPB VPWR Y
.ends

* Black-box entry subcircuit for sky130_fd_sc_hd__and2b_4 abstract view
.subckt sky130_fd_sc_hd__and2b_4 A_N B VGND VNB VPB VPWR X
.ends

* Black-box entry subcircuit for sky130_fd_sc_hd__o2111ai_2 abstract view
.subckt sky130_fd_sc_hd__o2111ai_2 A1 A2 B1 C1 D1 VGND VNB VPB VPWR Y
.ends

* Black-box entry subcircuit for sky130_fd_sc_hd__a41o_4 abstract view
.subckt sky130_fd_sc_hd__a41o_4 A1 A2 A3 A4 B1 VGND VNB VPB VPWR X
.ends

* Black-box entry subcircuit for sky130_fd_sc_hd__mux2_8 abstract view
.subckt sky130_fd_sc_hd__mux2_8 A0 A1 S VGND VNB VPB VPWR X
.ends

* Black-box entry subcircuit for sky130_fd_sc_hd__conb_1 abstract view
.subckt sky130_fd_sc_hd__conb_1 VGND VNB VPB VPWR HI LO
.ends

* Black-box entry subcircuit for sky130_fd_sc_hd__buf_4 abstract view
.subckt sky130_fd_sc_hd__buf_4 A VGND VNB VPB VPWR X
.ends

* Black-box entry subcircuit for sky130_fd_sc_hd__buf_12 abstract view
.subckt sky130_fd_sc_hd__buf_12 A VGND VNB VPB VPWR X
.ends

* Black-box entry subcircuit for sky130_fd_sc_hd__o21ai_2 abstract view
.subckt sky130_fd_sc_hd__o21ai_2 A1 A2 B1 VGND VNB VPB VPWR Y
.ends

* Black-box entry subcircuit for sky130_fd_sc_hd__or3b_2 abstract view
.subckt sky130_fd_sc_hd__or3b_2 A B C_N VGND VNB VPB VPWR X
.ends

* Black-box entry subcircuit for sky130_fd_sc_hd__dlymetal6s2s_1 abstract view
.subckt sky130_fd_sc_hd__dlymetal6s2s_1 A VGND VNB VPB VPWR X
.ends

* Black-box entry subcircuit for sky130_fd_sc_hd__a21o_2 abstract view
.subckt sky130_fd_sc_hd__a21o_2 A1 A2 B1 VGND VNB VPB VPWR X
.ends

* Black-box entry subcircuit for sky130_fd_sc_hd__a21oi_2 abstract view
.subckt sky130_fd_sc_hd__a21oi_2 A1 A2 B1 VGND VNB VPB VPWR Y
.ends

* Black-box entry subcircuit for sky130_fd_sc_hd__buf_6 abstract view
.subckt sky130_fd_sc_hd__buf_6 A VGND VNB VPB VPWR X
.ends

* Black-box entry subcircuit for sky130_fd_sc_hd__and2_2 abstract view
.subckt sky130_fd_sc_hd__and2_2 A B VGND VNB VPB VPWR X
.ends

* Black-box entry subcircuit for sky130_fd_sc_hd__and4b_1 abstract view
.subckt sky130_fd_sc_hd__and4b_1 A_N B C D VGND VNB VPB VPWR X
.ends

* Black-box entry subcircuit for sky130_fd_sc_hd__o221ai_2 abstract view
.subckt sky130_fd_sc_hd__o221ai_2 A1 A2 B1 B2 C1 VGND VNB VPB VPWR Y
.ends

* Black-box entry subcircuit for sky130_fd_sc_hd__o311a_1 abstract view
.subckt sky130_fd_sc_hd__o311a_1 A1 A2 A3 B1 C1 VGND VNB VPB VPWR X
.ends

* Black-box entry subcircuit for sky130_fd_sc_hd__and4b_4 abstract view
.subckt sky130_fd_sc_hd__and4b_4 A_N B C D VGND VNB VPB VPWR X
.ends

* Black-box entry subcircuit for sky130_fd_sc_hd__and4bb_1 abstract view
.subckt sky130_fd_sc_hd__and4bb_1 A_N B_N C D VGND VNB VPB VPWR X
.ends

* Black-box entry subcircuit for sky130_fd_sc_hd__nor3b_1 abstract view
.subckt sky130_fd_sc_hd__nor3b_1 A B C_N VGND VNB VPB VPWR Y
.ends

* Black-box entry subcircuit for sky130_fd_sc_hd__o21bai_1 abstract view
.subckt sky130_fd_sc_hd__o21bai_1 A1 A2 B1_N VGND VNB VPB VPWR Y
.ends

* Black-box entry subcircuit for sky130_fd_sc_hd__a2111o_2 abstract view
.subckt sky130_fd_sc_hd__a2111o_2 A1 A2 B1 C1 D1 VGND VNB VPB VPWR X
.ends

* Black-box entry subcircuit for sky130_fd_sc_hd__and3_2 abstract view
.subckt sky130_fd_sc_hd__and3_2 A B C VGND VNB VPB VPWR X
.ends

* Black-box entry subcircuit for sky130_fd_sc_hd__a31oi_4 abstract view
.subckt sky130_fd_sc_hd__a31oi_4 A1 A2 A3 B1 VGND VNB VPB VPWR Y
.ends

* Black-box entry subcircuit for sky130_fd_sc_hd__buf_8 abstract view
.subckt sky130_fd_sc_hd__buf_8 A VGND VNB VPB VPWR X
.ends

* Black-box entry subcircuit for sky130_fd_sc_hd__a311oi_2 abstract view
.subckt sky130_fd_sc_hd__a311oi_2 A1 A2 A3 B1 C1 VGND VNB VPB VPWR Y
.ends

* Black-box entry subcircuit for sky130_fd_sc_hd__o21a_2 abstract view
.subckt sky130_fd_sc_hd__o21a_2 A1 A2 B1 VGND VNB VPB VPWR X
.ends

* Black-box entry subcircuit for sky130_fd_sc_hd__nor3_1 abstract view
.subckt sky130_fd_sc_hd__nor3_1 A B C VGND VNB VPB VPWR Y
.ends

* Black-box entry subcircuit for sky130_fd_sc_hd__or2_2 abstract view
.subckt sky130_fd_sc_hd__or2_2 A B VGND VNB VPB VPWR X
.ends

* Black-box entry subcircuit for sky130_fd_sc_hd__a221o_2 abstract view
.subckt sky130_fd_sc_hd__a221o_2 A1 A2 B1 B2 C1 VGND VNB VPB VPWR X
.ends

* Black-box entry subcircuit for sky130_fd_sc_hd__a31o_4 abstract view
.subckt sky130_fd_sc_hd__a31o_4 A1 A2 A3 B1 VGND VNB VPB VPWR X
.ends

* Black-box entry subcircuit for sky130_fd_sc_hd__a2111oi_1 abstract view
.subckt sky130_fd_sc_hd__a2111oi_1 A1 A2 B1 C1 D1 VGND VNB VPB VPWR Y
.ends

* Black-box entry subcircuit for sky130_fd_sc_hd__nand3b_2 abstract view
.subckt sky130_fd_sc_hd__nand3b_2 A_N B C VGND VNB VPB VPWR Y
.ends

* Black-box entry subcircuit for sky130_fd_sc_hd__a21boi_2 abstract view
.subckt sky130_fd_sc_hd__a21boi_2 A1 A2 B1_N VGND VNB VPB VPWR Y
.ends

.subckt cpu DataAddress[0] DataAddress[10] DataAddress[11] DataAddress[12] DataAddress[13]
+ DataAddress[14] DataAddress[15] DataAddress[16] DataAddress[17] DataAddress[18]
+ DataAddress[19] DataAddress[1] DataAddress[20] DataAddress[21] DataAddress[22] DataAddress[23]
+ DataAddress[24] DataAddress[25] DataAddress[26] DataAddress[27] DataAddress[2] DataAddress[3]
+ DataAddress[4] DataAddress[5] DataAddress[6] DataAddress[7] DataAddress[8] DataAddress[9]
+ DataMemoryRead[0] DataMemoryRead[10] DataMemoryRead[11] DataMemoryRead[12] DataMemoryRead[13]
+ DataMemoryRead[14] DataMemoryRead[15] DataMemoryRead[16] DataMemoryRead[17] DataMemoryRead[18]
+ DataMemoryRead[19] DataMemoryRead[1] DataMemoryRead[20] DataMemoryRead[21] DataMemoryRead[22]
+ DataMemoryRead[23] DataMemoryRead[24] DataMemoryRead[25] DataMemoryRead[26] DataMemoryRead[27]
+ DataMemoryRead[2] DataMemoryRead[3] DataMemoryRead[4] DataMemoryRead[5] DataMemoryRead[6]
+ DataMemoryRead[7] DataMemoryRead[8] DataMemoryRead[9] DataMemoryWrite[0] DataMemoryWrite[10]
+ DataMemoryWrite[11] DataMemoryWrite[12] DataMemoryWrite[13] DataMemoryWrite[14]
+ DataMemoryWrite[15] DataMemoryWrite[16] DataMemoryWrite[17] DataMemoryWrite[18]
+ DataMemoryWrite[19] DataMemoryWrite[1] DataMemoryWrite[20] DataMemoryWrite[21] DataMemoryWrite[22]
+ DataMemoryWrite[23] DataMemoryWrite[24] DataMemoryWrite[25] DataMemoryWrite[26]
+ DataMemoryWrite[27] DataMemoryWrite[2] DataMemoryWrite[3] DataMemoryWrite[4] DataMemoryWrite[5]
+ DataMemoryWrite[6] DataMemoryWrite[7] DataMemoryWrite[8] DataMemoryWrite[9] DmemReadEn
+ DmemWriteEn IC[0] IC[10] IC[11] IC[12] IC[13] IC[14] IC[15] IC[16] IC[17] IC[18]
+ IC[19] IC[1] IC[20] IC[21] IC[22] IC[23] IC[24] IC[25] IC[26] IC[27] IC[2] IC[3]
+ IC[4] IC[5] IC[6] IC[7] IC[8] IC[9] VGND VPWR clk halt instr[0] instr[10] instr[11]
+ instr[12] instr[13] instr[14] instr[15] instr[1] instr[2] instr[3] instr[4] instr[5]
+ instr[6] instr[7] instr[8] instr[9] reset
XFILLER_100_149 VGND VGND VPWR VPWR sky130_fd_sc_hd__fill_1
XFILLER_100_138 VGND VGND VPWR VPWR sky130_fd_sc_hd__fill_2
XFILLER_79_391 VGND VGND VPWR VPWR sky130_fd_sc_hd__fill_1
X_3155_ reg_file_inst.registry\[4\]\[27\] _1092_ _1094_ reg_file_inst.registry\[6\]\[27\]
+ VGND VGND VPWR VPWR _1099_ sky130_fd_sc_hd__a22o_1
XFILLER_39_255 VGND VGND VPWR VPWR sky130_fd_sc_hd__fill_2
XFILLER_82_545 VGND VGND VPWR VPWR sky130_fd_sc_hd__decap_6
XFILLER_67_597 VPWR VGND VPWR VGND sky130_ef_sc_hd__decap_12
X_3086_ JMPOFF\[9\] net141 net41 VGND VGND VPWR VPWR _1030_ sky130_fd_sc_hd__a21o_1
XFILLER_54_269 VPWR VGND VPWR VGND sky130_ef_sc_hd__decap_12
XFILLER_82_589 VPWR VGND VPWR VGND sky130_ef_sc_hd__decap_12
XTAP_TAPCELL_ROW_53_927 VGND VPWR sky130_fd_sc_hd__tapvpwrvgnd_1
XFILLER_52_29 VPWR VGND VPWR VGND sky130_ef_sc_hd__decap_12
XTAP_TAPCELL_ROW_33_673 VGND VPWR sky130_fd_sc_hd__tapvpwrvgnd_1
X_3988_ _1044_ _1885_ VGND VGND VPWR VPWR _1904_ sky130_fd_sc_hd__nand2_1
XFILLER_50_475 VGND VGND VPWR VPWR sky130_fd_sc_hd__fill_1
X_5727_ net146 VGND VGND VPWR VPWR _0135_ sky130_fd_sc_hd__inv_2
X_5658_ net149 VGND VGND VPWR VPWR _0066_ sky130_fd_sc_hd__inv_2
X_4609_ _2339_ _2361_ _1790_ VGND VGND VPWR VPWR _2486_ sky130_fd_sc_hd__mux2_1
XFILLER_2_505 VPWR VGND VPWR VGND sky130_ef_sc_hd__decap_12
X_5589_ reg_file_inst.registry\[15\]\[3\] _2478_ _3003_ VGND VGND VPWR VPWR _0478_
+ sky130_fd_sc_hd__mux2_1
XFILLER_117_55 VGND VGND VPWR VPWR sky130_fd_sc_hd__fill_1
XFILLER_77_15 VPWR VGND VPWR VGND sky130_ef_sc_hd__decap_12
XFILLER_104_477 VPWR VGND VPWR VGND sky130_ef_sc_hd__decap_12
XFILLER_89_177 VPWR VGND VPWR VGND sky130_ef_sc_hd__decap_12
XTAP_TAPCELL_ROW_5_321 VGND VPWR sky130_fd_sc_hd__tapvpwrvgnd_1
XFILLER_58_531 VGND VGND VPWR VPWR sky130_fd_sc_hd__fill_1
XTAP_TAPCELL_ROW_5_332 VGND VPWR sky130_fd_sc_hd__tapvpwrvgnd_1
XFILLER_92_309 VPWR VGND VPWR VGND sky130_ef_sc_hd__decap_12
XFILLER_73_501 VGND VGND VPWR VPWR sky130_fd_sc_hd__decap_3
XFILLER_73_545 VGND VGND VPWR VPWR sky130_fd_sc_hd__fill_1
XFILLER_73_512 VPWR VGND VPWR VGND sky130_ef_sc_hd__decap_12
XFILLER_18_428 VGND VGND VPWR VPWR sky130_fd_sc_hd__fill_2
XFILLER_14_601 VPWR VGND VPWR VGND sky130_ef_sc_hd__decap_12
XFILLER_26_63 VPWR VGND VPWR VGND sky130_ef_sc_hd__decap_12
XFILLER_60_239 VGND VGND VPWR VPWR sky130_fd_sc_hd__decap_4
XFILLER_13_111 VGND VGND VPWR VPWR sky130_fd_sc_hd__fill_1
XFILLER_14_645 VPWR VGND VPWR VGND sky130_ef_sc_hd__decap_12
XFILLER_26_85 VPWR VGND VPWR VGND sky130_ef_sc_hd__decap_12
XFILLER_115_709 VPWR VGND VPWR VGND sky130_ef_sc_hd__decap_12
XFILLER_107_293 VPWR VGND VPWR VGND sky130_ef_sc_hd__decap_12
XFILLER_96_637 VGND VGND VPWR VPWR sky130_fd_sc_hd__decap_6
XFILLER_68_339 VGND VGND VPWR VPWR sky130_fd_sc_hd__fill_1
XFILLER_110_469 VGND VGND VPWR VPWR sky130_fd_sc_hd__decap_6
XFILLER_95_169 VGND VGND VPWR VPWR sky130_fd_sc_hd__decap_4
XFILLER_76_361 VGND VGND VPWR VPWR sky130_fd_sc_hd__decap_3
XFILLER_67_81 VGND VGND VPWR VPWR sky130_fd_sc_hd__fill_2
XTAP_TAPCELL_ROW_108_1616 VGND VPWR sky130_fd_sc_hd__tapvpwrvgnd_1
XFILLER_36_203 VGND VGND VPWR VPWR sky130_fd_sc_hd__fill_1
XFILLER_36_236 VGND VGND VPWR VPWR sky130_fd_sc_hd__decap_8
XFILLER_83_80 VPWR VGND VPWR VGND sky130_ef_sc_hd__decap_12
XFILLER_64_589 VPWR VGND VPWR VGND sky130_ef_sc_hd__decap_12
X_4960_ _1255_ _1267_ _2289_ _2808_ VGND VGND VPWR VPWR _2809_ sky130_fd_sc_hd__a2bb2o_1
X_4891_ net19 net101 net63 _2308_ VGND VGND VPWR VPWR _2747_ sky130_fd_sc_hd__a22o_4
X_3911_ reg_file_inst.registry\[3\]\[0\] _1091_ _1092_ reg_file_inst.registry\[4\]\[0\]
+ VGND VGND VPWR VPWR _1828_ sky130_fd_sc_hd__a22o_1
X_3842_ reg_file_inst.registry\[7\]\[3\] _1086_ _1091_ reg_file_inst.registry\[3\]\[3\]
+ _1754_ VGND VGND VPWR VPWR _1762_ sky130_fd_sc_hd__a221o_1
XPHY_EDGE_ROW_17_Left_140 VGND VGND VPWR VPWR sky130_fd_sc_hd__decap_3
XTAP_TAPCELL_ROW_80_1270 VGND VPWR sky130_fd_sc_hd__tapvpwrvgnd_1
X_5512_ reg_file_inst.registry\[6\]\[22\] _2817_ _3001_ VGND VGND VPWR VPWR _0553_
+ sky130_fd_sc_hd__mux2_1
XFILLER_9_671 VGND VGND VPWR VPWR sky130_fd_sc_hd__fill_1
XTAP_TAPCELL_ROW_30_643 VGND VPWR sky130_fd_sc_hd__tapvpwrvgnd_1
X_3773_ _1693_ _1694_ _1669_ VGND VGND VPWR VPWR _1695_ sky130_fd_sc_hd__a21oi_1
XTAP_TAPCELL_ROW_119_1756 VGND VPWR sky130_fd_sc_hd__tapvpwrvgnd_1
XFILLER_118_525 VGND VGND VPWR VPWR sky130_fd_sc_hd__decap_6
X_6492_ clknet_leaf_22_clk _0900_ _0425_ VGND VGND VPWR VPWR reg_file_inst.registry\[7\]\[25\]
+ sky130_fd_sc_hd__dfrtp_1
XFILLER_118_569 VPWR VGND VPWR VGND sky130_ef_sc_hd__decap_12
X_5443_ _2455_ reg_file_inst.registry\[10\]\[4\] _2998_ VGND VGND VPWR VPWR _0619_
+ sky130_fd_sc_hd__mux2_1
X_5374_ MEMOFF\[15\] _2897_ _2996_ VGND VGND VPWR VPWR _0686_ sky130_fd_sc_hd__mux2_1
X_4325_ _1446_ _2190_ VGND VGND VPWR VPWR _2213_ sky130_fd_sc_hd__and2_1
X_4256_ _1735_ _2143_ VGND VGND VPWR VPWR _2144_ sky130_fd_sc_hd__xnor2_1
X_3207_ _1146_ _1147_ _1150_ _1118_ reg_file_inst.registry\[0\]\[27\] VGND VGND VPWR
+ VPWR net92 sky130_fd_sc_hd__o32a_2
X_4187_ _1909_ _2084_ _1906_ VGND VGND VPWR VPWR _2090_ sky130_fd_sc_hd__a21oi_1
X_3138_ net34 net40 net41 VGND VGND VPWR VPWR _1082_ sky130_fd_sc_hd__nor3_4
XFILLER_27_225 VPWR VGND VPWR VGND sky130_ef_sc_hd__decap_12
XFILLER_103_57 VPWR VGND VPWR VGND sky130_ef_sc_hd__decap_12
XFILLER_82_342 VPWR VGND VPWR VGND sky130_ef_sc_hd__decap_12
XTAP_TAPCELL_ROW_38_743 VGND VPWR sky130_fd_sc_hd__tapvpwrvgnd_1
X_3069_ _0955_ _1008_ _1010_ _1006_ _0954_ VGND VGND VPWR VPWR _1013_ sky130_fd_sc_hd__o32a_1
XFILLER_11_615 VGND VGND VPWR VPWR sky130_fd_sc_hd__fill_1
XFILLER_23_486 VGND VGND VPWR VPWR sky130_fd_sc_hd__decap_4
XFILLER_109_503 VGND VGND VPWR VPWR sky130_fd_sc_hd__fill_1
XFILLER_6_118 VGND VGND VPWR VPWR sky130_fd_sc_hd__decap_3
XTAP_TAPCELL_ROW_94_1439 VGND VPWR sky130_fd_sc_hd__tapvpwrvgnd_1
XFILLER_120_701 VPWR VGND VPWR VGND sky130_ef_sc_hd__decap_12
XFILLER_78_637 VGND VGND VPWR VPWR sky130_fd_sc_hd__decap_6
XFILLER_93_629 VPWR VGND VPWR VGND sky130_ef_sc_hd__decap_12
XFILLER_19_704 VGND VGND VPWR VPWR sky130_fd_sc_hd__fill_1
XFILLER_92_139 VGND VGND VPWR VPWR sky130_fd_sc_hd__fill_1
XFILLER_86_681 VPWR VGND VPWR VGND sky130_ef_sc_hd__decap_12
XFILLER_37_51 VGND VGND VPWR VPWR sky130_fd_sc_hd__decap_4
XFILLER_73_353 VGND VGND VPWR VPWR sky130_fd_sc_hd__fill_1
XFILLER_61_526 VGND VGND VPWR VPWR sky130_fd_sc_hd__fill_1
XFILLER_46_589 VGND VGND VPWR VPWR sky130_fd_sc_hd__fill_2
XFILLER_26_280 VGND VGND VPWR VPWR sky130_fd_sc_hd__decap_6
XTAP_TAPCELL_ROW_103_1557 VGND VPWR sky130_fd_sc_hd__tapvpwrvgnd_1
XTAP_TAPCELL_ROW_103_1546 VGND VPWR sky130_fd_sc_hd__tapvpwrvgnd_1
XTAP_TAPCELL_ROW_16_459 VGND VPWR sky130_fd_sc_hd__tapvpwrvgnd_1
XFILLER_10_681 VPWR VGND VPWR VGND sky130_ef_sc_hd__decap_12
XFILLER_115_517 VPWR VGND VPWR VGND sky130_ef_sc_hd__decap_12
XTAP_TAPCELL_ROW_114_1686 VGND VPWR sky130_fd_sc_hd__tapvpwrvgnd_1
XFILLER_110_233 VPWR VGND VPWR VGND sky130_ef_sc_hd__decap_12
X_4110_ net116 net131 _2024_ _2025_ VGND VGND VPWR VPWR _2026_ sky130_fd_sc_hd__and4_1
X_5090_ _2128_ _2920_ _2720_ VGND VGND VPWR VPWR _2921_ sky130_fd_sc_hd__a21oi_1
XFILLER_1_390 VGND VGND VPWR VPWR sky130_fd_sc_hd__fill_2
X_4041_ _1011_ _1956_ VGND VGND VPWR VPWR _1957_ sky130_fd_sc_hd__or2_1
XFILLER_110_277 VPWR VGND VPWR VGND sky130_ef_sc_hd__decap_12
XTAP_TAPCELL_ROW_69_1121 VGND VPWR sky130_fd_sc_hd__tapvpwrvgnd_1
XTAP_TAPCELL_ROW_69_1132 VGND VPWR sky130_fd_sc_hd__tapvpwrvgnd_1
X_5992_ net146 VGND VGND VPWR VPWR _0400_ sky130_fd_sc_hd__inv_2
XTAP_TAPCELL_ROW_35_702 VGND VPWR sky130_fd_sc_hd__tapvpwrvgnd_1
XFILLER_64_397 VGND VGND VPWR VPWR sky130_fd_sc_hd__decap_3
X_4943_ _1231_ _2123_ _2286_ _1243_ _2288_ VGND VGND VPWR VPWR _2794_ sky130_fd_sc_hd__a221o_1
X_4874_ _1841_ _2357_ _2354_ VGND VGND VPWR VPWR _2731_ sky130_fd_sc_hd__o21ba_1
X_3825_ reg_file_inst.registry\[10\]\[5\] _1123_ net144 VGND VGND VPWR VPWR _1746_
+ sky130_fd_sc_hd__and3_1
XFILLER_118_333 VPWR VGND VPWR VGND sky130_ef_sc_hd__decap_12
X_3756_ reg_file_inst.registry\[0\]\[6\] net138 _1673_ _1678_ VGND VGND VPWR VPWR
+ _1679_ sky130_fd_sc_hd__o22a_2
X_6475_ clknet_leaf_50_clk _0883_ _0408_ VGND VGND VPWR VPWR reg_file_inst.registry\[7\]\[8\]
+ sky130_fd_sc_hd__dfrtp_1
XFILLER_118_377 VPWR VGND VPWR VGND sky130_ef_sc_hd__decap_12
X_5426_ _2829_ reg_file_inst.registry\[10\]\[21\] _2998_ VGND VGND VPWR VPWR _0636_
+ sky130_fd_sc_hd__mux2_1
X_3687_ reg_file_inst.registry\[8\]\[8\] _1136_ _1139_ reg_file_inst.registry\[5\]\[8\]
+ _1611_ VGND VGND VPWR VPWR _1612_ sky130_fd_sc_hd__a221o_1
XFILLER_102_701 VPWR VGND VPWR VGND sky130_ef_sc_hd__decap_12
X_5357_ _2478_ reg_file_inst.registry\[3\]\[3\] _2995_ VGND VGND VPWR VPWR _0702_
+ sky130_fd_sc_hd__mux2_1
XFILLER_87_445 VGND VGND VPWR VPWR sky130_fd_sc_hd__decap_3
X_5288_ _2909_ reg_file_inst.registry\[2\]\[14\] _2993_ VGND VGND VPWR VPWR _0769_
+ sky130_fd_sc_hd__mux2_1
X_4308_ net132 _2193_ _2195_ VGND VGND VPWR VPWR _2196_ sky130_fd_sc_hd__o21ba_1
XFILLER_75_629 VPWR VGND VPWR VGND sky130_ef_sc_hd__decap_12
X_4239_ _1112_ _2123_ _2125_ VGND VGND VPWR VPWR _2127_ sky130_fd_sc_hd__or3b_4
XFILLER_74_27 VGND VGND VPWR VPWR sky130_fd_sc_hd__fill_1
XFILLER_55_331 VGND VGND VPWR VPWR sky130_fd_sc_hd__decap_4
XFILLER_83_673 VPWR VGND VPWR VGND sky130_ef_sc_hd__decap_12
XFILLER_83_662 VGND VGND VPWR VPWR sky130_fd_sc_hd__decap_8
XFILLER_51_570 VPWR VGND VPWR VGND sky130_ef_sc_hd__decap_12
XFILLER_11_401 VGND VGND VPWR VPWR sky130_fd_sc_hd__decap_8
XTAP_TAPCELL_ROW_13_429 VGND VPWR sky130_fd_sc_hd__tapvpwrvgnd_1
XFILLER_23_53 VGND VGND VPWR VPWR sky130_fd_sc_hd__decap_3
XFILLER_11_467 VPWR VGND VPWR VGND sky130_ef_sc_hd__decap_12
XFILLER_23_75 VGND VGND VPWR VPWR sky130_fd_sc_hd__decap_8
XFILLER_23_86 VGND VGND VPWR VPWR sky130_fd_sc_hd__fill_2
XFILLER_105_561 VPWR VGND VPWR VGND sky130_ef_sc_hd__decap_12
XFILLER_2_132 VGND VGND VPWR VPWR sky130_fd_sc_hd__decap_3
XFILLER_2_154 VGND VGND VPWR VPWR sky130_fd_sc_hd__decap_8
XFILLER_120_531 VGND VGND VPWR VPWR sky130_fd_sc_hd__fill_1
XFILLER_38_309 VPWR VGND VPWR VGND sky130_ef_sc_hd__decap_12
XFILLER_59_670 VGND VGND VPWR VPWR sky130_fd_sc_hd__fill_2
XFILLER_19_501 VGND VGND VPWR VPWR sky130_fd_sc_hd__decap_3
XFILLER_48_83 VGND VGND VPWR VPWR sky130_fd_sc_hd__fill_1
XFILLER_0_24 VGND VGND VPWR VPWR sky130_fd_sc_hd__decap_4
XFILLER_19_545 VGND VGND VPWR VPWR sky130_fd_sc_hd__decap_3
XFILLER_74_684 VGND VGND VPWR VPWR sky130_fd_sc_hd__decap_6
XFILLER_61_301 VGND VGND VPWR VPWR sky130_fd_sc_hd__decap_3
XFILLER_0_57 VGND VGND VPWR VPWR sky130_fd_sc_hd__decap_3
XFILLER_64_82 VGND VGND VPWR VPWR sky130_fd_sc_hd__fill_2
XFILLER_34_548 VPWR VGND VPWR VGND sky130_ef_sc_hd__decap_12
XTAP_TAPCELL_ROW_64_1062 VGND VPWR sky130_fd_sc_hd__tapvpwrvgnd_1
XFILLER_30_721 VGND VGND VPWR VPWR sky130_fd_sc_hd__fill_2
XFILLER_42_592 VGND VGND VPWR VPWR sky130_fd_sc_hd__decap_4
XFILLER_9_55 VGND VGND VPWR VPWR sky130_fd_sc_hd__fill_1
XPHY_EDGE_ROW_104_Right_104 VGND VGND VPWR VPWR sky130_fd_sc_hd__decap_3
X_4590_ _2468_ VGND VGND VPWR VPWR _2469_ sky130_fd_sc_hd__inv_2
X_3610_ reg_file_inst.registry\[8\]\[11\] _1136_ _1138_ reg_file_inst.registry\[14\]\[11\]
+ VGND VGND VPWR VPWR _1538_ sky130_fd_sc_hd__a22o_1
XTAP_TAPCELL_ROW_40_760 VGND VPWR sky130_fd_sc_hd__tapvpwrvgnd_1
XTAP_TAPCELL_ROW_116_1715 VGND VPWR sky130_fd_sc_hd__tapvpwrvgnd_1
X_3541_ reg_file_inst.registry\[8\]\[15\] _1090_ _1095_ JMPOFF\[15\] VGND VGND VPWR
+ VPWR _1471_ sky130_fd_sc_hd__a22o_1
X_6260_ clknet_leaf_22_clk _0668_ _0193_ VGND VGND VPWR VPWR reg_file_inst.registry\[4\]\[25\]
+ sky130_fd_sc_hd__dfrtp_1
X_3472_ reg_file_inst.registry\[7\]\[17\] _1119_ net142 VGND VGND VPWR VPWR _1405_
+ sky130_fd_sc_hd__and3_1
X_5211_ reg_file_inst.registry\[11\]\[19\] _2478_ _2989_ VGND VGND VPWR VPWR _0842_
+ sky130_fd_sc_hd__mux2_1
X_6191_ clknet_leaf_2_clk _0599_ _0124_ VGND VGND VPWR VPWR reg_file_inst.registry\[5\]\[12\]
+ sky130_fd_sc_hd__dfrtp_1
XFILLER_97_721 VGND VGND VPWR VPWR sky130_fd_sc_hd__decap_4
X_5142_ _1764_ _2519_ _2964_ _1708_ VGND VGND VPWR VPWR _2965_ sky130_fd_sc_hd__a211o_1
XFILLER_111_553 VGND VGND VPWR VPWR sky130_fd_sc_hd__decap_6
XFILLER_111_597 VPWR VGND VPWR VGND sky130_ef_sc_hd__decap_12
XFILLER_69_489 VPWR VGND VPWR VGND sky130_ef_sc_hd__decap_12
XFILLER_57_629 VPWR VGND VPWR VGND sky130_ef_sc_hd__decap_12
X_5073_ _1518_ _2286_ _2905_ _1517_ _2904_ VGND VGND VPWR VPWR _2906_ sky130_fd_sc_hd__a221o_1
X_4024_ _1022_ _1878_ _1939_ net126 VGND VGND VPWR VPWR _1940_ sky130_fd_sc_hd__a31o_1
XFILLER_64_161 VPWR VGND VPWR VGND sky130_ef_sc_hd__decap_12
XFILLER_37_364 VGND VGND VPWR VPWR sky130_fd_sc_hd__fill_2
XTAP_TAPCELL_ROW_48_860 VGND VPWR sky130_fd_sc_hd__tapvpwrvgnd_1
XFILLER_80_643 VGND VGND VPWR VPWR sky130_fd_sc_hd__fill_1
XFILLER_65_695 VGND VGND VPWR VPWR sky130_fd_sc_hd__decap_8
XFILLER_25_559 VGND VGND VPWR VPWR sky130_fd_sc_hd__fill_1
XFILLER_44_19 VGND VGND VPWR VPWR sky130_fd_sc_hd__decap_8
X_5975_ net147 VGND VGND VPWR VPWR _0383_ sky130_fd_sc_hd__inv_2
X_4926_ _1217_ _2282_ _2285_ _1218_ VGND VGND VPWR VPWR _2779_ sky130_fd_sc_hd__o22ai_1
XFILLER_21_721 VGND VGND VPWR VPWR sky130_fd_sc_hd__decap_4
XFILLER_33_581 VGND VGND VPWR VPWR sky130_fd_sc_hd__decap_3
XFILLER_100_69 VPWR VGND VPWR VGND sky130_ef_sc_hd__decap_12
X_4857_ net20 net101 net64 _2308_ VGND VGND VPWR VPWR _2715_ sky130_fd_sc_hd__a22o_4
X_3808_ reg_file_inst.registry\[11\]\[5\] _1096_ _1727_ _1728_ VGND VGND VPWR VPWR
+ _1729_ sky130_fd_sc_hd__a211o_1
XFILLER_20_253 VPWR VGND VPWR VGND sky130_ef_sc_hd__decap_12
XFILLER_119_653 VPWR VGND VPWR VGND sky130_ef_sc_hd__decap_12
XFILLER_118_141 VPWR VGND VPWR VGND sky130_ef_sc_hd__decap_12
X_4788_ _1469_ _2645_ VGND VGND VPWR VPWR _2647_ sky130_fd_sc_hd__or2_1
XFILLER_20_297 VGND VGND VPWR VPWR sky130_fd_sc_hd__decap_8
X_6527_ clknet_leaf_48_clk _0935_ _0460_ VGND VGND VPWR VPWR net106 sky130_fd_sc_hd__dfrtp_1
XFILLER_119_697 VPWR VGND VPWR VGND sky130_ef_sc_hd__decap_12
X_3739_ reg_file_inst.registry\[9\]\[7\] _1131_ _1140_ reg_file_inst.registry\[3\]\[7\]
+ VGND VGND VPWR VPWR _1663_ sky130_fd_sc_hd__a22o_1
XFILLER_4_408 VPWR VGND VPWR VGND sky130_ef_sc_hd__decap_12
X_6458_ clknet_leaf_24_clk _0866_ _0391_ VGND VGND VPWR VPWR reg_file_inst.registry\[0\]\[19\]
+ sky130_fd_sc_hd__dfrtp_2
XFILLER_121_317 VPWR VGND VPWR VGND sky130_ef_sc_hd__decap_12
X_6389_ clknet_leaf_11_clk _0797_ _0322_ VGND VGND VPWR VPWR reg_file_inst.registry\[14\]\[14\]
+ sky130_fd_sc_hd__dfrtp_1
X_5409_ reg_file_inst.registry\[4\]\[9\] _2974_ _2997_ VGND VGND VPWR VPWR _0652_
+ sky130_fd_sc_hd__mux2_1
XFILLER_85_15 VPWR VGND VPWR VGND sky130_ef_sc_hd__decap_12
XFILLER_0_669 VGND VGND VPWR VPWR sky130_fd_sc_hd__decap_3
XFILLER_28_331 VPWR VGND VPWR VGND sky130_ef_sc_hd__decap_12
XFILLER_70_120 VGND VGND VPWR VPWR sky130_fd_sc_hd__decap_8
XFILLER_70_153 VGND VGND VPWR VPWR sky130_fd_sc_hd__decap_6
XTAP_TAPCELL_ROW_100_1516 VGND VPWR sky130_fd_sc_hd__tapvpwrvgnd_1
XFILLER_12_710 VGND VGND VPWR VPWR sky130_fd_sc_hd__decap_8
XTAP_TAPCELL_ROW_26_587 VGND VPWR sky130_fd_sc_hd__tapvpwrvgnd_1
XFILLER_34_85 VGND VGND VPWR VPWR sky130_fd_sc_hd__decap_6
XFILLER_98_529 VGND VGND VPWR VPWR sky130_fd_sc_hd__decap_3
XFILLER_3_441 VGND VGND VPWR VPWR sky130_fd_sc_hd__decap_6
XFILLER_79_721 VGND VGND VPWR VPWR sky130_fd_sc_hd__decap_4
XFILLER_3_485 VGND VGND VPWR VPWR sky130_fd_sc_hd__decap_4
XTAP_TAPCELL_ROW_111_1656 VGND VPWR sky130_fd_sc_hd__tapvpwrvgnd_1
XFILLER_94_713 VPWR VGND VPWR VGND sky130_ef_sc_hd__decap_12
XFILLER_78_275 VPWR VGND VPWR VGND sky130_ef_sc_hd__decap_12
XFILLER_39_629 VGND VGND VPWR VPWR sky130_fd_sc_hd__decap_8
XFILLER_38_139 VGND VGND VPWR VPWR sky130_fd_sc_hd__fill_1
XFILLER_75_70 VPWR VGND VPWR VGND sky130_ef_sc_hd__decap_12
XFILLER_19_353 VGND VGND VPWR VPWR sky130_fd_sc_hd__fill_1
XFILLER_62_621 VPWR VGND VPWR VGND sky130_ef_sc_hd__decap_12
XTAP_TAPCELL_ROW_45_830 VGND VPWR sky130_fd_sc_hd__tapvpwrvgnd_1
XFILLER_98_3 VPWR VGND VPWR VGND sky130_ef_sc_hd__decap_12
XFILLER_62_687 VGND VGND VPWR VPWR sky130_fd_sc_hd__decap_3
X_5760_ net146 VGND VGND VPWR VPWR _0168_ sky130_fd_sc_hd__inv_2
XTAP_TAPCELL_ROW_122_1796 VGND VPWR sky130_fd_sc_hd__tapvpwrvgnd_1
XTAP_TAPCELL_ROW_122_1785 VGND VPWR sky130_fd_sc_hd__tapvpwrvgnd_1
XFILLER_91_80 VGND VGND VPWR VPWR sky130_fd_sc_hd__fill_1
X_5691_ net147 VGND VGND VPWR VPWR _0099_ sky130_fd_sc_hd__inv_2
X_4711_ _1195_ _2569_ VGND VGND VPWR VPWR _2570_ sky130_fd_sc_hd__nor2_1
X_4642_ _1764_ _2504_ _2516_ VGND VGND VPWR VPWR _2517_ sky130_fd_sc_hd__a21oi_1
XFILLER_116_601 VPWR VGND VPWR VGND sky130_ef_sc_hd__decap_12
XTAP_TAPCELL_ROW_77_1231 VGND VPWR sky130_fd_sc_hd__tapvpwrvgnd_1
X_4573_ _2255_ _2447_ _2453_ _2446_ VGND VGND VPWR VPWR net67 sky130_fd_sc_hd__a31o_2
XFILLER_116_645 VPWR VGND VPWR VGND sky130_ef_sc_hd__decap_12
XFILLER_115_111 VGND VGND VPWR VPWR sky130_fd_sc_hd__fill_1
X_6312_ clknet_leaf_30_clk _0720_ _0245_ VGND VGND VPWR VPWR reg_file_inst.registry\[3\]\[21\]
+ sky130_fd_sc_hd__dfrtp_1
X_3524_ reg_file_inst.registry\[14\]\[13\] _1081_ _1092_ reg_file_inst.registry\[4\]\[13\]
+ VGND VGND VPWR VPWR _1455_ sky130_fd_sc_hd__a22o_1
X_3455_ reg_file_inst.registry\[9\]\[16\] _1131_ _1138_ reg_file_inst.registry\[14\]\[16\]
+ _1387_ VGND VGND VPWR VPWR _1389_ sky130_fd_sc_hd__a221o_1
X_6243_ clknet_leaf_46_clk _0651_ _0176_ VGND VGND VPWR VPWR reg_file_inst.registry\[4\]\[8\]
+ sky130_fd_sc_hd__dfrtp_1
XFILLER_103_328 VGND VGND VPWR VPWR sky130_fd_sc_hd__decap_8
XFILLER_97_540 VGND VGND VPWR VPWR sky130_fd_sc_hd__decap_8
X_6174_ clknet_leaf_36_clk _0582_ _0107_ VGND VGND VPWR VPWR JMPOFF\[23\] sky130_fd_sc_hd__dfrtp_4
X_3386_ _1307_ _1320_ VGND VGND VPWR VPWR _1322_ sky130_fd_sc_hd__xnor2_1
XFILLER_111_361 VPWR VGND VPWR VGND sky130_ef_sc_hd__decap_12
X_5125_ _2482_ _2486_ _1764_ VGND VGND VPWR VPWR _2950_ sky130_fd_sc_hd__mux2_1
X_5056_ _2275_ _2711_ _2800_ _2279_ _2890_ VGND VGND VPWR VPWR _2891_ sky130_fd_sc_hd__a221o_1
XTAP_TAPCELL_ROW_88_1360 VGND VPWR sky130_fd_sc_hd__tapvpwrvgnd_1
XFILLER_84_289 VGND VGND VPWR VPWR sky130_fd_sc_hd__decap_6
XFILLER_38_662 VPWR VGND VPWR VGND sky130_ef_sc_hd__decap_12
X_4007_ _1901_ _1922_ VGND VGND VPWR VPWR _1923_ sky130_fd_sc_hd__nor2_1
XPHY_EDGE_ROW_9_Left_132 VGND VGND VPWR VPWR sky130_fd_sc_hd__decap_3
XFILLER_25_356 VGND VGND VPWR VPWR sky130_fd_sc_hd__fill_2
XFILLER_111_57 VPWR VGND VPWR VGND sky130_ef_sc_hd__decap_12
X_5958_ net147 VGND VGND VPWR VPWR _0366_ sky130_fd_sc_hd__inv_2
XFILLER_52_197 VGND VGND VPWR VPWR sky130_fd_sc_hd__decap_3
XTAP_TAPCELL_ROW_23_546 VGND VPWR sky130_fd_sc_hd__tapvpwrvgnd_1
X_4909_ _2404_ _2763_ _1791_ VGND VGND VPWR VPWR _2764_ sky130_fd_sc_hd__mux2_1
X_5889_ net147 VGND VGND VPWR VPWR _0297_ sky130_fd_sc_hd__inv_2
XTAP_TAPCELL_ROW_51_899 VGND VPWR sky130_fd_sc_hd__tapvpwrvgnd_1
XTAP_TAPCELL_ROW_23_557 VGND VPWR sky130_fd_sc_hd__tapvpwrvgnd_1
XFILLER_119_461 VPWR VGND VPWR VGND sky130_ef_sc_hd__decap_12
XFILLER_106_133 VGND VGND VPWR VPWR sky130_fd_sc_hd__decap_6
XFILLER_121_125 VPWR VGND VPWR VGND sky130_ef_sc_hd__decap_12
XFILLER_106_177 VPWR VGND VPWR VGND sky130_ef_sc_hd__decap_12
XFILLER_0_433 VGND VGND VPWR VPWR sky130_fd_sc_hd__fill_1
XFILLER_121_169 VPWR VGND VPWR VGND sky130_ef_sc_hd__decap_12
XFILLER_102_361 VGND VGND VPWR VPWR sky130_fd_sc_hd__decap_3
XFILLER_76_713 VGND VGND VPWR VPWR sky130_fd_sc_hd__decap_4
XFILLER_0_466 VGND VGND VPWR VPWR sky130_fd_sc_hd__decap_8
XFILLER_48_404 VGND VGND VPWR VPWR sky130_fd_sc_hd__decap_6
XFILLER_75_223 VGND VGND VPWR VPWR sky130_fd_sc_hd__fill_1
XFILLER_75_278 VGND VGND VPWR VPWR sky130_fd_sc_hd__fill_2
XTAP_TAPCELL_ROW_59_999 VGND VPWR sky130_fd_sc_hd__tapvpwrvgnd_1
XFILLER_28_172 VPWR VGND VPWR VGND sky130_ef_sc_hd__decap_12
XFILLER_44_632 VPWR VGND VPWR VGND sky130_ef_sc_hd__decap_12
XFILLER_45_51 VGND VGND VPWR VPWR sky130_fd_sc_hd__fill_2
XFILLER_43_186 VGND VGND VPWR VPWR sky130_fd_sc_hd__fill_1
XFILLER_44_698 VGND VGND VPWR VPWR sky130_fd_sc_hd__fill_2
XTAP_TAPCELL_ROW_61_1032 VGND VPWR sky130_fd_sc_hd__tapvpwrvgnd_1
XTAP_TAPCELL_ROW_61_1021 VGND VPWR sky130_fd_sc_hd__tapvpwrvgnd_1
XFILLER_31_337 VGND VGND VPWR VPWR sky130_fd_sc_hd__decap_6
XFILLER_8_522 VGND VGND VPWR VPWR sky130_fd_sc_hd__decap_8
XFILLER_8_533 VPWR VGND VPWR VGND sky130_ef_sc_hd__decap_12
XANTENNA_5 _1119_ VGND VGND VPWR VPWR sky130_fd_sc_hd__diode_2
XFILLER_113_615 VGND VGND VPWR VPWR sky130_fd_sc_hd__fill_1
XFILLER_3_271 VGND VGND VPWR VPWR sky130_fd_sc_hd__fill_1
X_3240_ reg_file_inst.registry\[1\]\[25\] _1087_ _1097_ reg_file_inst.registry\[5\]\[25\]
+ VGND VGND VPWR VPWR _1182_ sky130_fd_sc_hd__a22o_1
XFILLER_79_551 VGND VGND VPWR VPWR sky130_fd_sc_hd__decap_8
XTAP_TAPCELL_ROW_72_1161 VGND VPWR sky130_fd_sc_hd__tapvpwrvgnd_1
XFILLER_100_309 VPWR VGND VPWR VGND sky130_ef_sc_hd__decap_12
XFILLER_66_201 VGND VGND VPWR VPWR sky130_fd_sc_hd__fill_1
X_3171_ net29 net35 VGND VGND VPWR VPWR _1115_ sky130_fd_sc_hd__or2_4
XFILLER_94_554 VGND VGND VPWR VPWR sky130_fd_sc_hd__decap_4
XFILLER_66_223 VGND VGND VPWR VPWR sky130_fd_sc_hd__decap_6
XFILLER_13_3 VPWR VGND VPWR VGND sky130_ef_sc_hd__decap_12
XFILLER_26_109 VGND VGND VPWR VPWR sky130_fd_sc_hd__decap_6
XFILLER_94_598 VPWR VGND VPWR VGND sky130_ef_sc_hd__decap_12
XFILLER_19_172 VGND VGND VPWR VPWR sky130_fd_sc_hd__fill_2
XFILLER_34_120 VGND VGND VPWR VPWR sky130_fd_sc_hd__decap_8
X_5812_ net149 VGND VGND VPWR VPWR _0220_ sky130_fd_sc_hd__inv_2
XFILLER_34_153 VGND VGND VPWR VPWR sky130_fd_sc_hd__fill_2
XFILLER_35_687 VPWR VGND VPWR VGND sky130_ef_sc_hd__decap_12
XFILLER_50_657 VPWR VGND VPWR VGND sky130_ef_sc_hd__decap_12
XFILLER_34_186 VGND VGND VPWR VPWR sky130_fd_sc_hd__decap_4
XFILLER_34_197 VGND VGND VPWR VPWR sky130_fd_sc_hd__fill_2
X_5743_ net147 VGND VGND VPWR VPWR _0151_ sky130_fd_sc_hd__inv_2
X_5674_ net44 VGND VGND VPWR VPWR _0082_ sky130_fd_sc_hd__inv_2
XTAP_TAPCELL_ROW_20_516 VGND VPWR sky130_fd_sc_hd__tapvpwrvgnd_1
XFILLER_30_392 VPWR VGND VPWR VGND sky130_ef_sc_hd__decap_12
X_4625_ net21 _2309_ _2500_ VGND VGND VPWR VPWR _2501_ sky130_fd_sc_hd__o21a_4
X_4556_ _2124_ _2289_ VGND VGND VPWR VPWR _2437_ sky130_fd_sc_hd__nand2_2
X_3507_ reg_file_inst.registry\[8\]\[12\] _1136_ _1139_ reg_file_inst.registry\[5\]\[12\]
+ VGND VGND VPWR VPWR _1439_ sky130_fd_sc_hd__a22o_1
XFILLER_116_475 VGND VGND VPWR VPWR sky130_fd_sc_hd__fill_1
XFILLER_104_637 VGND VGND VPWR VPWR sky130_fd_sc_hd__decap_6
XFILLER_89_337 VGND VGND VPWR VPWR sky130_fd_sc_hd__decap_4
XFILLER_89_315 VPWR VGND VPWR VGND sky130_ef_sc_hd__decap_12
X_4487_ _2192_ _2352_ _2370_ _2249_ _2255_ VGND VGND VPWR VPWR _2372_ sky130_fd_sc_hd__o221a_1
X_6226_ clknet_leaf_20_clk _0634_ _0159_ VGND VGND VPWR VPWR reg_file_inst.registry\[10\]\[19\]
+ sky130_fd_sc_hd__dfrtp_1
XFILLER_103_125 VGND VGND VPWR VPWR sky130_fd_sc_hd__decap_6
X_3438_ _1347_ _1371_ VGND VGND VPWR VPWR _1372_ sky130_fd_sc_hd__or2_1
XFILLER_112_681 VPWR VGND VPWR VGND sky130_ef_sc_hd__decap_12
X_3369_ reg_file_inst.registry\[0\]\[20\] _1076_ _1299_ _1305_ VGND VGND VPWR VPWR
+ _1306_ sky130_fd_sc_hd__o22a_1
XFILLER_58_713 VGND VGND VPWR VPWR sky130_fd_sc_hd__decap_4
X_6157_ clknet_leaf_60_clk _0565_ _0090_ VGND VGND VPWR VPWR JMPOFF\[6\] sky130_fd_sc_hd__dfrtp_4
XFILLER_66_39 VGND VGND VPWR VPWR sky130_fd_sc_hd__fill_1
X_5108_ _2608_ _2609_ VGND VGND VPWR VPWR _2935_ sky130_fd_sc_hd__nand2_1
X_6088_ clknet_leaf_42_clk _0496_ _0021_ VGND VGND VPWR VPWR reg_file_inst.registry\[15\]\[21\]
+ sky130_fd_sc_hd__dfrtp_1
XTAP_TAPCELL_ROW_28_616 VGND VPWR sky130_fd_sc_hd__tapvpwrvgnd_1
X_5039_ _1382_ _1392_ _2284_ VGND VGND VPWR VPWR _2876_ sky130_fd_sc_hd__nand3_1
XFILLER_82_27 VGND VGND VPWR VPWR sky130_fd_sc_hd__fill_1
XTAP_TAPCELL_ROW_56_969 VGND VPWR sky130_fd_sc_hd__tapvpwrvgnd_1
XTAP_TAPCELL_ROW_56_958 VGND VPWR sky130_fd_sc_hd__tapvpwrvgnd_1
XFILLER_53_440 VGND VGND VPWR VPWR sky130_fd_sc_hd__decap_8
XTAP_TAPCELL_ROW_0_252 VGND VPWR sky130_fd_sc_hd__tapvpwrvgnd_1
XTAP_TAPCELL_ROW_0_263 VGND VPWR sky130_fd_sc_hd__tapvpwrvgnd_1
XFILLER_25_120 VPWR VGND VPWR VGND sky130_ef_sc_hd__decap_12
XFILLER_53_473 VGND VGND VPWR VPWR sky130_fd_sc_hd__decap_8
XFILLER_26_698 VGND VGND VPWR VPWR sky130_fd_sc_hd__fill_2
XFILLER_13_337 VGND VGND VPWR VPWR sky130_fd_sc_hd__fill_1
XFILLER_31_20 VGND VGND VPWR VPWR sky130_fd_sc_hd__decap_6
XFILLER_107_497 VGND VGND VPWR VPWR sky130_fd_sc_hd__decap_6
XFILLER_122_445 VGND VGND VPWR VPWR sky130_fd_sc_hd__decap_3
XTAP_TAPCELL_ROW_8_363 VGND VPWR sky130_fd_sc_hd__tapvpwrvgnd_1
Xoutput53 net53 VGND VGND VPWR VPWR DataAddress[17] sky130_fd_sc_hd__buf_1
Xoutput64 net64 VGND VGND VPWR VPWR DataAddress[27] sky130_fd_sc_hd__buf_1
Xoutput75 net75 VGND VGND VPWR VPWR DataMemoryWrite[11] sky130_fd_sc_hd__buf_1
XFILLER_122_489 VPWR VGND VPWR VGND sky130_ef_sc_hd__decap_12
Xoutput86 net86 VGND VGND VPWR VPWR DataMemoryWrite[21] sky130_fd_sc_hd__buf_1
XFILLER_0_263 VGND VGND VPWR VPWR sky130_fd_sc_hd__decap_4
Xoutput97 net97 VGND VGND VPWR VPWR DataMemoryWrite[6] sky130_fd_sc_hd__buf_1
XFILLER_48_234 VPWR VGND VPWR VGND sky130_ef_sc_hd__decap_12
XFILLER_48_278 VGND VGND VPWR VPWR sky130_fd_sc_hd__decap_8
XFILLER_63_204 VGND VGND VPWR VPWR sky130_fd_sc_hd__fill_2
XFILLER_17_610 VGND VGND VPWR VPWR sky130_fd_sc_hd__decap_6
XFILLER_17_621 VGND VGND VPWR VPWR sky130_fd_sc_hd__fill_1
XFILLER_29_470 VGND VGND VPWR VPWR sky130_fd_sc_hd__fill_2
XTAP_TAPCELL_ROW_106_1588 VGND VPWR sky130_fd_sc_hd__tapvpwrvgnd_1
XFILLER_71_281 VPWR VGND VPWR VGND sky130_ef_sc_hd__decap_12
XFILLER_16_197 VGND VGND VPWR VPWR sky130_fd_sc_hd__decap_4
XFILLER_44_495 VPWR VGND VPWR VGND sky130_ef_sc_hd__decap_12
XFILLER_72_82 VGND VGND VPWR VPWR sky130_fd_sc_hd__fill_2
XFILLER_117_217 VGND VGND VPWR VPWR sky130_fd_sc_hd__decap_6
XFILLER_8_363 VGND VGND VPWR VPWR sky130_fd_sc_hd__fill_1
XFILLER_12_392 VGND VGND VPWR VPWR sky130_fd_sc_hd__fill_2
X_4410_ _1151_ _1841_ _2190_ VGND VGND VPWR VPWR _2298_ sky130_fd_sc_hd__and3_1
X_5390_ _1115_ _2552_ VGND VGND VPWR VPWR _2997_ sky130_fd_sc_hd__nor2_8
X_4341_ _2196_ _2200_ net134 VGND VGND VPWR VPWR _2229_ sky130_fd_sc_hd__mux2_1
X_4272_ _2159_ _1826_ VGND VGND VPWR VPWR _2160_ sky130_fd_sc_hd__nand2b_1
XFILLER_101_629 VPWR VGND VPWR VGND sky130_ef_sc_hd__decap_12
X_6011_ net147 VGND VGND VPWR VPWR _0419_ sky130_fd_sc_hd__inv_2
X_3223_ MEMOFF\[26\] _1129_ _1130_ JMPOFF\[26\] _1165_ VGND VGND VPWR VPWR _1166_
+ sky130_fd_sc_hd__a221o_1
XFILLER_86_329 VPWR VGND VPWR VGND sky130_ef_sc_hd__decap_12
XFILLER_86_307 VGND VGND VPWR VPWR sky130_fd_sc_hd__fill_1
XFILLER_100_117 VGND VGND VPWR VPWR sky130_fd_sc_hd__fill_1
XFILLER_39_223 VGND VGND VPWR VPWR sky130_fd_sc_hd__fill_1
XFILLER_39_234 VPWR VGND VPWR VGND sky130_ef_sc_hd__decap_12
XFILLER_82_502 VGND VGND VPWR VPWR sky130_fd_sc_hd__decap_6
X_3154_ _1080_ _1088_ VGND VGND VPWR VPWR _1098_ sky130_fd_sc_hd__and2_4
X_3085_ _1028_ VGND VGND VPWR VPWR _1029_ sky130_fd_sc_hd__inv_2
XFILLER_39_278 VGND VGND VPWR VPWR sky130_fd_sc_hd__fill_2
XTAP_TAPCELL_ROW_85_1330 VGND VPWR sky130_fd_sc_hd__tapvpwrvgnd_1
XFILLER_54_248 VGND VGND VPWR VPWR sky130_fd_sc_hd__decap_4
XTAP_TAPCELL_ROW_53_928 VGND VPWR sky130_fd_sc_hd__tapvpwrvgnd_1
XFILLER_23_602 VGND VGND VPWR VPWR sky130_fd_sc_hd__decap_3
XFILLER_62_270 VGND VGND VPWR VPWR sky130_fd_sc_hd__decap_8
XFILLER_50_421 VPWR VGND VPWR VGND sky130_ef_sc_hd__decap_12
XPHY_EDGE_ROW_99_Left_222 VGND VGND VPWR VPWR sky130_fd_sc_hd__decap_3
XFILLER_10_307 VGND VGND VPWR VPWR sky130_fd_sc_hd__fill_1
X_3987_ _1902_ VGND VGND VPWR VPWR _1903_ sky130_fd_sc_hd__inv_2
X_5726_ net146 VGND VGND VPWR VPWR _0134_ sky130_fd_sc_hd__inv_2
XFILLER_22_178 VPWR VGND VPWR VGND sky130_ef_sc_hd__decap_12
XTAP_TAPCELL_ROW_33_674 VGND VPWR sky130_fd_sc_hd__tapvpwrvgnd_1
X_5657_ net148 VGND VGND VPWR VPWR _0065_ sky130_fd_sc_hd__inv_2
XTAP_TAPCELL_ROW_96_1470 VGND VPWR sky130_fd_sc_hd__tapvpwrvgnd_1
X_4608_ _2245_ _2368_ _2243_ VGND VGND VPWR VPWR _2485_ sky130_fd_sc_hd__o21a_1
X_5588_ reg_file_inst.registry\[15\]\[4\] _2455_ _3003_ VGND VGND VPWR VPWR _0479_
+ sky130_fd_sc_hd__mux2_1
XFILLER_2_517 VPWR VGND VPWR VGND sky130_ef_sc_hd__decap_12
X_4539_ _2333_ _2336_ net133 VGND VGND VPWR VPWR _2420_ sky130_fd_sc_hd__mux2_1
XFILLER_77_27 VGND VGND VPWR VPWR sky130_fd_sc_hd__decap_4
XFILLER_104_489 VGND VGND VPWR VPWR sky130_fd_sc_hd__decap_4
XFILLER_89_189 VGND VGND VPWR VPWR sky130_fd_sc_hd__fill_1
XFILLER_77_307 VPWR VGND VPWR VGND sky130_ef_sc_hd__decap_12
XTAP_TAPCELL_ROW_5_322 VGND VPWR sky130_fd_sc_hd__tapvpwrvgnd_1
X_6209_ clknet_leaf_1_clk _0617_ _0142_ VGND VGND VPWR VPWR reg_file_inst.registry\[10\]\[2\]
+ sky130_fd_sc_hd__dfrtp_1
XFILLER_93_15 VGND VGND VPWR VPWR sky130_fd_sc_hd__fill_2
XFILLER_93_26 VPWR VGND VPWR VGND sky130_ef_sc_hd__decap_12
XFILLER_73_524 VGND VGND VPWR VPWR sky130_fd_sc_hd__decap_6
XFILLER_58_598 VGND VGND VPWR VPWR sky130_fd_sc_hd__decap_6
Xclkbuf_3_6__f_clk clknet_0_clk VGND VGND VPWR VPWR clknet_3_6__leaf_clk sky130_fd_sc_hd__clkbuf_16
XFILLER_14_613 VPWR VGND VPWR VGND sky130_ef_sc_hd__decap_12
XFILLER_26_75 VGND VGND VPWR VPWR sky130_fd_sc_hd__decap_8
XFILLER_53_281 VGND VGND VPWR VPWR sky130_fd_sc_hd__decap_6
XFILLER_14_657 VGND VGND VPWR VPWR sky130_fd_sc_hd__decap_4
XFILLER_26_97 VPWR VGND VPWR VGND sky130_ef_sc_hd__decap_12
XFILLER_41_410 VPWR VGND VPWR VGND sky130_ef_sc_hd__decap_12
XFILLER_42_85 VPWR VGND VPWR VGND sky130_ef_sc_hd__decap_12
XFILLER_5_311 VGND VGND VPWR VPWR sky130_fd_sc_hd__fill_1
XFILLER_114_209 VPWR VGND VPWR VGND sky130_ef_sc_hd__decap_12
XFILLER_5_333 VGND VGND VPWR VPWR sky130_fd_sc_hd__decap_3
XFILLER_107_261 VPWR VGND VPWR VGND sky130_ef_sc_hd__decap_12
XFILLER_5_377 VGND VGND VPWR VPWR sky130_fd_sc_hd__fill_1
XFILLER_122_253 VPWR VGND VPWR VGND sky130_ef_sc_hd__decap_12
XFILLER_68_307 VGND VGND VPWR VPWR sky130_fd_sc_hd__fill_1
XFILLER_1_561 VPWR VGND VPWR VGND sky130_ef_sc_hd__decap_12
XFILLER_3_57 VPWR VGND VPWR VGND sky130_ef_sc_hd__decap_12
XFILLER_49_554 VGND VGND VPWR VPWR sky130_fd_sc_hd__decap_6
XTAP_TAPCELL_ROW_108_1617 VGND VPWR sky130_fd_sc_hd__tapvpwrvgnd_1
XFILLER_91_354 VPWR VGND VPWR VGND sky130_ef_sc_hd__decap_12
XFILLER_83_70 VGND VGND VPWR VPWR sky130_fd_sc_hd__fill_2
XFILLER_51_218 VGND VGND VPWR VPWR sky130_fd_sc_hd__decap_3
X_4890_ _2684_ _2746_ _2741_ _2722_ _2717_ VGND VGND VPWR VPWR net63 sky130_fd_sc_hd__a2111o_1
XFILLER_32_421 VGND VGND VPWR VPWR sky130_fd_sc_hd__fill_1
X_3910_ net135 _1826_ VGND VGND VPWR VPWR _1827_ sky130_fd_sc_hd__or2_1
X_3841_ reg_file_inst.registry\[11\]\[3\] _1096_ _1097_ reg_file_inst.registry\[5\]\[3\]
+ VGND VGND VPWR VPWR _1761_ sky130_fd_sc_hd__a22o_1
XFILLER_32_454 VGND VGND VPWR VPWR sky130_fd_sc_hd__decap_8
XTAP_TAPCELL_ROW_80_1260 VGND VPWR sky130_fd_sc_hd__tapvpwrvgnd_1
XFILLER_20_627 VGND VGND VPWR VPWR sky130_fd_sc_hd__decap_4
X_3772_ _1679_ _1692_ VGND VGND VPWR VPWR _1694_ sky130_fd_sc_hd__or2_1
X_5511_ reg_file_inst.registry\[6\]\[23\] _2806_ _3001_ VGND VGND VPWR VPWR _0554_
+ sky130_fd_sc_hd__mux2_1
XTAP_TAPCELL_ROW_30_633 VGND VPWR sky130_fd_sc_hd__tapvpwrvgnd_1
XTAP_TAPCELL_ROW_30_644 VGND VPWR sky130_fd_sc_hd__tapvpwrvgnd_1
XTAP_TAPCELL_ROW_119_1757 VGND VPWR sky130_fd_sc_hd__tapvpwrvgnd_1
XTAP_TAPCELL_ROW_119_1746 VGND VPWR sky130_fd_sc_hd__tapvpwrvgnd_1
X_6491_ clknet_leaf_32_clk _0899_ _0424_ VGND VGND VPWR VPWR reg_file_inst.registry\[7\]\[24\]
+ sky130_fd_sc_hd__dfrtp_1
X_5442_ _2419_ reg_file_inst.registry\[10\]\[5\] _2998_ VGND VGND VPWR VPWR _0620_
+ sky130_fd_sc_hd__mux2_1
X_5373_ MEMOFF\[16\] _2883_ _2996_ VGND VGND VPWR VPWR _0687_ sky130_fd_sc_hd__mux2_1
XTAP_TAPCELL_ROW_10_390 VGND VPWR sky130_fd_sc_hd__tapvpwrvgnd_1
X_4324_ _2209_ _2211_ VGND VGND VPWR VPWR _2212_ sky130_fd_sc_hd__nor2_1
XFILLER_86_137 VGND VGND VPWR VPWR sky130_fd_sc_hd__decap_3
X_4255_ _1708_ _2131_ _2127_ VGND VGND VPWR VPWR _2143_ sky130_fd_sc_hd__o21a_1
X_3206_ reg_file_inst.registry\[4\]\[27\] _1134_ _1148_ _1149_ VGND VGND VPWR VPWR
+ _1150_ sky130_fd_sc_hd__a211o_1
X_4186_ net130 _2088_ _2089_ VGND VGND VPWR VPWR _0937_ sky130_fd_sc_hd__o21ai_1
XFILLER_95_671 VGND VGND VPWR VPWR sky130_fd_sc_hd__fill_1
XFILLER_94_170 VGND VGND VPWR VPWR sky130_fd_sc_hd__fill_1
X_3137_ _1077_ _1080_ VGND VGND VPWR VPWR _1081_ sky130_fd_sc_hd__and2_4
XFILLER_27_204 VGND VGND VPWR VPWR sky130_fd_sc_hd__decap_6
XFILLER_27_215 VGND VGND VPWR VPWR sky130_fd_sc_hd__decap_8
XFILLER_82_354 VGND VGND VPWR VPWR sky130_fd_sc_hd__decap_8
XFILLER_27_237 VGND VGND VPWR VPWR sky130_fd_sc_hd__decap_6
XTAP_TAPCELL_ROW_38_733 VGND VPWR sky130_fd_sc_hd__tapvpwrvgnd_1
XTAP_TAPCELL_ROW_38_744 VGND VPWR sky130_fd_sc_hd__tapvpwrvgnd_1
XPHY_EDGE_ROW_118_Right_118 VGND VGND VPWR VPWR sky130_fd_sc_hd__decap_3
XFILLER_103_69 VPWR VGND VPWR VGND sky130_ef_sc_hd__decap_12
XFILLER_63_18 VPWR VGND VPWR VGND sky130_ef_sc_hd__decap_12
X_3068_ _1007_ _1009_ _1011_ VGND VGND VPWR VPWR _1012_ sky130_fd_sc_hd__and3_1
XFILLER_35_281 VPWR VGND VPWR VGND sky130_ef_sc_hd__decap_12
XTAP_TAPCELL_ROW_18_490 VGND VPWR sky130_fd_sc_hd__tapvpwrvgnd_1
XFILLER_50_251 VGND VGND VPWR VPWR sky130_fd_sc_hd__fill_1
XFILLER_11_649 VGND VGND VPWR VPWR sky130_fd_sc_hd__fill_2
XFILLER_10_115 VGND VGND VPWR VPWR sky130_fd_sc_hd__fill_1
XFILLER_10_148 VPWR VGND VPWR VGND sky130_ef_sc_hd__decap_12
XFILLER_10_137 VGND VGND VPWR VPWR sky130_fd_sc_hd__decap_3
XFILLER_7_609 VGND VGND VPWR VPWR sky130_fd_sc_hd__decap_6
X_5709_ net149 VGND VGND VPWR VPWR _0117_ sky130_fd_sc_hd__inv_2
XFILLER_109_559 VGND VGND VPWR VPWR sky130_fd_sc_hd__fill_1
XFILLER_12_66 VGND VGND VPWR VPWR sky130_fd_sc_hd__decap_8
XFILLER_88_26 VGND VGND VPWR VPWR sky130_fd_sc_hd__fill_2
XFILLER_120_713 VPWR VGND VPWR VGND sky130_ef_sc_hd__decap_12
XFILLER_104_253 VPWR VGND VPWR VGND sky130_ef_sc_hd__decap_12
XFILLER_77_104 VGND VGND VPWR VPWR sky130_fd_sc_hd__decap_8
XFILLER_86_693 VGND VGND VPWR VPWR sky130_fd_sc_hd__decap_6
XFILLER_37_41 VGND VGND VPWR VPWR sky130_fd_sc_hd__fill_1
XFILLER_85_181 VPWR VGND VPWR VGND sky130_ef_sc_hd__decap_12
XFILLER_73_321 VGND VGND VPWR VPWR sky130_fd_sc_hd__decap_6
XFILLER_73_365 VPWR VGND VPWR VGND sky130_ef_sc_hd__decap_12
XTAP_TAPCELL_ROW_103_1547 VGND VPWR sky130_fd_sc_hd__tapvpwrvgnd_1
XFILLER_41_262 VPWR VGND VPWR VGND sky130_ef_sc_hd__decap_12
XFILLER_10_693 VGND VGND VPWR VPWR sky130_fd_sc_hd__decap_6
XFILLER_115_529 VPWR VGND VPWR VGND sky130_ef_sc_hd__decap_12
XFILLER_108_581 VGND VGND VPWR VPWR sky130_fd_sc_hd__decap_6
XTAP_TAPCELL_ROW_114_1687 VGND VPWR sky130_fd_sc_hd__tapvpwrvgnd_1
XFILLER_96_424 VGND VGND VPWR VPWR sky130_fd_sc_hd__decap_6
XFILLER_78_81 VGND VGND VPWR VPWR sky130_fd_sc_hd__decap_3
XFILLER_69_638 VGND VGND VPWR VPWR sky130_fd_sc_hd__decap_8
XFILLER_110_245 VGND VGND VPWR VPWR sky130_fd_sc_hd__decap_6
X_4040_ _0955_ _1010_ VGND VGND VPWR VPWR _1956_ sky130_fd_sc_hd__and2_1
XFILLER_110_289 VPWR VGND VPWR VGND sky130_ef_sc_hd__decap_12
XFILLER_37_502 VGND VGND VPWR VPWR sky130_fd_sc_hd__fill_2
XFILLER_76_181 VPWR VGND VPWR VGND sky130_ef_sc_hd__decap_12
XTAP_TAPCELL_ROW_69_1122 VGND VPWR sky130_fd_sc_hd__tapvpwrvgnd_1
X_5991_ net147 VGND VGND VPWR VPWR _0399_ sky130_fd_sc_hd__inv_2
XFILLER_64_365 VPWR VGND VPWR VGND sky130_ef_sc_hd__decap_12
XTAP_TAPCELL_ROW_35_703 VGND VPWR sky130_fd_sc_hd__tapvpwrvgnd_1
X_4942_ _2580_ _2582_ _2791_ VGND VGND VPWR VPWR _2793_ sky130_fd_sc_hd__or3_1
X_4873_ _2353_ _2363_ _1817_ VGND VGND VPWR VPWR _2730_ sky130_fd_sc_hd__o21ai_1
X_3824_ reg_file_inst.registry\[9\]\[5\] net144 _1127_ VGND VGND VPWR VPWR _1745_
+ sky130_fd_sc_hd__and3_1
XFILLER_32_295 VGND VGND VPWR VPWR sky130_fd_sc_hd__decap_4
XFILLER_118_301 VGND VGND VPWR VPWR sky130_fd_sc_hd__decap_6
X_3755_ _1674_ _1675_ _1676_ _1677_ VGND VGND VPWR VPWR _1678_ sky130_fd_sc_hd__or4_1
XFILLER_118_345 VPWR VGND VPWR VGND sky130_ef_sc_hd__decap_12
X_6474_ clknet_leaf_47_clk _0882_ _0407_ VGND VGND VPWR VPWR reg_file_inst.registry\[7\]\[7\]
+ sky130_fd_sc_hd__dfrtp_1
X_3686_ reg_file_inst.registry\[2\]\[8\] _1116_ _1123_ VGND VGND VPWR VPWR _1611_
+ sky130_fd_sc_hd__and3_1
XFILLER_118_389 VPWR VGND VPWR VGND sky130_ef_sc_hd__decap_12
X_5425_ _2817_ reg_file_inst.registry\[10\]\[22\] _2998_ VGND VGND VPWR VPWR _0637_
+ sky130_fd_sc_hd__mux2_1
XPHY_EDGE_ROW_12_Right_12 VGND VGND VPWR VPWR sky130_fd_sc_hd__decap_3
XFILLER_102_713 VPWR VGND VPWR VGND sky130_ef_sc_hd__decap_12
XFILLER_58_29 VGND VGND VPWR VPWR sky130_fd_sc_hd__fill_2
X_5356_ _2455_ reg_file_inst.registry\[3\]\[4\] _2995_ VGND VGND VPWR VPWR _0703_
+ sky130_fd_sc_hd__mux2_1
XFILLER_101_201 VPWR VGND VPWR VGND sky130_ef_sc_hd__decap_12
XFILLER_99_284 VGND VGND VPWR VPWR sky130_fd_sc_hd__decap_4
X_5287_ _2897_ reg_file_inst.registry\[2\]\[15\] _2993_ VGND VGND VPWR VPWR _0770_
+ sky130_fd_sc_hd__mux2_1
X_4307_ _1840_ _2194_ VGND VGND VPWR VPWR _2195_ sky130_fd_sc_hd__nor2_1
X_4238_ _1113_ _2124_ _2125_ VGND VGND VPWR VPWR _2126_ sky130_fd_sc_hd__and3_4
XFILLER_101_278 VGND VGND VPWR VPWR sky130_fd_sc_hd__fill_2
XFILLER_67_181 VPWR VGND VPWR VGND sky130_ef_sc_hd__decap_12
X_4169_ _2005_ _2014_ _2017_ VGND VGND VPWR VPWR _2077_ sky130_fd_sc_hd__and3_1
XFILLER_28_546 VGND VGND VPWR VPWR sky130_fd_sc_hd__fill_2
XFILLER_83_685 VPWR VGND VPWR VGND sky130_ef_sc_hd__decap_12
XPHY_EDGE_ROW_21_Right_21 VGND VGND VPWR VPWR sky130_fd_sc_hd__decap_3
XFILLER_43_505 VPWR VGND VPWR VGND sky130_ef_sc_hd__decap_12
XFILLER_43_549 VGND VGND VPWR VPWR sky130_fd_sc_hd__decap_8
XFILLER_90_27 VGND VGND VPWR VPWR sky130_fd_sc_hd__fill_1
XFILLER_90_49 VGND VGND VPWR VPWR sky130_fd_sc_hd__decap_8
XFILLER_51_582 VGND VGND VPWR VPWR sky130_fd_sc_hd__decap_6
XFILLER_11_446 VGND VGND VPWR VPWR sky130_fd_sc_hd__fill_2
XFILLER_23_295 VGND VGND VPWR VPWR sky130_fd_sc_hd__fill_2
XFILLER_11_479 VGND VGND VPWR VPWR sky130_fd_sc_hd__fill_1
XPHY_EDGE_ROW_30_Right_30 VGND VGND VPWR VPWR sky130_fd_sc_hd__decap_3
XPHY_EDGE_ROW_36_Left_159 VGND VGND VPWR VPWR sky130_fd_sc_hd__decap_3
XFILLER_105_573 VPWR VGND VPWR VGND sky130_ef_sc_hd__decap_12
XFILLER_2_177 VPWR VGND VPWR VGND sky130_ef_sc_hd__decap_12
XFILLER_120_587 VGND VGND VPWR VPWR sky130_fd_sc_hd__fill_1
XFILLER_65_107 VGND VGND VPWR VPWR sky130_fd_sc_hd__decap_4
XFILLER_74_641 VGND VGND VPWR VPWR sky130_fd_sc_hd__decap_3
XFILLER_19_557 VGND VGND VPWR VPWR sky130_fd_sc_hd__decap_3
XPHY_EDGE_ROW_45_Left_168 VGND VGND VPWR VPWR sky130_fd_sc_hd__decap_3
XFILLER_61_335 VGND VGND VPWR VPWR sky130_fd_sc_hd__fill_1
XFILLER_34_527 VGND VGND VPWR VPWR sky130_fd_sc_hd__decap_4
XFILLER_61_346 VPWR VGND VPWR VGND sky130_ef_sc_hd__decap_12
XTAP_TAPCELL_ROW_64_1063 VGND VPWR sky130_fd_sc_hd__tapvpwrvgnd_1
XFILLER_9_78 VPWR VGND VPWR VGND sky130_ef_sc_hd__decap_12
XPHY_EDGE_ROW_54_Left_177 VGND VGND VPWR VPWR sky130_fd_sc_hd__decap_3
XTAP_TAPCELL_ROW_40_761 VGND VPWR sky130_fd_sc_hd__tapvpwrvgnd_1
XTAP_TAPCELL_ROW_116_1716 VGND VPWR sky130_fd_sc_hd__tapvpwrvgnd_1
X_3540_ _1457_ _1469_ VGND VGND VPWR VPWR _1470_ sky130_fd_sc_hd__xnor2_1
XFILLER_115_337 VPWR VGND VPWR VGND sky130_ef_sc_hd__decap_12
X_3471_ reg_file_inst.registry\[0\]\[17\] net138 _1395_ _1402_ VGND VGND VPWR VPWR
+ _1404_ sky130_fd_sc_hd__o22ai_4
X_5210_ reg_file_inst.registry\[11\]\[20\] _2455_ _2989_ VGND VGND VPWR VPWR _0843_
+ sky130_fd_sc_hd__mux2_1
XFILLER_69_402 VGND VGND VPWR VPWR sky130_fd_sc_hd__fill_2
X_6190_ clknet_leaf_62_clk _0598_ _0123_ VGND VGND VPWR VPWR reg_file_inst.registry\[5\]\[11\]
+ sky130_fd_sc_hd__dfrtp_1
XFILLER_43_3 VPWR VGND VPWR VGND sky130_ef_sc_hd__decap_12
XFILLER_96_221 VGND VGND VPWR VPWR sky130_fd_sc_hd__decap_4
X_5141_ _1764_ _2504_ VGND VGND VPWR VPWR _2964_ sky130_fd_sc_hd__nor2_1
X_5072_ _1504_ _2124_ _2289_ VGND VGND VPWR VPWR _2905_ sky130_fd_sc_hd__o21ai_1
XPHY_EDGE_ROW_63_Left_186 VGND VGND VPWR VPWR sky130_fd_sc_hd__decap_3
XFILLER_56_129 VGND VGND VPWR VPWR sky130_fd_sc_hd__decap_3
X_4023_ _1000_ _1001_ _1021_ VGND VGND VPWR VPWR _1939_ sky130_fd_sc_hd__or3_1
XFILLER_49_181 VPWR VGND VPWR VGND sky130_ef_sc_hd__decap_12
XFILLER_80_600 VGND VGND VPWR VPWR sky130_fd_sc_hd__decap_6
XFILLER_25_505 VPWR VGND VPWR VGND sky130_ef_sc_hd__decap_12
XTAP_TAPCELL_ROW_48_861 VGND VPWR sky130_fd_sc_hd__tapvpwrvgnd_1
XFILLER_64_173 VPWR VGND VPWR VGND sky130_ef_sc_hd__decap_12
XFILLER_25_538 VGND VGND VPWR VPWR sky130_fd_sc_hd__fill_1
X_5974_ net149 VGND VGND VPWR VPWR _0382_ sky130_fd_sc_hd__inv_2
X_4925_ _2776_ _2777_ net136 VGND VGND VPWR VPWR _2778_ sky130_fd_sc_hd__mux2_1
XPHY_EDGE_ROW_72_Left_195 VGND VGND VPWR VPWR sky130_fd_sc_hd__decap_3
X_4856_ _2176_ _2682_ _2683_ _2714_ VGND VGND VPWR VPWR net64 sky130_fd_sc_hd__a31o_1
XFILLER_20_210 VGND VGND VPWR VPWR sky130_fd_sc_hd__fill_1
XFILLER_33_593 VPWR VGND VPWR VGND sky130_ef_sc_hd__decap_12
X_3807_ reg_file_inst.registry\[2\]\[5\] _1083_ _1093_ reg_file_inst.registry\[15\]\[5\]
+ VGND VGND VPWR VPWR _1728_ sky130_fd_sc_hd__a22o_1
XFILLER_20_265 VPWR VGND VPWR VGND sky130_ef_sc_hd__decap_12
XFILLER_119_665 VGND VGND VPWR VPWR sky130_fd_sc_hd__decap_6
X_4787_ _1469_ _2645_ VGND VGND VPWR VPWR _2646_ sky130_fd_sc_hd__nand2_1
X_6526_ clknet_leaf_49_clk _0934_ _0459_ VGND VGND VPWR VPWR net105 sky130_fd_sc_hd__dfrtp_1
XFILLER_118_153 VPWR VGND VPWR VGND sky130_ef_sc_hd__decap_12
X_3738_ reg_file_inst.registry\[7\]\[7\] _1133_ _1139_ reg_file_inst.registry\[5\]\[7\]
+ _1659_ VGND VGND VPWR VPWR _1662_ sky130_fd_sc_hd__a221o_1
XFILLER_118_197 VPWR VGND VPWR VGND sky130_ef_sc_hd__decap_12
XFILLER_109_57 VPWR VGND VPWR VGND sky130_ef_sc_hd__decap_12
XFILLER_69_39 VGND VGND VPWR VPWR sky130_fd_sc_hd__decap_8
X_6457_ clknet_leaf_10_clk _0865_ _0390_ VGND VGND VPWR VPWR reg_file_inst.registry\[0\]\[18\]
+ sky130_fd_sc_hd__dfrtp_1
X_3669_ MEMOFF\[9\] net100 _1113_ VGND VGND VPWR VPWR _1594_ sky130_fd_sc_hd__mux2_4
X_5408_ reg_file_inst.registry\[4\]\[10\] _2960_ _2997_ VGND VGND VPWR VPWR _0653_
+ sky130_fd_sc_hd__mux2_1
X_6388_ clknet_leaf_1_clk _0796_ _0321_ VGND VGND VPWR VPWR reg_file_inst.registry\[14\]\[13\]
+ sky130_fd_sc_hd__dfrtp_1
XFILLER_121_329 VGND VGND VPWR VPWR sky130_fd_sc_hd__decap_6
X_5339_ _2829_ reg_file_inst.registry\[3\]\[21\] _2995_ VGND VGND VPWR VPWR _0720_
+ sky130_fd_sc_hd__mux2_1
XFILLER_0_648 VGND VGND VPWR VPWR sky130_fd_sc_hd__decap_8
XFILLER_102_587 VGND VGND VPWR VPWR sky130_fd_sc_hd__fill_1
XFILLER_85_27 VPWR VGND VPWR VGND sky130_ef_sc_hd__decap_12
XFILLER_75_405 VGND VGND VPWR VPWR sky130_fd_sc_hd__decap_4
XFILLER_75_449 VPWR VGND VPWR VGND sky130_ef_sc_hd__decap_12
XFILLER_28_321 VGND VGND VPWR VPWR sky130_fd_sc_hd__decap_6
XFILLER_28_343 VGND VGND VPWR VPWR sky130_fd_sc_hd__fill_1
XFILLER_43_335 VGND VGND VPWR VPWR sky130_fd_sc_hd__fill_1
XTAP_TAPCELL_ROW_100_1517 VGND VPWR sky130_fd_sc_hd__tapvpwrvgnd_1
XFILLER_12_722 VGND VGND VPWR VPWR sky130_fd_sc_hd__fill_1
XTAP_TAPCELL_ROW_26_588 VGND VPWR sky130_fd_sc_hd__tapvpwrvgnd_1
XFILLER_11_221 VGND VGND VPWR VPWR sky130_fd_sc_hd__decap_3
XFILLER_7_203 VGND VGND VPWR VPWR sky130_fd_sc_hd__fill_2
Xwire145 _1116_ VGND VGND VPWR VPWR net145 sky130_fd_sc_hd__clkbuf_8
XFILLER_7_225 VGND VGND VPWR VPWR sky130_fd_sc_hd__fill_1
XFILLER_50_41 VGND VGND VPWR VPWR sky130_fd_sc_hd__decap_4
XFILLER_50_85 VPWR VGND VPWR VGND sky130_ef_sc_hd__decap_12
XFILLER_112_307 VGND VGND VPWR VPWR sky130_fd_sc_hd__fill_1
XFILLER_98_508 VGND VGND VPWR VPWR sky130_fd_sc_hd__decap_6
XFILLER_3_453 VPWR VGND VPWR VGND sky130_ef_sc_hd__decap_12
XTAP_TAPCELL_ROW_111_1646 VGND VPWR sky130_fd_sc_hd__tapvpwrvgnd_1
XTAP_TAPCELL_ROW_111_1657 VGND VPWR sky130_fd_sc_hd__tapvpwrvgnd_1
XFILLER_78_243 VGND VGND VPWR VPWR sky130_fd_sc_hd__fill_2
XFILLER_94_725 VGND VGND VPWR VPWR sky130_fd_sc_hd__fill_1
XFILLER_78_287 VPWR VGND VPWR VGND sky130_ef_sc_hd__decap_12
XFILLER_78_265 VGND VGND VPWR VPWR sky130_fd_sc_hd__fill_1
XFILLER_38_118 VGND VGND VPWR VPWR sky130_fd_sc_hd__fill_1
XFILLER_47_641 VGND VGND VPWR VPWR sky130_fd_sc_hd__fill_1
Xclkbuf_leaf_58_clk clknet_3_4__leaf_clk VGND VGND VPWR VPWR clknet_leaf_58_clk sky130_fd_sc_hd__clkbuf_8
XFILLER_93_279 VGND VGND VPWR VPWR sky130_fd_sc_hd__fill_1
XFILLER_75_82 VGND VGND VPWR VPWR sky130_fd_sc_hd__decap_6
XFILLER_74_460 VGND VGND VPWR VPWR sky130_fd_sc_hd__fill_1
XTAP_TAPCELL_ROW_45_831 VGND VPWR sky130_fd_sc_hd__tapvpwrvgnd_1
XFILLER_46_195 VGND VGND VPWR VPWR sky130_fd_sc_hd__fill_1
XTAP_TAPCELL_ROW_122_1797 VGND VPWR sky130_fd_sc_hd__tapvpwrvgnd_1
XTAP_TAPCELL_ROW_122_1786 VGND VPWR sky130_fd_sc_hd__tapvpwrvgnd_1
X_5690_ net147 VGND VGND VPWR VPWR _0098_ sky130_fd_sc_hd__inv_2
X_4710_ _1185_ _2565_ VGND VGND VPWR VPWR _2569_ sky130_fd_sc_hd__xor2_1
XFILLER_42_390 VPWR VGND VPWR VGND sky130_ef_sc_hd__decap_12
X_4641_ _1764_ _2515_ VGND VGND VPWR VPWR _2516_ sky130_fd_sc_hd__nor2_1
XFILLER_116_613 VPWR VGND VPWR VGND sky130_ef_sc_hd__decap_12
XTAP_TAPCELL_ROW_77_1221 VGND VPWR sky130_fd_sc_hd__tapvpwrvgnd_1
X_4572_ _2249_ _2452_ VGND VGND VPWR VPWR _2453_ sky130_fd_sc_hd__or2_1
XFILLER_116_657 VPWR VGND VPWR VGND sky130_ef_sc_hd__decap_12
XTAP_TAPCELL_ROW_77_1232 VGND VPWR sky130_fd_sc_hd__tapvpwrvgnd_1
X_6311_ clknet_leaf_43_clk _0719_ _0244_ VGND VGND VPWR VPWR reg_file_inst.registry\[3\]\[20\]
+ sky130_fd_sc_hd__dfrtp_1
X_3523_ reg_file_inst.registry\[3\]\[13\] _1091_ _1094_ reg_file_inst.registry\[6\]\[13\]
+ VGND VGND VPWR VPWR _1454_ sky130_fd_sc_hd__a22o_1
XFILLER_115_167 VGND VGND VPWR VPWR sky130_fd_sc_hd__fill_1
XFILLER_103_307 VGND VGND VPWR VPWR sky130_fd_sc_hd__fill_1
X_3454_ reg_file_inst.registry\[7\]\[16\] _1133_ _1139_ reg_file_inst.registry\[5\]\[16\]
+ VGND VGND VPWR VPWR _1388_ sky130_fd_sc_hd__a22o_1
X_6242_ clknet_leaf_40_clk _0650_ _0175_ VGND VGND VPWR VPWR reg_file_inst.registry\[4\]\[7\]
+ sky130_fd_sc_hd__dfrtp_1
XFILLER_6_291 VGND VGND VPWR VPWR sky130_fd_sc_hd__decap_8
X_6173_ clknet_leaf_36_clk _0581_ _0106_ VGND VGND VPWR VPWR JMPOFF\[22\] sky130_fd_sc_hd__dfrtp_2
X_3385_ _1306_ _1320_ VGND VGND VPWR VPWR _1321_ sky130_fd_sc_hd__nand2_1
XFILLER_111_373 VPWR VGND VPWR VGND sky130_ef_sc_hd__decap_12
XFILLER_57_416 VPWR VGND VPWR VGND sky130_ef_sc_hd__decap_12
X_5124_ _2623_ _2935_ VGND VGND VPWR VPWR _2949_ sky130_fd_sc_hd__xor2_1
XFILLER_84_224 VGND VGND VPWR VPWR sky130_fd_sc_hd__decap_4
XFILLER_57_449 VGND VGND VPWR VPWR sky130_fd_sc_hd__decap_8
X_5055_ _1491_ _2282_ _2285_ _1493_ _2889_ VGND VGND VPWR VPWR _2890_ sky130_fd_sc_hd__o221ai_4
Xclkbuf_leaf_49_clk clknet_3_5__leaf_clk VGND VGND VPWR VPWR clknet_leaf_49_clk sky130_fd_sc_hd__clkbuf_8
XFILLER_38_641 VGND VGND VPWR VPWR sky130_fd_sc_hd__decap_3
XFILLER_38_674 VGND VGND VPWR VPWR sky130_fd_sc_hd__decap_8
X_4006_ _1900_ _1906_ VGND VGND VPWR VPWR _1922_ sky130_fd_sc_hd__nor2_1
XTAP_TAPCELL_ROW_88_1361 VGND VPWR sky130_fd_sc_hd__tapvpwrvgnd_1
XFILLER_80_452 VGND VGND VPWR VPWR sky130_fd_sc_hd__fill_2
XFILLER_25_335 VGND VGND VPWR VPWR sky130_fd_sc_hd__fill_1
XFILLER_111_69 VPWR VGND VPWR VGND sky130_ef_sc_hd__decap_12
XPHY_EDGE_ROW_80_Left_203 VGND VGND VPWR VPWR sky130_fd_sc_hd__decap_3
X_5957_ net148 VGND VGND VPWR VPWR _0365_ sky130_fd_sc_hd__inv_2
XFILLER_13_508 VGND VGND VPWR VPWR sky130_fd_sc_hd__decap_4
XTAP_TAPCELL_ROW_23_547 VGND VPWR sky130_fd_sc_hd__tapvpwrvgnd_1
X_4908_ _2271_ _2686_ net133 VGND VGND VPWR VPWR _2763_ sky130_fd_sc_hd__mux2_1
X_5888_ net44 VGND VGND VPWR VPWR _0296_ sky130_fd_sc_hd__inv_2
X_4839_ _1708_ _2301_ VGND VGND VPWR VPWR _2698_ sky130_fd_sc_hd__nor2_1
XFILLER_119_473 VPWR VGND VPWR VGND sky130_ef_sc_hd__decap_12
XFILLER_112_6 VPWR VGND VPWR VGND sky130_ef_sc_hd__decap_12
X_6509_ clknet_leaf_2_clk _0917_ _0442_ VGND VGND VPWR VPWR reg_file_inst.registry\[11\]\[2\]
+ sky130_fd_sc_hd__dfrtp_1
XFILLER_20_66 VPWR VGND VPWR VGND sky130_ef_sc_hd__decap_12
XFILLER_106_189 VGND VGND VPWR VPWR sky130_fd_sc_hd__decap_6
XFILLER_0_401 VGND VGND VPWR VPWR sky130_fd_sc_hd__decap_8
XFILLER_121_137 VPWR VGND VPWR VGND sky130_ef_sc_hd__decap_12
XFILLER_96_37 VGND VGND VPWR VPWR sky130_fd_sc_hd__fill_2
XFILLER_76_725 VGND VGND VPWR VPWR sky130_fd_sc_hd__fill_1
XFILLER_29_641 VPWR VGND VPWR VGND sky130_ef_sc_hd__decap_12
XFILLER_28_184 VPWR VGND VPWR VGND sky130_ef_sc_hd__decap_12
XPHY_EDGE_ROW_119_Left_242 VGND VGND VPWR VPWR sky130_fd_sc_hd__decap_3
XFILLER_83_290 VPWR VGND VPWR VGND sky130_ef_sc_hd__decap_12
XFILLER_16_346 VGND VGND VPWR VPWR sky130_fd_sc_hd__decap_6
XFILLER_71_496 VGND VGND VPWR VPWR sky130_fd_sc_hd__decap_8
XTAP_TAPCELL_ROW_61_1022 VGND VPWR sky130_fd_sc_hd__tapvpwrvgnd_1
XFILLER_12_541 VGND VGND VPWR VPWR sky130_fd_sc_hd__fill_2
XFILLER_12_552 VPWR VGND VPWR VGND sky130_ef_sc_hd__decap_12
XFILLER_8_545 VPWR VGND VPWR VGND sky130_ef_sc_hd__decap_12
XFILLER_8_589 VPWR VGND VPWR VGND sky130_ef_sc_hd__decap_12
XANTENNA_6 _1123_ VGND VGND VPWR VPWR sky130_fd_sc_hd__diode_2
XFILLER_121_671 VGND VGND VPWR VPWR sky130_fd_sc_hd__fill_1
X_3170_ net29 net35 VGND VGND VPWR VPWR _1114_ sky130_fd_sc_hd__nor2_8
XTAP_TAPCELL_ROW_72_1162 VGND VPWR sky130_fd_sc_hd__tapvpwrvgnd_1
XFILLER_94_533 VPWR VGND VPWR VGND sky130_ef_sc_hd__decap_12
XFILLER_39_449 VGND VGND VPWR VPWR sky130_fd_sc_hd__decap_8
XFILLER_54_419 VGND VGND VPWR VPWR sky130_fd_sc_hd__fill_1
XFILLER_35_633 VGND VGND VPWR VPWR sky130_fd_sc_hd__decap_8
X_5811_ net149 VGND VGND VPWR VPWR _0219_ sky130_fd_sc_hd__inv_2
XFILLER_35_699 VGND VGND VPWR VPWR sky130_fd_sc_hd__decap_3
X_5742_ net148 VGND VGND VPWR VPWR _0150_ sky130_fd_sc_hd__inv_2
XFILLER_50_636 VGND VGND VPWR VPWR sky130_fd_sc_hd__fill_2
XFILLER_50_669 VPWR VGND VPWR VGND sky130_ef_sc_hd__decap_12
X_5673_ net149 VGND VGND VPWR VPWR _0081_ sky130_fd_sc_hd__inv_2
XTAP_TAPCELL_ROW_20_517 VGND VPWR sky130_fd_sc_hd__tapvpwrvgnd_1
X_4624_ net36 _2117_ _2308_ net65 net101 VGND VGND VPWR VPWR _2500_ sky130_fd_sc_hd__a221o_1
XPHY_EDGE_ROW_6_Right_6 VGND VGND VPWR VPWR sky130_fd_sc_hd__decap_3
XFILLER_116_421 VPWR VGND VPWR VGND sky130_ef_sc_hd__decap_12
X_4555_ _2282_ _2289_ _1721_ VGND VGND VPWR VPWR _2436_ sky130_fd_sc_hd__mux2_1
X_3506_ reg_file_inst.registry\[2\]\[12\] net145 _1123_ VGND VGND VPWR VPWR _1438_
+ sky130_fd_sc_hd__and3_1
XFILLER_89_327 VGND VGND VPWR VPWR sky130_fd_sc_hd__decap_8
XFILLER_89_305 VGND VGND VPWR VPWR sky130_fd_sc_hd__fill_2
X_4486_ _2129_ _2191_ VGND VGND VPWR VPWR _2371_ sky130_fd_sc_hd__or2_1
X_6225_ clknet_leaf_9_clk _0633_ _0158_ VGND VGND VPWR VPWR reg_file_inst.registry\[10\]\[18\]
+ sky130_fd_sc_hd__dfrtp_1
X_3437_ _1358_ _1369_ VGND VGND VPWR VPWR _1371_ sky130_fd_sc_hd__xnor2_1
X_3368_ _1075_ _1297_ _1300_ _1304_ VGND VGND VPWR VPWR _1305_ sky130_fd_sc_hd__or4_2
X_6156_ clknet_3_5__leaf_clk _0564_ _0089_ VGND VGND VPWR VPWR JMPOFF\[5\] sky130_fd_sc_hd__dfrtp_4
XFILLER_112_693 VGND VGND VPWR VPWR sky130_fd_sc_hd__decap_6
XFILLER_111_181 VPWR VGND VPWR VGND sky130_ef_sc_hd__decap_12
XFILLER_85_533 VGND VGND VPWR VPWR sky130_fd_sc_hd__fill_1
XFILLER_66_29 VGND VGND VPWR VPWR sky130_fd_sc_hd__decap_3
X_5107_ reg_file_inst.registry\[7\]\[12\] _2934_ _2553_ VGND VGND VPWR VPWR _0887_
+ sky130_fd_sc_hd__mux2_1
X_3299_ reg_file_inst.registry\[5\]\[23\] _1139_ _1232_ _1233_ _1234_ VGND VGND VPWR
+ VPWR _1239_ sky130_fd_sc_hd__a2111o_1
XFILLER_73_706 VGND VGND VPWR VPWR sky130_fd_sc_hd__decap_8
X_6087_ clknet_leaf_41_clk _0495_ _0020_ VGND VGND VPWR VPWR reg_file_inst.registry\[15\]\[20\]
+ sky130_fd_sc_hd__dfrtp_1
XFILLER_72_216 VPWR VGND VPWR VGND sky130_ef_sc_hd__decap_12
XFILLER_72_205 VGND VGND VPWR VPWR sky130_fd_sc_hd__fill_2
X_5038_ _2128_ _2546_ _2720_ VGND VGND VPWR VPWR _2875_ sky130_fd_sc_hd__a21o_1
XFILLER_26_622 VGND VGND VPWR VPWR sky130_fd_sc_hd__decap_4
XTAP_TAPCELL_ROW_28_617 VGND VPWR sky130_fd_sc_hd__tapvpwrvgnd_1
XFILLER_122_57 VPWR VGND VPWR VGND sky130_ef_sc_hd__decap_12
XTAP_TAPCELL_ROW_56_959 VGND VPWR sky130_fd_sc_hd__tapvpwrvgnd_1
XTAP_TAPCELL_ROW_0_253 VGND VPWR sky130_fd_sc_hd__tapvpwrvgnd_1
XFILLER_25_132 VGND VGND VPWR VPWR sky130_fd_sc_hd__decap_3
XTAP_TAPCELL_ROW_0_264 VGND VPWR sky130_fd_sc_hd__tapvpwrvgnd_1
XFILLER_13_316 VGND VGND VPWR VPWR sky130_fd_sc_hd__decap_3
XFILLER_15_66 VPWR VGND VPWR VGND sky130_ef_sc_hd__decap_12
XFILLER_21_393 VGND VGND VPWR VPWR sky130_fd_sc_hd__decap_8
XFILLER_119_281 VPWR VGND VPWR VGND sky130_ef_sc_hd__decap_12
XFILLER_110_3 VPWR VGND VPWR VGND sky130_ef_sc_hd__decap_12
XFILLER_5_559 VGND VGND VPWR VPWR sky130_fd_sc_hd__fill_1
Xoutput76 net76 VGND VGND VPWR VPWR DataMemoryWrite[12] sky130_fd_sc_hd__buf_1
Xoutput65 net65 VGND VGND VPWR VPWR DataAddress[2] sky130_fd_sc_hd__buf_1
Xoutput54 net54 VGND VGND VPWR VPWR DataAddress[18] sky130_fd_sc_hd__buf_1
XFILLER_1_721 VGND VGND VPWR VPWR sky130_fd_sc_hd__decap_4
XFILLER_103_671 VGND VGND VPWR VPWR sky130_fd_sc_hd__fill_1
Xoutput87 net87 VGND VGND VPWR VPWR DataMemoryWrite[22] sky130_fd_sc_hd__buf_1
XFILLER_76_500 VGND VGND VPWR VPWR sky130_fd_sc_hd__fill_1
XTAP_TAPCELL_ROW_8_364 VGND VPWR sky130_fd_sc_hd__tapvpwrvgnd_1
XFILLER_0_253 VGND VGND VPWR VPWR sky130_fd_sc_hd__fill_2
Xoutput98 net98 VGND VGND VPWR VPWR DataMemoryWrite[7] sky130_fd_sc_hd__buf_1
XFILLER_76_533 VPWR VGND VPWR VGND sky130_ef_sc_hd__decap_12
XFILLER_0_297 VGND VGND VPWR VPWR sky130_fd_sc_hd__decap_8
XFILLER_48_246 VGND VGND VPWR VPWR sky130_fd_sc_hd__decap_6
XFILLER_48_268 VGND VGND VPWR VPWR sky130_fd_sc_hd__fill_1
XFILLER_29_482 VPWR VGND VPWR VGND sky130_ef_sc_hd__decap_12
XFILLER_36_419 VGND VGND VPWR VPWR sky130_fd_sc_hd__fill_1
XFILLER_44_430 VGND VGND VPWR VPWR sky130_fd_sc_hd__decap_6
XFILLER_17_699 VGND VGND VPWR VPWR sky130_fd_sc_hd__decap_6
XFILLER_44_474 VGND VGND VPWR VPWR sky130_fd_sc_hd__fill_2
XTAP_TAPCELL_ROW_106_1589 VGND VPWR sky130_fd_sc_hd__tapvpwrvgnd_1
XFILLER_71_293 VGND VGND VPWR VPWR sky130_fd_sc_hd__decap_8
XFILLER_31_113 VPWR VGND VPWR VGND sky130_ef_sc_hd__decap_12
XFILLER_44_485 VGND VGND VPWR VPWR sky130_fd_sc_hd__fill_1
XFILLER_72_94 VGND VGND VPWR VPWR sky130_fd_sc_hd__decap_4
XPHY_EDGE_ROW_59_Right_59 VGND VGND VPWR VPWR sky130_fd_sc_hd__decap_3
XFILLER_12_360 VGND VGND VPWR VPWR sky130_fd_sc_hd__decap_4
XFILLER_75_6 VGND VGND VPWR VPWR sky130_fd_sc_hd__decap_6
X_4340_ _2218_ _2227_ _1791_ VGND VGND VPWR VPWR _2228_ sky130_fd_sc_hd__mux2_1
XFILLER_4_581 VGND VGND VPWR VPWR sky130_fd_sc_hd__decap_6
X_4271_ _1817_ _2158_ VGND VGND VPWR VPWR _2159_ sky130_fd_sc_hd__xnor2_1
X_3222_ reg_file_inst.registry\[15\]\[26\] _1122_ _1134_ reg_file_inst.registry\[4\]\[26\]
+ _1117_ VGND VGND VPWR VPWR _1165_ sky130_fd_sc_hd__a221o_1
X_6010_ net147 VGND VGND VPWR VPWR _0418_ sky130_fd_sc_hd__inv_2
XFILLER_79_393 VPWR VGND VPWR VGND sky130_ef_sc_hd__decap_12
XPHY_EDGE_ROW_68_Right_68 VGND VGND VPWR VPWR sky130_fd_sc_hd__decap_3
X_3153_ _1078_ _1084_ VGND VGND VPWR VPWR _1097_ sky130_fd_sc_hd__and2_4
XFILLER_27_408 VGND VGND VPWR VPWR sky130_fd_sc_hd__decap_3
XFILLER_39_246 VGND VGND VPWR VPWR sky130_fd_sc_hd__decap_4
XFILLER_94_363 VGND VGND VPWR VPWR sky130_fd_sc_hd__fill_1
X_3084_ _0992_ _1024_ _1027_ VGND VGND VPWR VPWR _1028_ sky130_fd_sc_hd__o21a_1
XTAP_TAPCELL_ROW_85_1331 VGND VPWR sky130_fd_sc_hd__tapvpwrvgnd_1
XTAP_TAPCELL_ROW_53_929 VGND VPWR sky130_fd_sc_hd__tapvpwrvgnd_1
XFILLER_23_614 VGND VGND VPWR VPWR sky130_fd_sc_hd__fill_2
XFILLER_35_474 VGND VGND VPWR VPWR sky130_fd_sc_hd__decap_6
XFILLER_50_433 VPWR VGND VPWR VGND sky130_ef_sc_hd__decap_12
XPHY_EDGE_ROW_77_Right_77 VGND VGND VPWR VPWR sky130_fd_sc_hd__decap_3
XFILLER_22_146 VPWR VGND VPWR VGND sky130_ef_sc_hd__decap_12
XFILLER_23_669 VGND VGND VPWR VPWR sky130_fd_sc_hd__decap_3
X_3986_ _1900_ _1901_ VGND VGND VPWR VPWR _1902_ sky130_fd_sc_hd__nor2_1
X_5725_ net146 VGND VGND VPWR VPWR _0133_ sky130_fd_sc_hd__inv_2
XTAP_TAPCELL_ROW_33_675 VGND VPWR sky130_fd_sc_hd__tapvpwrvgnd_1
X_5656_ net146 VGND VGND VPWR VPWR _0064_ sky130_fd_sc_hd__inv_2
X_4607_ _1764_ _2482_ _2483_ _1708_ VGND VGND VPWR VPWR _2484_ sky130_fd_sc_hd__a211o_1
XTAP_TAPCELL_ROW_96_1460 VGND VPWR sky130_fd_sc_hd__tapvpwrvgnd_1
X_5587_ reg_file_inst.registry\[15\]\[5\] _2419_ _3003_ VGND VGND VPWR VPWR _0480_
+ sky130_fd_sc_hd__mux2_1
XFILLER_116_251 VGND VGND VPWR VPWR sky130_fd_sc_hd__fill_1
XFILLER_89_113 VPWR VGND VPWR VGND sky130_ef_sc_hd__decap_12
X_4538_ reg_file_inst.registry\[11\]\[5\] _2419_ _2122_ VGND VGND VPWR VPWR _0920_
+ sky130_fd_sc_hd__mux2_1
XFILLER_2_529 VGND VGND VPWR VPWR sky130_fd_sc_hd__decap_3
XFILLER_117_57 VPWR VGND VPWR VGND sky130_ef_sc_hd__decap_12
X_4469_ _1217_ _2190_ _1840_ VGND VGND VPWR VPWR _2354_ sky130_fd_sc_hd__a21oi_1
XPHY_EDGE_ROW_86_Right_86 VGND VGND VPWR VPWR sky130_fd_sc_hd__decap_3
XFILLER_77_319 VGND VGND VPWR VPWR sky130_fd_sc_hd__fill_2
X_6208_ clknet_leaf_58_clk _0616_ _0141_ VGND VGND VPWR VPWR reg_file_inst.registry\[10\]\[1\]
+ sky130_fd_sc_hd__dfrtp_1
XTAP_TAPCELL_ROW_5_323 VGND VPWR sky130_fd_sc_hd__tapvpwrvgnd_1
X_6139_ clknet_leaf_16_clk _0547_ _0072_ VGND VGND VPWR VPWR reg_file_inst.registry\[6\]\[16\]
+ sky130_fd_sc_hd__dfrtp_1
XFILLER_58_555 VGND VGND VPWR VPWR sky130_fd_sc_hd__decap_4
XFILLER_93_38 VGND VGND VPWR VPWR sky130_fd_sc_hd__decap_8
XFILLER_85_396 VGND VGND VPWR VPWR sky130_fd_sc_hd__decap_8
XFILLER_18_419 VGND VGND VPWR VPWR sky130_fd_sc_hd__fill_1
XPHY_EDGE_ROW_95_Right_95 VGND VGND VPWR VPWR sky130_fd_sc_hd__decap_3
XFILLER_13_113 VGND VGND VPWR VPWR sky130_fd_sc_hd__decap_8
XFILLER_14_625 VPWR VGND VPWR VGND sky130_ef_sc_hd__decap_12
XFILLER_26_485 VGND VGND VPWR VPWR sky130_fd_sc_hd__decap_4
XFILLER_41_422 VGND VGND VPWR VPWR sky130_fd_sc_hd__decap_6
XFILLER_42_97 VGND VGND VPWR VPWR sky130_fd_sc_hd__decap_8
XFILLER_107_273 VGND VGND VPWR VPWR sky130_fd_sc_hd__decap_6
XFILLER_122_221 VGND VGND VPWR VPWR sky130_fd_sc_hd__decap_3
XFILLER_122_265 VPWR VGND VPWR VGND sky130_ef_sc_hd__decap_12
XFILLER_95_116 VGND VGND VPWR VPWR sky130_fd_sc_hd__decap_8
XFILLER_3_69 VPWR VGND VPWR VGND sky130_ef_sc_hd__decap_12
XFILLER_1_573 VPWR VGND VPWR VGND sky130_ef_sc_hd__decap_12
XTAP_TAPCELL_ROW_108_1618 VGND VPWR sky130_fd_sc_hd__tapvpwrvgnd_1
XFILLER_64_525 VGND VGND VPWR VPWR sky130_fd_sc_hd__decap_6
XFILLER_36_249 VGND VGND VPWR VPWR sky130_fd_sc_hd__decap_3
XFILLER_91_366 VPWR VGND VPWR VGND sky130_ef_sc_hd__decap_12
XFILLER_44_260 VGND VGND VPWR VPWR sky130_fd_sc_hd__decap_8
X_3840_ reg_file_inst.registry\[6\]\[3\] _1094_ _1095_ JMPOFF\[3\] VGND VGND VPWR
+ VPWR _1760_ sky130_fd_sc_hd__a22o_1
XTAP_TAPCELL_ROW_80_1261 VGND VPWR sky130_fd_sc_hd__tapvpwrvgnd_1
X_3771_ _1679_ _1692_ VGND VGND VPWR VPWR _1693_ sky130_fd_sc_hd__nand2_1
X_5510_ reg_file_inst.registry\[6\]\[24\] _2787_ _3001_ VGND VGND VPWR VPWR _0555_
+ sky130_fd_sc_hd__mux2_1
XFILLER_12_190 VGND VGND VPWR VPWR sky130_fd_sc_hd__decap_6
XFILLER_13_691 VPWR VGND VPWR VGND sky130_ef_sc_hd__decap_12
XTAP_TAPCELL_ROW_30_634 VGND VPWR sky130_fd_sc_hd__tapvpwrvgnd_1
XTAP_TAPCELL_ROW_30_645 VGND VPWR sky130_fd_sc_hd__tapvpwrvgnd_1
XTAP_TAPCELL_ROW_119_1747 VGND VPWR sky130_fd_sc_hd__tapvpwrvgnd_1
X_6490_ clknet_leaf_35_clk _0898_ _0423_ VGND VGND VPWR VPWR reg_file_inst.registry\[7\]\[23\]
+ sky130_fd_sc_hd__dfrtp_1
XFILLER_73_3 VGND VGND VPWR VPWR sky130_fd_sc_hd__decap_8
XFILLER_9_673 VPWR VGND VPWR VGND sky130_ef_sc_hd__decap_12
XFILLER_8_172 VPWR VGND VPWR VGND sky130_ef_sc_hd__decap_12
X_5441_ _2375_ reg_file_inst.registry\[10\]\[6\] _2998_ VGND VGND VPWR VPWR _0621_
+ sky130_fd_sc_hd__mux2_1
X_5372_ MEMOFF\[17\] _2873_ _2996_ VGND VGND VPWR VPWR _0688_ sky130_fd_sc_hd__mux2_1
XTAP_TAPCELL_ROW_10_391 VGND VPWR sky130_fd_sc_hd__tapvpwrvgnd_1
X_4323_ _1840_ _2210_ VGND VGND VPWR VPWR _2211_ sky130_fd_sc_hd__nor2_1
XFILLER_87_617 VPWR VGND VPWR VGND sky130_ef_sc_hd__decap_12
XFILLER_99_499 VGND VGND VPWR VPWR sky130_fd_sc_hd__decap_4
X_4254_ _2139_ _2141_ VGND VGND VPWR VPWR _2142_ sky130_fd_sc_hd__nor2_1
XFILLER_101_449 VPWR VGND VPWR VGND sky130_ef_sc_hd__decap_12
X_3205_ reg_file_inst.registry\[10\]\[27\] _1126_ _1138_ reg_file_inst.registry\[14\]\[27\]
+ _1144_ VGND VGND VPWR VPWR _1149_ sky130_fd_sc_hd__a221o_1
XFILLER_86_149 VGND VGND VPWR VPWR sky130_fd_sc_hd__fill_2
X_4185_ net108 net130 VGND VGND VPWR VPWR _2089_ sky130_fd_sc_hd__nand2_1
XFILLER_103_15 VPWR VGND VPWR VGND sky130_ef_sc_hd__decap_12
XFILLER_82_300 VGND VGND VPWR VPWR sky130_fd_sc_hd__fill_1
XFILLER_55_525 VPWR VGND VPWR VGND sky130_ef_sc_hd__decap_12
X_3136_ net34 net38 net39 VGND VGND VPWR VPWR _1080_ sky130_fd_sc_hd__nor3b_4
X_3067_ _0955_ _1010_ VGND VGND VPWR VPWR _1011_ sky130_fd_sc_hd__nor2_1
XTAP_TAPCELL_ROW_38_734 VGND VPWR sky130_fd_sc_hd__tapvpwrvgnd_1
XTAP_TAPCELL_ROW_38_745 VGND VPWR sky130_fd_sc_hd__tapvpwrvgnd_1
XFILLER_70_539 VGND VGND VPWR VPWR sky130_fd_sc_hd__decap_3
XFILLER_63_591 VGND VGND VPWR VPWR sky130_fd_sc_hd__decap_3
XTAP_TAPCELL_ROW_18_491 VGND VPWR sky130_fd_sc_hd__tapvpwrvgnd_1
XFILLER_35_293 VPWR VGND VPWR VGND sky130_ef_sc_hd__decap_12
XFILLER_11_617 VPWR VGND VPWR VGND sky130_ef_sc_hd__decap_12
XFILLER_109_505 VPWR VGND VPWR VGND sky130_ef_sc_hd__decap_12
X_5708_ net146 VGND VGND VPWR VPWR _0116_ sky130_fd_sc_hd__inv_2
X_3969_ _1041_ _1055_ VGND VGND VPWR VPWR _1885_ sky130_fd_sc_hd__and2_1
X_5639_ net147 VGND VGND VPWR VPWR _0047_ sky130_fd_sc_hd__inv_2
XFILLER_12_78 VGND VGND VPWR VPWR sky130_fd_sc_hd__fill_1
XFILLER_104_265 VGND VGND VPWR VPWR sky130_fd_sc_hd__decap_8
XFILLER_120_725 VGND VGND VPWR VPWR sky130_fd_sc_hd__fill_1
XFILLER_77_149 VGND VGND VPWR VPWR sky130_fd_sc_hd__fill_1
XFILLER_18_216 VGND VGND VPWR VPWR sky130_fd_sc_hd__decap_6
XFILLER_19_717 VGND VGND VPWR VPWR sky130_fd_sc_hd__fill_2
XFILLER_85_193 VGND VGND VPWR VPWR sky130_fd_sc_hd__decap_3
XFILLER_73_377 VPWR VGND VPWR VGND sky130_ef_sc_hd__decap_12
XFILLER_26_271 VGND VGND VPWR VPWR sky130_fd_sc_hd__decap_4
XTAP_TAPCELL_ROW_103_1548 VGND VPWR sky130_fd_sc_hd__tapvpwrvgnd_1
XFILLER_14_444 VPWR VGND VPWR VGND sky130_ef_sc_hd__decap_12
XFILLER_41_274 VGND VGND VPWR VPWR sky130_fd_sc_hd__decap_6
XFILLER_6_643 VGND VGND VPWR VPWR sky130_fd_sc_hd__fill_1
XFILLER_5_142 VGND VGND VPWR VPWR sky130_fd_sc_hd__decap_8
XFILLER_5_186 VPWR VGND VPWR VGND sky130_ef_sc_hd__decap_12
XTAP_TAPCELL_ROW_114_1688 VGND VPWR sky130_fd_sc_hd__tapvpwrvgnd_1
XFILLER_111_725 VGND VGND VPWR VPWR sky130_fd_sc_hd__fill_1
XFILLER_69_628 VGND VGND VPWR VPWR sky130_fd_sc_hd__fill_2
XFILLER_68_149 VGND VGND VPWR VPWR sky130_fd_sc_hd__fill_2
XFILLER_76_193 VGND VGND VPWR VPWR sky130_fd_sc_hd__decap_3
XFILLER_76_171 VGND VGND VPWR VPWR sky130_fd_sc_hd__fill_1
XTAP_TAPCELL_ROW_69_1123 VGND VPWR sky130_fd_sc_hd__tapvpwrvgnd_1
XFILLER_37_558 VGND VGND VPWR VPWR sky130_fd_sc_hd__fill_2
X_5990_ net148 VGND VGND VPWR VPWR _0398_ sky130_fd_sc_hd__inv_2
XFILLER_64_377 VPWR VGND VPWR VGND sky130_ef_sc_hd__decap_12
XTAP_TAPCELL_ROW_35_704 VGND VPWR sky130_fd_sc_hd__tapvpwrvgnd_1
X_4941_ _2582_ _2791_ _2580_ VGND VGND VPWR VPWR _2792_ sky130_fd_sc_hd__o21ai_1
XFILLER_33_720 VGND VGND VPWR VPWR sky130_fd_sc_hd__decap_3
XFILLER_45_591 VGND VGND VPWR VPWR sky130_fd_sc_hd__fill_1
X_4872_ _2725_ _2728_ net136 VGND VGND VPWR VPWR _2729_ sky130_fd_sc_hd__mux2_1
X_3823_ reg_file_inst.registry\[3\]\[5\] _1116_ _1119_ VGND VGND VPWR VPWR _1744_
+ sky130_fd_sc_hd__and3_1
XTAP_TAPCELL_ROW_15_450 VGND VPWR sky130_fd_sc_hd__tapvpwrvgnd_1
X_3754_ reg_file_inst.registry\[7\]\[6\] _1086_ _1092_ reg_file_inst.registry\[4\]\[6\]
+ VGND VGND VPWR VPWR _1677_ sky130_fd_sc_hd__a22o_1
XFILLER_118_357 VGND VGND VPWR VPWR sky130_fd_sc_hd__decap_6
XFILLER_9_481 VPWR VGND VPWR VGND sky130_ef_sc_hd__decap_12
X_3685_ reg_file_inst.registry\[15\]\[8\] _1122_ _1130_ JMPOFF\[8\] _1609_ VGND VGND
+ VPWR VPWR _1610_ sky130_fd_sc_hd__a221o_1
X_6473_ clknet_leaf_3_clk _0881_ _0406_ VGND VGND VPWR VPWR reg_file_inst.registry\[7\]\[6\]
+ sky130_fd_sc_hd__dfrtp_1
X_5424_ _2806_ reg_file_inst.registry\[10\]\[23\] _2998_ VGND VGND VPWR VPWR _0638_
+ sky130_fd_sc_hd__mux2_1
XTAP_TAPCELL_ROW_93_1430 VGND VPWR sky130_fd_sc_hd__tapvpwrvgnd_1
X_5355_ _2419_ reg_file_inst.registry\[3\]\[5\] _2995_ VGND VGND VPWR VPWR _0704_
+ sky130_fd_sc_hd__mux2_1
XFILLER_102_725 VGND VGND VPWR VPWR sky130_fd_sc_hd__fill_1
XFILLER_101_213 VGND VGND VPWR VPWR sky130_fd_sc_hd__decap_8
X_5286_ _2883_ reg_file_inst.registry\[2\]\[16\] _2993_ VGND VGND VPWR VPWR _0771_
+ sky130_fd_sc_hd__mux2_1
X_4306_ _1417_ _2190_ VGND VGND VPWR VPWR _2194_ sky130_fd_sc_hd__and2_1
X_4237_ net31 _1110_ VGND VGND VPWR VPWR _2125_ sky130_fd_sc_hd__or2_4
XFILLER_28_503 VGND VGND VPWR VPWR sky130_fd_sc_hd__decap_8
XFILLER_74_29 VPWR VGND VPWR VGND sky130_ef_sc_hd__decap_12
XFILLER_67_193 VGND VGND VPWR VPWR sky130_fd_sc_hd__fill_2
X_4168_ _2076_ net114 net130 VGND VGND VPWR VPWR _0942_ sky130_fd_sc_hd__mux2_1
XFILLER_82_141 VPWR VGND VPWR VGND sky130_ef_sc_hd__decap_12
XFILLER_82_130 VGND VGND VPWR VPWR sky130_fd_sc_hd__decap_8
XFILLER_70_303 VGND VGND VPWR VPWR sky130_fd_sc_hd__fill_2
X_3119_ JMPOFF\[19\] net141 net41 VGND VGND VPWR VPWR _1063_ sky130_fd_sc_hd__a21o_1
X_4099_ net112 _2011_ VGND VGND VPWR VPWR _2015_ sky130_fd_sc_hd__or2_1
XFILLER_43_517 VGND VGND VPWR VPWR sky130_fd_sc_hd__fill_1
XFILLER_83_697 VPWR VGND VPWR VGND sky130_ef_sc_hd__decap_12
XFILLER_43_528 VGND VGND VPWR VPWR sky130_fd_sc_hd__decap_8
XFILLER_23_33 VGND VGND VPWR VPWR sky130_fd_sc_hd__decap_3
XFILLER_7_429 VGND VGND VPWR VPWR sky130_fd_sc_hd__decap_3
XFILLER_109_335 VGND VGND VPWR VPWR sky130_fd_sc_hd__fill_1
XFILLER_99_15 VPWR VGND VPWR VGND sky130_ef_sc_hd__decap_12
XFILLER_2_101 VGND VGND VPWR VPWR sky130_fd_sc_hd__decap_3
XFILLER_105_541 VPWR VGND VPWR VGND sky130_ef_sc_hd__decap_12
XFILLER_3_3 VPWR VGND VPWR VGND sky130_ef_sc_hd__decap_12
XFILLER_105_585 VPWR VGND VPWR VGND sky130_ef_sc_hd__decap_12
XFILLER_2_189 VGND VGND VPWR VPWR sky130_fd_sc_hd__decap_6
XFILLER_120_533 VPWR VGND VPWR VGND sky130_ef_sc_hd__decap_12
XFILLER_78_469 VGND VGND VPWR VPWR sky130_fd_sc_hd__decap_6
XFILLER_48_85 VGND VGND VPWR VPWR sky130_fd_sc_hd__decap_6
XPHY_EDGE_ROW_100_Left_223 VGND VGND VPWR VPWR sky130_fd_sc_hd__decap_3
XFILLER_58_193 VGND VGND VPWR VPWR sky130_fd_sc_hd__decap_3
XFILLER_0_37 VGND VGND VPWR VPWR sky130_fd_sc_hd__decap_8
XFILLER_74_697 VGND VGND VPWR VPWR sky130_fd_sc_hd__decap_3
XFILLER_73_163 VGND VGND VPWR VPWR sky130_fd_sc_hd__decap_4
XFILLER_64_51 VPWR VGND VPWR VGND sky130_ef_sc_hd__decap_12
XFILLER_61_358 VGND VGND VPWR VPWR sky130_fd_sc_hd__decap_8
XTAP_TAPCELL_ROW_64_1064 VGND VPWR sky130_fd_sc_hd__tapvpwrvgnd_1
XFILLER_14_241 VGND VGND VPWR VPWR sky130_fd_sc_hd__decap_4
XFILLER_30_701 VGND VGND VPWR VPWR sky130_fd_sc_hd__decap_4
XFILLER_42_550 VGND VGND VPWR VPWR sky130_fd_sc_hd__decap_6
XFILLER_9_57 VGND VGND VPWR VPWR sky130_fd_sc_hd__decap_6
XTAP_TAPCELL_ROW_12_420 VGND VPWR sky130_fd_sc_hd__tapvpwrvgnd_1
XTAP_TAPCELL_ROW_40_762 VGND VPWR sky130_fd_sc_hd__tapvpwrvgnd_1
XTAP_TAPCELL_ROW_116_1717 VGND VPWR sky130_fd_sc_hd__tapvpwrvgnd_1
XFILLER_115_305 VPWR VGND VPWR VGND sky130_ef_sc_hd__decap_12
XFILLER_115_349 VPWR VGND VPWR VGND sky130_ef_sc_hd__decap_12
X_3470_ reg_file_inst.registry\[0\]\[17\] net138 _1395_ _1402_ VGND VGND VPWR VPWR
+ _1403_ sky130_fd_sc_hd__o22a_2
X_5140_ _2177_ _2961_ _2962_ VGND VGND VPWR VPWR _2963_ sky130_fd_sc_hd__or3_1
XFILLER_69_447 VGND VGND VPWR VPWR sky130_fd_sc_hd__fill_1
X_5071_ _1515_ _2282_ _2903_ VGND VGND VPWR VPWR _2904_ sky130_fd_sc_hd__o21ai_1
XFILLER_56_108 VGND VGND VPWR VPWR sky130_fd_sc_hd__fill_1
X_4022_ _1935_ _1937_ VGND VGND VPWR VPWR _1938_ sky130_fd_sc_hd__or2_1
XFILLER_65_631 VGND VGND VPWR VPWR sky130_fd_sc_hd__fill_2
XFILLER_49_193 VPWR VGND VPWR VGND sky130_ef_sc_hd__decap_12
XFILLER_65_664 VGND VGND VPWR VPWR sky130_fd_sc_hd__fill_1
XTAP_TAPCELL_ROW_48_862 VGND VPWR sky130_fd_sc_hd__tapvpwrvgnd_1
XFILLER_92_472 VGND VGND VPWR VPWR sky130_fd_sc_hd__decap_4
XFILLER_64_185 VGND VGND VPWR VPWR sky130_fd_sc_hd__decap_8
X_5973_ net148 VGND VGND VPWR VPWR _0381_ sky130_fd_sc_hd__inv_2
XFILLER_52_303 VGND VGND VPWR VPWR sky130_fd_sc_hd__decap_4
XFILLER_18_580 VGND VGND VPWR VPWR sky130_fd_sc_hd__decap_8
XFILLER_37_399 VGND VGND VPWR VPWR sky130_fd_sc_hd__fill_1
XFILLER_52_347 VPWR VGND VPWR VGND sky130_ef_sc_hd__decap_12
X_4924_ _2724_ _2726_ net133 VGND VGND VPWR VPWR _2777_ sky130_fd_sc_hd__mux2_1
XFILLER_33_561 VPWR VGND VPWR VGND sky130_ef_sc_hd__decap_12
X_4855_ _2684_ _2690_ _2713_ VGND VGND VPWR VPWR _2714_ sky130_fd_sc_hd__a21o_1
X_3806_ reg_file_inst.registry\[8\]\[5\] _1090_ _1094_ reg_file_inst.registry\[6\]\[5\]
+ VGND VGND VPWR VPWR _1727_ sky130_fd_sc_hd__a22o_1
X_4786_ _1457_ _2639_ VGND VGND VPWR VPWR _2645_ sky130_fd_sc_hd__xnor2_1
XFILLER_118_121 VPWR VGND VPWR VGND sky130_ef_sc_hd__decap_12
X_3737_ reg_file_inst.registry\[2\]\[7\] _1116_ _1123_ VGND VGND VPWR VPWR _1661_
+ sky130_fd_sc_hd__and3_1
X_6525_ clknet_leaf_49_clk _0933_ _0458_ VGND VGND VPWR VPWR net104 sky130_fd_sc_hd__dfrtp_1
XFILLER_118_165 VPWR VGND VPWR VGND sky130_ef_sc_hd__decap_12
XFILLER_109_69 VPWR VGND VPWR VGND sky130_ef_sc_hd__decap_12
XFILLER_69_29 VGND VGND VPWR VPWR sky130_fd_sc_hd__fill_1
X_6456_ clknet_leaf_7_clk _0864_ _0389_ VGND VGND VPWR VPWR reg_file_inst.registry\[0\]\[17\]
+ sky130_fd_sc_hd__dfrtp_2
X_3668_ _1587_ _1589_ _1593_ _1583_ VGND VGND VPWR VPWR net100 sky130_fd_sc_hd__o31a_2
XFILLER_88_701 VPWR VGND VPWR VGND sky130_ef_sc_hd__decap_12
X_6387_ clknet_leaf_7_clk _0795_ _0320_ VGND VGND VPWR VPWR reg_file_inst.registry\[14\]\[12\]
+ sky130_fd_sc_hd__dfrtp_1
X_5407_ reg_file_inst.registry\[4\]\[11\] _2948_ _2997_ VGND VGND VPWR VPWR _0654_
+ sky130_fd_sc_hd__mux2_1
X_3599_ reg_file_inst.registry\[1\]\[11\] _1087_ _1095_ JMPOFF\[11\] _1526_ VGND VGND
+ VPWR VPWR _1527_ sky130_fd_sc_hd__a221o_1
X_5338_ _2817_ reg_file_inst.registry\[3\]\[22\] _2995_ VGND VGND VPWR VPWR _0721_
+ sky130_fd_sc_hd__mux2_1
XFILLER_0_605 VGND VGND VPWR VPWR sky130_fd_sc_hd__fill_1
XFILLER_102_533 VPWR VGND VPWR VGND sky130_ef_sc_hd__decap_12
XFILLER_85_39 VPWR VGND VPWR VGND sky130_ef_sc_hd__decap_12
X_5269_ reg_file_inst.registry\[14\]\[4\] _2455_ _2992_ VGND VGND VPWR VPWR _0787_
+ sky130_fd_sc_hd__mux2_1
XFILLER_71_612 VGND VGND VPWR VPWR sky130_fd_sc_hd__decap_4
XFILLER_43_325 VGND VGND VPWR VPWR sky130_fd_sc_hd__fill_2
XFILLER_70_166 VPWR VGND VPWR VGND sky130_ef_sc_hd__decap_12
XTAP_TAPCELL_ROW_26_589 VGND VPWR sky130_fd_sc_hd__tapvpwrvgnd_1
XTAP_TAPCELL_ROW_100_1518 VGND VPWR sky130_fd_sc_hd__tapvpwrvgnd_1
XFILLER_3_421 VGND VGND VPWR VPWR sky130_fd_sc_hd__fill_1
XFILLER_50_97 VGND VGND VPWR VPWR sky130_fd_sc_hd__decap_8
XFILLER_3_465 VGND VGND VPWR VPWR sky130_fd_sc_hd__decap_4
XTAP_TAPCELL_ROW_111_1647 VGND VPWR sky130_fd_sc_hd__tapvpwrvgnd_1
XFILLER_105_393 VGND VGND VPWR VPWR sky130_fd_sc_hd__decap_8
XFILLER_120_363 VGND VGND VPWR VPWR sky130_fd_sc_hd__fill_1
XFILLER_78_299 VGND VGND VPWR VPWR sky130_fd_sc_hd__decap_8
XFILLER_81_409 VGND VGND VPWR VPWR sky130_fd_sc_hd__decap_8
XFILLER_46_141 VGND VGND VPWR VPWR sky130_fd_sc_hd__decap_8
XFILLER_34_303 VGND VGND VPWR VPWR sky130_fd_sc_hd__fill_2
XTAP_TAPCELL_ROW_45_821 VGND VPWR sky130_fd_sc_hd__tapvpwrvgnd_1
XFILLER_46_163 VGND VGND VPWR VPWR sky130_fd_sc_hd__decap_4
XFILLER_62_667 VPWR VGND VPWR VGND sky130_ef_sc_hd__decap_12
XFILLER_61_133 VGND VGND VPWR VPWR sky130_fd_sc_hd__fill_2
XTAP_TAPCELL_ROW_45_832 VGND VPWR sky130_fd_sc_hd__tapvpwrvgnd_1
XFILLER_61_166 VGND VGND VPWR VPWR sky130_fd_sc_hd__fill_2
XFILLER_15_561 VGND VGND VPWR VPWR sky130_fd_sc_hd__fill_1
XTAP_TAPCELL_ROW_122_1798 VGND VPWR sky130_fd_sc_hd__tapvpwrvgnd_1
XTAP_TAPCELL_ROW_122_1787 VGND VPWR sky130_fd_sc_hd__tapvpwrvgnd_1
X_4640_ _2377_ _2514_ _1791_ VGND VGND VPWR VPWR _2515_ sky130_fd_sc_hd__mux2_1
XFILLER_30_542 VGND VGND VPWR VPWR sky130_fd_sc_hd__decap_6
X_6310_ clknet_leaf_21_clk _0718_ _0243_ VGND VGND VPWR VPWR reg_file_inst.registry\[3\]\[19\]
+ sky130_fd_sc_hd__dfrtp_1
XTAP_TAPCELL_ROW_77_1222 VGND VPWR sky130_fd_sc_hd__tapvpwrvgnd_1
X_4571_ _2449_ _2451_ _2237_ VGND VGND VPWR VPWR _2452_ sky130_fd_sc_hd__o21a_1
XFILLER_116_625 VPWR VGND VPWR VGND sky130_ef_sc_hd__decap_12
XFILLER_115_113 VPWR VGND VPWR VGND sky130_ef_sc_hd__decap_12
X_3522_ reg_file_inst.registry\[15\]\[13\] _1093_ _1097_ reg_file_inst.registry\[5\]\[13\]
+ _1452_ VGND VGND VPWR VPWR _1453_ sky130_fd_sc_hd__a221o_1
XFILLER_116_669 VPWR VGND VPWR VGND sky130_ef_sc_hd__decap_12
X_3453_ reg_file_inst.registry\[6\]\[16\] _1135_ _1140_ reg_file_inst.registry\[3\]\[16\]
+ VGND VGND VPWR VPWR _1387_ sky130_fd_sc_hd__a22o_1
X_6241_ clknet_leaf_2_clk _0649_ _0174_ VGND VGND VPWR VPWR reg_file_inst.registry\[4\]\[6\]
+ sky130_fd_sc_hd__dfrtp_1
X_6172_ clknet_leaf_37_clk _0580_ _0105_ VGND VGND VPWR VPWR JMPOFF\[21\] sky130_fd_sc_hd__dfrtp_2
X_3384_ MEMOFF\[20\] net85 _1113_ VGND VGND VPWR VPWR _1320_ sky130_fd_sc_hd__mux2_4
X_5123_ reg_file_inst.registry\[7\]\[11\] _2948_ _2553_ VGND VGND VPWR VPWR _0886_
+ sky130_fd_sc_hd__mux2_1
XFILLER_97_564 VPWR VGND VPWR VGND sky130_ef_sc_hd__decap_12
XFILLER_69_277 VGND VGND VPWR VPWR sky130_fd_sc_hd__decap_3
XFILLER_111_385 VGND VGND VPWR VPWR sky130_fd_sc_hd__decap_6
XFILLER_57_439 VGND VGND VPWR VPWR sky130_fd_sc_hd__decap_8
XFILLER_57_428 VGND VGND VPWR VPWR sky130_fd_sc_hd__decap_4
X_5054_ _1480_ _1492_ _2289_ _2888_ VGND VGND VPWR VPWR _2889_ sky130_fd_sc_hd__a22o_1
X_4005_ _1916_ _1920_ VGND VGND VPWR VPWR _1921_ sky130_fd_sc_hd__nand2_1
XTAP_TAPCELL_ROW_88_1362 VGND VPWR sky130_fd_sc_hd__tapvpwrvgnd_1
XFILLER_38_697 VGND VGND VPWR VPWR sky130_fd_sc_hd__decap_3
XFILLER_111_15 VPWR VGND VPWR VGND sky130_ef_sc_hd__decap_12
X_5956_ net148 VGND VGND VPWR VPWR _0364_ sky130_fd_sc_hd__inv_2
XFILLER_53_689 VGND VGND VPWR VPWR sky130_fd_sc_hd__fill_2
X_5887_ net44 VGND VGND VPWR VPWR _0295_ sky130_fd_sc_hd__inv_2
X_4907_ _1765_ _2296_ _2518_ _2761_ _2277_ VGND VGND VPWR VPWR _2762_ sky130_fd_sc_hd__a32o_1
X_4838_ _1790_ _2696_ _2693_ VGND VGND VPWR VPWR _2697_ sky130_fd_sc_hd__a21o_1
XFILLER_21_564 VGND VGND VPWR VPWR sky130_fd_sc_hd__decap_3
XTAP_TAPCELL_ROW_23_548 VGND VPWR sky130_fd_sc_hd__tapvpwrvgnd_1
XFILLER_119_441 VGND VGND VPWR VPWR sky130_fd_sc_hd__decap_6
X_4769_ _2126_ _2556_ VGND VGND VPWR VPWR _2628_ sky130_fd_sc_hd__nor2_1
XFILLER_119_485 VPWR VGND VPWR VGND sky130_ef_sc_hd__decap_12
X_6508_ clknet_leaf_57_clk _0916_ _0441_ VGND VGND VPWR VPWR reg_file_inst.registry\[11\]\[1\]
+ sky130_fd_sc_hd__dfrtp_1
XFILLER_20_56 VGND VGND VPWR VPWR sky130_fd_sc_hd__fill_1
X_6439_ clknet_leaf_55_clk _0847_ _0372_ VGND VGND VPWR VPWR reg_file_inst.registry\[0\]\[0\]
+ sky130_fd_sc_hd__dfrtp_4
XFILLER_121_105 VGND VGND VPWR VPWR sky130_fd_sc_hd__decap_6
XFILLER_20_78 VGND VGND VPWR VPWR sky130_fd_sc_hd__decap_6
XFILLER_121_149 VPWR VGND VPWR VGND sky130_ef_sc_hd__decap_12
XFILLER_88_542 VGND VGND VPWR VPWR sky130_fd_sc_hd__decap_8
XFILLER_88_564 VPWR VGND VPWR VGND sky130_ef_sc_hd__decap_12
XFILLER_102_385 VPWR VGND VPWR VGND sky130_ef_sc_hd__decap_12
XFILLER_75_225 VPWR VGND VPWR VGND sky130_ef_sc_hd__decap_12
XFILLER_29_87 VGND VGND VPWR VPWR sky130_fd_sc_hd__decap_8
XFILLER_29_653 VPWR VGND VPWR VGND sky130_ef_sc_hd__decap_12
XFILLER_29_686 VGND VGND VPWR VPWR sky130_fd_sc_hd__fill_2
XFILLER_43_100 VPWR VGND VPWR VGND sky130_ef_sc_hd__decap_12
XFILLER_44_601 VGND VGND VPWR VPWR sky130_fd_sc_hd__decap_8
XFILLER_90_239 VGND VGND VPWR VPWR sky130_fd_sc_hd__fill_1
XFILLER_44_645 VPWR VGND VPWR VGND sky130_ef_sc_hd__decap_12
XFILLER_71_486 VGND VGND VPWR VPWR sky130_fd_sc_hd__fill_1
XFILLER_71_453 VGND VGND VPWR VPWR sky130_fd_sc_hd__fill_1
XTAP_TAPCELL_ROW_61_1023 VGND VPWR sky130_fd_sc_hd__tapvpwrvgnd_1
XFILLER_101_81 VPWR VGND VPWR VGND sky130_ef_sc_hd__decap_12
XFILLER_61_52 VGND VGND VPWR VPWR sky130_fd_sc_hd__decap_4
XFILLER_12_531 VGND VGND VPWR VPWR sky130_fd_sc_hd__fill_1
XFILLER_12_564 VPWR VGND VPWR VGND sky130_ef_sc_hd__decap_12
XFILLER_8_557 VPWR VGND VPWR VGND sky130_ef_sc_hd__decap_12
XTAP_TAPCELL_ROW_50_890 VGND VPWR sky130_fd_sc_hd__tapvpwrvgnd_1
XANTENNA_7 _1123_ VGND VGND VPWR VPWR sky130_fd_sc_hd__diode_2
XFILLER_113_617 VPWR VGND VPWR VGND sky130_ef_sc_hd__decap_12
XFILLER_98_306 VGND VGND VPWR VPWR sky130_fd_sc_hd__fill_2
XFILLER_3_251 VGND VGND VPWR VPWR sky130_fd_sc_hd__fill_2
XFILLER_3_240 VGND VGND VPWR VPWR sky130_fd_sc_hd__decap_3
XTAP_TAPCELL_ROW_72_1163 VGND VPWR sky130_fd_sc_hd__tapvpwrvgnd_1
XFILLER_39_406 VGND VGND VPWR VPWR sky130_fd_sc_hd__fill_1
XFILLER_94_545 VGND VGND VPWR VPWR sky130_fd_sc_hd__decap_6
XFILLER_19_152 VGND VGND VPWR VPWR sky130_fd_sc_hd__fill_1
XFILLER_35_612 VGND VGND VPWR VPWR sky130_fd_sc_hd__decap_4
XFILLER_35_623 VGND VGND VPWR VPWR sky130_fd_sc_hd__decap_6
XFILLER_47_461 VPWR VGND VPWR VGND sky130_ef_sc_hd__decap_12
XFILLER_74_291 VGND VGND VPWR VPWR sky130_fd_sc_hd__fill_1
XFILLER_62_431 VGND VGND VPWR VPWR sky130_fd_sc_hd__decap_4
XTAP_TAPCELL_ROW_58_990 VGND VPWR sky130_fd_sc_hd__tapvpwrvgnd_1
XFILLER_34_133 VGND VGND VPWR VPWR sky130_fd_sc_hd__decap_6
X_5810_ net149 VGND VGND VPWR VPWR _0218_ sky130_fd_sc_hd__inv_2
XFILLER_62_475 VGND VGND VPWR VPWR sky130_fd_sc_hd__fill_1
X_5741_ net148 VGND VGND VPWR VPWR _0149_ sky130_fd_sc_hd__inv_2
X_5672_ net146 VGND VGND VPWR VPWR _0080_ sky130_fd_sc_hd__inv_2
XTAP_TAPCELL_ROW_20_518 VGND VPWR sky130_fd_sc_hd__tapvpwrvgnd_1
X_4623_ _2488_ _2496_ _2499_ VGND VGND VPWR VPWR net65 sky130_fd_sc_hd__or3_4
X_4554_ _2168_ _2169_ VGND VGND VPWR VPWR _2435_ sky130_fd_sc_hd__or2_1
XFILLER_116_433 VPWR VGND VPWR VGND sky130_ef_sc_hd__decap_12
X_3505_ reg_file_inst.registry\[10\]\[12\] _1123_ net143 VGND VGND VPWR VPWR _1437_
+ sky130_fd_sc_hd__and3_1
XFILLER_116_477 VPWR VGND VPWR VGND sky130_ef_sc_hd__decap_12
XFILLER_103_105 VGND VGND VPWR VPWR sky130_fd_sc_hd__decap_6
X_6224_ clknet_leaf_25_clk _0632_ _0157_ VGND VGND VPWR VPWR reg_file_inst.registry\[10\]\[17\]
+ sky130_fd_sc_hd__dfrtp_1
X_4485_ _1764_ _2362_ _2369_ _2237_ VGND VGND VPWR VPWR _2370_ sky130_fd_sc_hd__o31a_1
XFILLER_106_15 VPWR VGND VPWR VGND sky130_ef_sc_hd__decap_12
X_3436_ _1357_ _1369_ VGND VGND VPWR VPWR _1370_ sky130_fd_sc_hd__nand2_1
X_3367_ reg_file_inst.registry\[4\]\[20\] _1092_ _1301_ _1303_ VGND VGND VPWR VPWR
+ _1304_ sky130_fd_sc_hd__a211o_1
X_6155_ clknet_leaf_53_clk _0563_ _0088_ VGND VGND VPWR VPWR JMPOFF\[4\] sky130_fd_sc_hd__dfrtp_2
X_6086_ clknet_leaf_19_clk _0494_ _0019_ VGND VGND VPWR VPWR reg_file_inst.registry\[15\]\[19\]
+ sky130_fd_sc_hd__dfrtp_1
X_5106_ net4 net101 net48 _2308_ VGND VGND VPWR VPWR _2934_ sky130_fd_sc_hd__a22o_4
XFILLER_111_193 VPWR VGND VPWR VGND sky130_ef_sc_hd__decap_12
X_3298_ reg_file_inst.registry\[10\]\[23\] _1126_ _1136_ reg_file_inst.registry\[8\]\[23\]
+ VGND VGND VPWR VPWR _1238_ sky130_fd_sc_hd__a22o_1
X_5037_ _2653_ _2655_ VGND VGND VPWR VPWR _2874_ sky130_fd_sc_hd__and2_1
XFILLER_72_228 VGND VGND VPWR VPWR sky130_fd_sc_hd__decap_8
XFILLER_26_601 VPWR VGND VPWR VGND sky130_ef_sc_hd__decap_12
XTAP_TAPCELL_ROW_28_618 VGND VPWR sky130_fd_sc_hd__tapvpwrvgnd_1
XFILLER_122_69 VPWR VGND VPWR VGND sky130_ef_sc_hd__decap_12
XFILLER_82_29 VPWR VGND VPWR VGND sky130_ef_sc_hd__decap_12
XTAP_TAPCELL_ROW_0_254 VGND VPWR sky130_fd_sc_hd__tapvpwrvgnd_1
XFILLER_25_111 VGND VGND VPWR VPWR sky130_fd_sc_hd__fill_1
XFILLER_26_634 VGND VGND VPWR VPWR sky130_fd_sc_hd__fill_1
XFILLER_26_645 VPWR VGND VPWR VGND sky130_ef_sc_hd__decap_12
XTAP_TAPCELL_ROW_0_265 VGND VPWR sky130_fd_sc_hd__tapvpwrvgnd_1
XFILLER_13_328 VGND VGND VPWR VPWR sky130_fd_sc_hd__fill_1
XFILLER_40_103 VPWR VGND VPWR VGND sky130_ef_sc_hd__decap_12
XFILLER_15_78 VPWR VGND VPWR VGND sky130_ef_sc_hd__decap_12
X_5939_ net147 VGND VGND VPWR VPWR _0347_ sky130_fd_sc_hd__inv_2
XFILLER_40_169 VGND VGND VPWR VPWR sky130_fd_sc_hd__fill_2
XFILLER_5_505 VPWR VGND VPWR VGND sky130_ef_sc_hd__decap_12
XFILLER_21_383 VGND VGND VPWR VPWR sky130_fd_sc_hd__fill_1
XFILLER_119_293 VPWR VGND VPWR VGND sky130_ef_sc_hd__decap_12
XFILLER_103_3 VPWR VGND VPWR VGND sky130_ef_sc_hd__decap_12
Xoutput66 net66 VGND VGND VPWR VPWR DataAddress[3] sky130_fd_sc_hd__buf_1
Xoutput55 net55 VGND VGND VPWR VPWR DataAddress[19] sky130_fd_sc_hd__buf_1
Xoutput88 net88 VGND VGND VPWR VPWR DataMemoryWrite[23] sky130_fd_sc_hd__buf_1
Xoutput77 net77 VGND VGND VPWR VPWR DataMemoryWrite[13] sky130_fd_sc_hd__buf_1
XTAP_TAPCELL_ROW_8_365 VGND VPWR sky130_fd_sc_hd__tapvpwrvgnd_1
XFILLER_0_232 VGND VGND VPWR VPWR sky130_fd_sc_hd__fill_2
Xoutput99 net99 VGND VGND VPWR VPWR DataMemoryWrite[8] sky130_fd_sc_hd__buf_1
XFILLER_76_545 VGND VGND VPWR VPWR sky130_fd_sc_hd__fill_1
XFILLER_17_634 VPWR VGND VPWR VGND sky130_ef_sc_hd__decap_12
XFILLER_29_494 VGND VGND VPWR VPWR sky130_fd_sc_hd__decap_8
XFILLER_71_261 VPWR VGND VPWR VGND sky130_ef_sc_hd__decap_12
XFILLER_31_169 VPWR VGND VPWR VGND sky130_ef_sc_hd__decap_12
XFILLER_8_332 VPWR VGND VPWR VGND sky130_ef_sc_hd__decap_12
XFILLER_40_692 VGND VGND VPWR VPWR sky130_fd_sc_hd__decap_8
XFILLER_68_6 VGND VGND VPWR VPWR sky130_fd_sc_hd__decap_6
XFILLER_8_376 VPWR VGND VPWR VGND sky130_ef_sc_hd__decap_12
XFILLER_8_365 VGND VGND VPWR VPWR sky130_fd_sc_hd__fill_2
XFILLER_99_615 VGND VGND VPWR VPWR sky130_fd_sc_hd__fill_1
XFILLER_113_447 VGND VGND VPWR VPWR sky130_fd_sc_hd__fill_1
X_4270_ reg_file_inst.registry\[0\]\[0\] _1076_ _1834_ _1839_ _2127_ VGND VGND VPWR
+ VPWR _2158_ sky130_fd_sc_hd__o221a_1
XFILLER_101_609 VGND VGND VPWR VPWR sky130_fd_sc_hd__decap_6
X_3221_ reg_file_inst.registry\[6\]\[26\] _1135_ _1141_ reg_file_inst.registry\[11\]\[26\]
+ _1163_ VGND VGND VPWR VPWR _1164_ sky130_fd_sc_hd__a221o_1
XFILLER_79_361 VGND VGND VPWR VPWR sky130_fd_sc_hd__fill_1
XFILLER_79_383 VGND VGND VPWR VPWR sky130_fd_sc_hd__decap_8
XFILLER_67_534 VGND VGND VPWR VPWR sky130_fd_sc_hd__decap_3
X_3152_ _1085_ _1088_ VGND VGND VPWR VPWR _1096_ sky130_fd_sc_hd__and2_4
XFILLER_39_203 VPWR VGND VPWR VGND sky130_ef_sc_hd__decap_12
XFILLER_94_353 VGND VGND VPWR VPWR sky130_fd_sc_hd__fill_2
XFILLER_94_386 VPWR VGND VPWR VGND sky130_ef_sc_hd__decap_12
XFILLER_55_718 VGND VGND VPWR VPWR sky130_fd_sc_hd__fill_1
X_3083_ _1025_ _1026_ VGND VGND VPWR VPWR _1027_ sky130_fd_sc_hd__and2_1
XTAP_TAPCELL_ROW_85_1332 VGND VPWR sky130_fd_sc_hd__tapvpwrvgnd_1
XTAP_TAPCELL_ROW_85_1321 VGND VPWR sky130_fd_sc_hd__tapvpwrvgnd_1
XFILLER_62_283 VGND VGND VPWR VPWR sky130_fd_sc_hd__decap_4
XFILLER_22_158 VPWR VGND VPWR VGND sky130_ef_sc_hd__decap_12
X_3985_ net131 _1898_ _1899_ net107 VGND VGND VPWR VPWR _1901_ sky130_fd_sc_hd__a31oi_1
XFILLER_50_445 VPWR VGND VPWR VGND sky130_ef_sc_hd__decap_12
X_5724_ net149 VGND VGND VPWR VPWR _0132_ sky130_fd_sc_hd__inv_2
XFILLER_10_309 VPWR VGND VPWR VGND sky130_ef_sc_hd__decap_12
XTAP_TAPCELL_ROW_33_676 VGND VPWR sky130_fd_sc_hd__tapvpwrvgnd_1
XFILLER_109_709 VPWR VGND VPWR VGND sky130_ef_sc_hd__decap_12
X_5655_ net146 VGND VGND VPWR VPWR _0063_ sky130_fd_sc_hd__inv_2
X_4606_ _1791_ _2350_ _2481_ net137 VGND VGND VPWR VPWR _2483_ sky130_fd_sc_hd__o211a_1
XTAP_TAPCELL_ROW_96_1461 VGND VPWR sky130_fd_sc_hd__tapvpwrvgnd_1
X_5586_ reg_file_inst.registry\[15\]\[6\] _2375_ _3003_ VGND VGND VPWR VPWR _0481_
+ sky130_fd_sc_hd__mux2_1
X_4537_ _2308_ net68 _2418_ VGND VGND VPWR VPWR _2419_ sky130_fd_sc_hd__a21o_4
XFILLER_117_69 VPWR VGND VPWR VGND sky130_ef_sc_hd__decap_12
XFILLER_89_125 VPWR VGND VPWR VGND sky130_ef_sc_hd__decap_12
X_4468_ _1194_ _2190_ _1841_ VGND VGND VPWR VPWR _2353_ sky130_fd_sc_hd__a21oi_1
X_3419_ reg_file_inst.registry\[2\]\[18\] _1083_ _1096_ reg_file_inst.registry\[11\]\[18\]
+ VGND VGND VPWR VPWR _1354_ sky130_fd_sc_hd__a22o_1
X_6207_ clknet_leaf_46_clk _0615_ _0140_ VGND VGND VPWR VPWR reg_file_inst.registry\[10\]\[0\]
+ sky130_fd_sc_hd__dfrtp_1
XFILLER_98_681 VPWR VGND VPWR VGND sky130_ef_sc_hd__decap_12
X_6138_ clknet_leaf_16_clk _0546_ _0071_ VGND VGND VPWR VPWR reg_file_inst.registry\[6\]\[15\]
+ sky130_fd_sc_hd__dfrtp_1
XTAP_TAPCELL_ROW_5_324 VGND VPWR sky130_fd_sc_hd__tapvpwrvgnd_1
X_4399_ _1873_ _2281_ VGND VGND VPWR VPWR _2287_ sky130_fd_sc_hd__nand2_4
X_6069_ clknet_leaf_61_clk _0477_ _0002_ VGND VGND VPWR VPWR reg_file_inst.registry\[15\]\[2\]
+ sky130_fd_sc_hd__dfrtp_1
XFILLER_73_559 VGND VGND VPWR VPWR sky130_fd_sc_hd__fill_1
XFILLER_60_209 VGND VGND VPWR VPWR sky130_fd_sc_hd__decap_4
XFILLER_26_453 VGND VGND VPWR VPWR sky130_fd_sc_hd__fill_1
XFILLER_81_592 VGND VGND VPWR VPWR sky130_fd_sc_hd__fill_1
XFILLER_14_637 VGND VGND VPWR VPWR sky130_fd_sc_hd__decap_6
XFILLER_41_401 VGND VGND VPWR VPWR sky130_fd_sc_hd__fill_2
XFILLER_5_302 VGND VGND VPWR VPWR sky130_fd_sc_hd__fill_2
XFILLER_68_309 VPWR VGND VPWR VGND sky130_ef_sc_hd__decap_12
XFILLER_3_15 VPWR VGND VPWR VGND sky130_ef_sc_hd__decap_12
XFILLER_1_541 VPWR VGND VPWR VGND sky130_ef_sc_hd__decap_12
XFILLER_122_277 VGND VGND VPWR VPWR sky130_fd_sc_hd__decap_3
XFILLER_1_585 VPWR VGND VPWR VGND sky130_ef_sc_hd__decap_12
XFILLER_76_331 VGND VGND VPWR VPWR sky130_fd_sc_hd__fill_2
XTAP_TAPCELL_ROW_108_1619 VGND VPWR sky130_fd_sc_hd__tapvpwrvgnd_1
XTAP_TAPCELL_ROW_108_1608 VGND VPWR sky130_fd_sc_hd__tapvpwrvgnd_1
XFILLER_76_353 VGND VGND VPWR VPWR sky130_fd_sc_hd__decap_8
XFILLER_91_345 VGND VGND VPWR VPWR sky130_fd_sc_hd__fill_2
XFILLER_64_537 VGND VGND VPWR VPWR sky130_fd_sc_hd__fill_1
XFILLER_91_378 VPWR VGND VPWR VGND sky130_ef_sc_hd__decap_12
XFILLER_60_721 VGND VGND VPWR VPWR sky130_fd_sc_hd__fill_2
XTAP_TAPCELL_ROW_80_1262 VGND VPWR sky130_fd_sc_hd__tapvpwrvgnd_1
XFILLER_13_670 VGND VGND VPWR VPWR sky130_fd_sc_hd__fill_2
X_3770_ MEMOFF\[6\] net97 _1113_ VGND VGND VPWR VPWR _1692_ sky130_fd_sc_hd__mux2_2
XFILLER_9_641 VPWR VGND VPWR VGND sky130_ef_sc_hd__decap_12
XTAP_TAPCELL_ROW_30_635 VGND VPWR sky130_fd_sc_hd__tapvpwrvgnd_1
XTAP_TAPCELL_ROW_119_1748 VGND VPWR sky130_fd_sc_hd__tapvpwrvgnd_1
X_5440_ _2311_ reg_file_inst.registry\[10\]\[7\] _2998_ VGND VGND VPWR VPWR _0622_
+ sky130_fd_sc_hd__mux2_1
XFILLER_9_685 VPWR VGND VPWR VGND sky130_ef_sc_hd__decap_12
XFILLER_66_3 VGND VGND VPWR VPWR sky130_fd_sc_hd__decap_8
XFILLER_8_184 VPWR VGND VPWR VGND sky130_ef_sc_hd__decap_12
XFILLER_114_701 VPWR VGND VPWR VGND sky130_ef_sc_hd__decap_12
X_5371_ MEMOFF\[18\] _2863_ _2996_ VGND VGND VPWR VPWR _0689_ sky130_fd_sc_hd__mux2_1
XTAP_TAPCELL_ROW_10_392 VGND VPWR sky130_fd_sc_hd__tapvpwrvgnd_1
X_4322_ _1469_ _2190_ VGND VGND VPWR VPWR _2210_ sky130_fd_sc_hd__and2_1
XFILLER_59_309 VPWR VGND VPWR VGND sky130_ef_sc_hd__decap_12
X_4253_ _1692_ _2138_ VGND VGND VPWR VPWR _2141_ sky130_fd_sc_hd__nor2_1
X_3204_ reg_file_inst.registry\[7\]\[27\] _1133_ _1140_ reg_file_inst.registry\[3\]\[27\]
+ _1143_ VGND VGND VPWR VPWR _1148_ sky130_fd_sc_hd__a221o_1
XFILLER_87_629 VPWR VGND VPWR VGND sky130_ef_sc_hd__decap_12
X_4184_ _1897_ _2085_ VGND VGND VPWR VPWR _2088_ sky130_fd_sc_hd__xnor2_1
XFILLER_95_673 VPWR VGND VPWR VGND sky130_ef_sc_hd__decap_12
XFILLER_67_353 VGND VGND VPWR VPWR sky130_fd_sc_hd__decap_6
XFILLER_55_515 VGND VGND VPWR VPWR sky130_fd_sc_hd__fill_2
X_3135_ _1077_ _1078_ VGND VGND VPWR VPWR _1079_ sky130_fd_sc_hd__and2_4
XFILLER_103_27 VPWR VGND VPWR VGND sky130_ef_sc_hd__decap_12
XFILLER_94_194 VGND VGND VPWR VPWR sky130_fd_sc_hd__fill_2
XFILLER_55_537 VPWR VGND VPWR VGND sky130_ef_sc_hd__decap_12
X_3066_ net33 _0961_ _0964_ JMPOFF\[0\] VGND VGND VPWR VPWR _1010_ sky130_fd_sc_hd__or4b_1
XTAP_TAPCELL_ROW_38_735 VGND VPWR sky130_fd_sc_hd__tapvpwrvgnd_1
XFILLER_23_423 VGND VGND VPWR VPWR sky130_fd_sc_hd__fill_1
XFILLER_35_261 VPWR VGND VPWR VGND sky130_ef_sc_hd__decap_12
XTAP_TAPCELL_ROW_18_492 VGND VPWR sky130_fd_sc_hd__tapvpwrvgnd_1
XFILLER_50_231 VPWR VGND VPWR VGND sky130_ef_sc_hd__decap_12
X_3968_ _1882_ _1883_ VGND VGND VPWR VPWR _1884_ sky130_fd_sc_hd__nand2b_1
XFILLER_11_629 VGND VGND VPWR VPWR sky130_fd_sc_hd__decap_4
X_5707_ net148 VGND VGND VPWR VPWR _0115_ sky130_fd_sc_hd__inv_2
XFILLER_50_286 VGND VGND VPWR VPWR sky130_fd_sc_hd__fill_1
XFILLER_109_517 VPWR VGND VPWR VGND sky130_ef_sc_hd__decap_12
X_3899_ _1810_ _1811_ _1815_ net138 reg_file_inst.registry\[0\]\[1\] VGND VGND VPWR
+ VPWR _1817_ sky130_fd_sc_hd__o32ai_4
X_5638_ net147 VGND VGND VPWR VPWR _0046_ sky130_fd_sc_hd__inv_2
XFILLER_117_561 VPWR VGND VPWR VGND sky130_ef_sc_hd__decap_12
X_5569_ reg_file_inst.registry\[15\]\[23\] _2806_ _3003_ VGND VGND VPWR VPWR _0498_
+ sky130_fd_sc_hd__mux2_1
XFILLER_2_338 VGND VGND VPWR VPWR sky130_fd_sc_hd__fill_1
XFILLER_2_349 VGND VGND VPWR VPWR sky130_fd_sc_hd__fill_1
XFILLER_92_109 VPWR VGND VPWR VGND sky130_ef_sc_hd__decap_12
XFILLER_73_301 VGND VGND VPWR VPWR sky130_fd_sc_hd__decap_8
XFILLER_18_206 VGND VGND VPWR VPWR sky130_fd_sc_hd__fill_1
XFILLER_73_345 VGND VGND VPWR VPWR sky130_fd_sc_hd__fill_1
XFILLER_73_389 VGND VGND VPWR VPWR sky130_fd_sc_hd__decap_3
XTAP_TAPCELL_ROW_103_1549 VGND VPWR sky130_fd_sc_hd__tapvpwrvgnd_1
XFILLER_53_42 VPWR VGND VPWR VGND sky130_ef_sc_hd__decap_12
XFILLER_14_456 VPWR VGND VPWR VGND sky130_ef_sc_hd__decap_12
XFILLER_53_75 VGND VGND VPWR VPWR sky130_fd_sc_hd__fill_1
XFILLER_14_489 VGND VGND VPWR VPWR sky130_fd_sc_hd__decap_6
XFILLER_5_121 VGND VGND VPWR VPWR sky130_fd_sc_hd__decap_3
XFILLER_6_699 VGND VGND VPWR VPWR sky130_fd_sc_hd__fill_1
XFILLER_5_198 VGND VGND VPWR VPWR sky130_fd_sc_hd__decap_8
XFILLER_5_176 VGND VGND VPWR VPWR sky130_fd_sc_hd__decap_6
XTAP_TAPCELL_ROW_114_1689 VGND VPWR sky130_fd_sc_hd__tapvpwrvgnd_1
XFILLER_78_72 VGND VGND VPWR VPWR sky130_fd_sc_hd__fill_1
XFILLER_68_106 VGND VGND VPWR VPWR sky130_fd_sc_hd__decap_3
XFILLER_49_342 VPWR VGND VPWR VGND sky130_ef_sc_hd__decap_12
XFILLER_77_673 VGND VGND VPWR VPWR sky130_fd_sc_hd__fill_1
XFILLER_92_643 VGND VGND VPWR VPWR sky130_fd_sc_hd__fill_1
XTAP_TAPCELL_ROW_69_1124 VGND VPWR sky130_fd_sc_hd__tapvpwrvgnd_1
XFILLER_37_526 VPWR VGND VPWR VGND sky130_ef_sc_hd__decap_12
XFILLER_94_82 VGND VGND VPWR VPWR sky130_fd_sc_hd__fill_2
XFILLER_24_209 VPWR VGND VPWR VGND sky130_ef_sc_hd__decap_12
XTAP_TAPCELL_ROW_35_705 VGND VPWR sky130_fd_sc_hd__tapvpwrvgnd_1
XFILLER_64_389 VGND VGND VPWR VPWR sky130_fd_sc_hd__decap_8
X_4940_ _2584_ _2790_ VGND VGND VPWR VPWR _2791_ sky130_fd_sc_hd__and2_1
XFILLER_17_261 VGND VGND VPWR VPWR sky130_fd_sc_hd__decap_8
XFILLER_45_570 VGND VGND VPWR VPWR sky130_fd_sc_hd__fill_1
X_4871_ _2726_ _2727_ net133 VGND VGND VPWR VPWR _2728_ sky130_fd_sc_hd__mux2_1
X_3822_ reg_file_inst.registry\[4\]\[5\] _1114_ _1132_ VGND VGND VPWR VPWR _1743_
+ sky130_fd_sc_hd__and3_1
XTAP_TAPCELL_ROW_15_451 VGND VPWR sky130_fd_sc_hd__tapvpwrvgnd_1
XFILLER_32_253 VPWR VGND VPWR VGND sky130_ef_sc_hd__decap_12
XFILLER_32_275 VPWR VGND VPWR VGND sky130_ef_sc_hd__decap_12
X_6541_ clknet_leaf_36_clk _0949_ _0474_ VGND VGND VPWR VPWR net121 sky130_fd_sc_hd__dfrtp_1
X_3753_ reg_file_inst.registry\[9\]\[6\] _1089_ _1090_ reg_file_inst.registry\[8\]\[6\]
+ VGND VGND VPWR VPWR _1676_ sky130_fd_sc_hd__a22o_1
X_6472_ clknet_leaf_43_clk _0880_ _0405_ VGND VGND VPWR VPWR reg_file_inst.registry\[7\]\[5\]
+ sky130_fd_sc_hd__dfrtp_1
XFILLER_9_493 VGND VGND VPWR VPWR sky130_fd_sc_hd__decap_8
X_3684_ MEMOFF\[8\] _1129_ _1138_ reg_file_inst.registry\[14\]\[8\] _1117_ VGND VGND
+ VPWR VPWR _1609_ sky130_fd_sc_hd__a221o_1
X_5423_ _2787_ reg_file_inst.registry\[10\]\[24\] _2998_ VGND VGND VPWR VPWR _0639_
+ sky130_fd_sc_hd__mux2_1
XFILLER_99_220 VGND VGND VPWR VPWR sky130_fd_sc_hd__decap_4
XTAP_TAPCELL_ROW_93_1431 VGND VPWR sky130_fd_sc_hd__tapvpwrvgnd_1
X_5354_ _2375_ reg_file_inst.registry\[3\]\[6\] _2995_ VGND VGND VPWR VPWR _0705_
+ sky130_fd_sc_hd__mux2_1
XFILLER_114_531 VGND VGND VPWR VPWR sky130_fd_sc_hd__fill_1
X_4305_ _1369_ _2190_ VGND VGND VPWR VPWR _2193_ sky130_fd_sc_hd__and2_1
X_5285_ _2873_ reg_file_inst.registry\[2\]\[17\] _2993_ VGND VGND VPWR VPWR _0772_
+ sky130_fd_sc_hd__mux2_1
XFILLER_114_15 VPWR VGND VPWR VGND sky130_ef_sc_hd__decap_12
XFILLER_101_225 VPWR VGND VPWR VGND sky130_ef_sc_hd__decap_12
X_4236_ _0960_ net42 _2115_ VGND VGND VPWR VPWR _2124_ sky130_fd_sc_hd__nand3_4
XFILLER_83_610 VGND VGND VPWR VPWR sky130_fd_sc_hd__decap_6
XFILLER_68_673 VGND VGND VPWR VPWR sky130_fd_sc_hd__fill_1
X_4167_ _2016_ _2075_ VGND VGND VPWR VPWR _2076_ sky130_fd_sc_hd__xnor2_1
XFILLER_95_470 VPWR VGND VPWR VGND sky130_ef_sc_hd__decap_12
XFILLER_67_161 VGND VGND VPWR VPWR sky130_fd_sc_hd__decap_6
X_3118_ _0991_ _1061_ VGND VGND VPWR VPWR _1062_ sky130_fd_sc_hd__or2_1
XFILLER_82_153 VGND VGND VPWR VPWR sky130_fd_sc_hd__decap_3
X_4098_ _1997_ _2001_ _1996_ VGND VGND VPWR VPWR _2014_ sky130_fd_sc_hd__a21oi_1
XFILLER_24_710 VPWR VGND VPWR VGND sky130_ef_sc_hd__decap_12
X_3049_ JMPOFF\[7\] net141 net41 VGND VGND VPWR VPWR _0993_ sky130_fd_sc_hd__a21o_1
XFILLER_82_197 VGND VGND VPWR VPWR sky130_fd_sc_hd__decap_4
XFILLER_11_415 VGND VGND VPWR VPWR sky130_fd_sc_hd__decap_3
XFILLER_23_264 VPWR VGND VPWR VGND sky130_ef_sc_hd__decap_12
XFILLER_23_45 VGND VGND VPWR VPWR sky130_fd_sc_hd__decap_8
XFILLER_7_408 VGND VGND VPWR VPWR sky130_fd_sc_hd__fill_1
XFILLER_99_27 VPWR VGND VPWR VGND sky130_ef_sc_hd__decap_12
XFILLER_117_391 VGND VGND VPWR VPWR sky130_fd_sc_hd__fill_1
XFILLER_105_553 VGND VGND VPWR VPWR sky130_fd_sc_hd__decap_6
XFILLER_120_501 VPWR VGND VPWR VGND sky130_ef_sc_hd__decap_12
XFILLER_105_597 VPWR VGND VPWR VGND sky130_ef_sc_hd__decap_12
XFILLER_120_545 VPWR VGND VPWR VGND sky130_ef_sc_hd__decap_12
XFILLER_120_589 VPWR VGND VPWR VGND sky130_ef_sc_hd__decap_12
XFILLER_93_429 VGND VGND VPWR VPWR sky130_fd_sc_hd__fill_1
XFILLER_59_662 VGND VGND VPWR VPWR sky130_fd_sc_hd__decap_3
XFILLER_58_183 VGND VGND VPWR VPWR sky130_fd_sc_hd__fill_1
XFILLER_46_312 VGND VGND VPWR VPWR sky130_fd_sc_hd__decap_6
XFILLER_64_63 VPWR VGND VPWR VGND sky130_ef_sc_hd__decap_12
XFILLER_15_721 VGND VGND VPWR VPWR sky130_fd_sc_hd__fill_2
XFILLER_64_85 VGND VGND VPWR VPWR sky130_fd_sc_hd__fill_1
XFILLER_61_337 VGND VGND VPWR VPWR sky130_fd_sc_hd__decap_4
XFILLER_14_220 VGND VGND VPWR VPWR sky130_fd_sc_hd__fill_1
XTAP_TAPCELL_ROW_64_1065 VGND VPWR sky130_fd_sc_hd__tapvpwrvgnd_1
XTAP_TAPCELL_ROW_12_410 VGND VPWR sky130_fd_sc_hd__tapvpwrvgnd_1
XTAP_TAPCELL_ROW_40_763 VGND VPWR sky130_fd_sc_hd__tapvpwrvgnd_1
XTAP_TAPCELL_ROW_116_1718 VGND VPWR sky130_fd_sc_hd__tapvpwrvgnd_1
XFILLER_115_317 VPWR VGND VPWR VGND sky130_ef_sc_hd__decap_12
XFILLER_89_82 VGND VGND VPWR VPWR sky130_fd_sc_hd__fill_1
X_5070_ _1504_ _1516_ _2285_ VGND VGND VPWR VPWR _2903_ sky130_fd_sc_hd__or3_1
X_4021_ _1933_ _1936_ VGND VGND VPWR VPWR _1937_ sky130_fd_sc_hd__or2_1
XFILLER_29_3 VGND VGND VPWR VPWR sky130_fd_sc_hd__decap_8
XFILLER_77_481 VGND VGND VPWR VPWR sky130_fd_sc_hd__fill_1
XFILLER_37_301 VGND VGND VPWR VPWR sky130_fd_sc_hd__decap_8
XFILLER_92_451 VGND VGND VPWR VPWR sky130_fd_sc_hd__fill_1
XFILLER_92_440 VGND VGND VPWR VPWR sky130_fd_sc_hd__decap_4
XFILLER_65_643 VGND VGND VPWR VPWR sky130_fd_sc_hd__fill_1
XTAP_TAPCELL_ROW_48_863 VGND VPWR sky130_fd_sc_hd__tapvpwrvgnd_1
XFILLER_92_495 VGND VGND VPWR VPWR sky130_fd_sc_hd__fill_1
XFILLER_65_687 VGND VGND VPWR VPWR sky130_fd_sc_hd__fill_1
X_5972_ net149 VGND VGND VPWR VPWR _0380_ sky130_fd_sc_hd__inv_2
XFILLER_64_197 VGND VGND VPWR VPWR sky130_fd_sc_hd__decap_6
XFILLER_52_359 VGND VGND VPWR VPWR sky130_fd_sc_hd__decap_4
X_4923_ _2723_ _2742_ _1816_ VGND VGND VPWR VPWR _2776_ sky130_fd_sc_hd__mux2_1
XFILLER_33_573 VGND VGND VPWR VPWR sky130_fd_sc_hd__decap_8
X_4854_ _2279_ _2697_ _2710_ _2711_ _2703_ VGND VGND VPWR VPWR _2713_ sky130_fd_sc_hd__a221o_1
X_3805_ MEMOFF\[5\] _1077_ _1078_ VGND VGND VPWR VPWR _1726_ sky130_fd_sc_hd__and3_1
X_4785_ _2642_ _2643_ VGND VGND VPWR VPWR _2644_ sky130_fd_sc_hd__or2_1
X_3736_ reg_file_inst.registry\[10\]\[7\] _1123_ _1125_ VGND VGND VPWR VPWR _1660_
+ sky130_fd_sc_hd__and3_1
X_6524_ clknet_leaf_52_clk _0932_ _0457_ VGND VGND VPWR VPWR net103 sky130_fd_sc_hd__dfrtp_1
XFILLER_118_133 VGND VGND VPWR VPWR sky130_fd_sc_hd__decap_6
XFILLER_109_15 VPWR VGND VPWR VGND sky130_ef_sc_hd__decap_12
XFILLER_118_177 VPWR VGND VPWR VGND sky130_ef_sc_hd__decap_12
X_6455_ clknet_leaf_15_clk _0863_ _0388_ VGND VGND VPWR VPWR reg_file_inst.registry\[0\]\[16\]
+ sky130_fd_sc_hd__dfrtp_1
X_3667_ reg_file_inst.registry\[6\]\[9\] _1135_ _1590_ _1591_ _1592_ VGND VGND VPWR
+ VPWR _1593_ sky130_fd_sc_hd__a2111o_1
X_5406_ reg_file_inst.registry\[4\]\[12\] _2934_ _2997_ VGND VGND VPWR VPWR _0655_
+ sky130_fd_sc_hd__mux2_1
X_6386_ clknet_leaf_62_clk _0794_ _0319_ VGND VGND VPWR VPWR reg_file_inst.registry\[14\]\[11\]
+ sky130_fd_sc_hd__dfrtp_1
X_3598_ reg_file_inst.registry\[15\]\[11\] _1093_ _1097_ reg_file_inst.registry\[5\]\[11\]
+ VGND VGND VPWR VPWR _1526_ sky130_fd_sc_hd__a22o_1
X_5337_ _2806_ reg_file_inst.registry\[3\]\[23\] _2995_ VGND VGND VPWR VPWR _0722_
+ sky130_fd_sc_hd__mux2_1
XFILLER_88_713 VGND VGND VPWR VPWR sky130_fd_sc_hd__decap_6
XFILLER_0_617 VGND VGND VPWR VPWR sky130_fd_sc_hd__fill_2
XFILLER_102_545 VPWR VGND VPWR VGND sky130_ef_sc_hd__decap_12
XFILLER_87_234 VGND VGND VPWR VPWR sky130_fd_sc_hd__decap_6
X_5268_ reg_file_inst.registry\[14\]\[5\] _2419_ _2992_ VGND VGND VPWR VPWR _0788_
+ sky130_fd_sc_hd__mux2_1
XFILLER_102_589 VPWR VGND VPWR VGND sky130_ef_sc_hd__decap_12
X_4219_ _1958_ _1960_ VGND VGND VPWR VPWR _2110_ sky130_fd_sc_hd__xnor2_1
X_5199_ _2375_ reg_file_inst.registry\[0\]\[6\] _2988_ VGND VGND VPWR VPWR _0853_
+ sky130_fd_sc_hd__mux2_1
XFILLER_56_643 VGND VGND VPWR VPWR sky130_fd_sc_hd__fill_1
XFILLER_71_602 VGND VGND VPWR VPWR sky130_fd_sc_hd__fill_1
XFILLER_43_337 VGND VGND VPWR VPWR sky130_fd_sc_hd__fill_2
XFILLER_43_348 VGND VGND VPWR VPWR sky130_fd_sc_hd__decap_6
XTAP_TAPCELL_ROW_100_1508 VGND VPWR sky130_fd_sc_hd__tapvpwrvgnd_1
XFILLER_70_178 VGND VGND VPWR VPWR sky130_fd_sc_hd__decap_4
XFILLER_34_55 VGND VGND VPWR VPWR sky130_fd_sc_hd__fill_1
XTAP_TAPCELL_ROW_100_1519 VGND VPWR sky130_fd_sc_hd__tapvpwrvgnd_1
XFILLER_11_201 VPWR VGND VPWR VGND sky130_ef_sc_hd__decap_12
XFILLER_24_584 VGND VGND VPWR VPWR sky130_fd_sc_hd__decap_4
XFILLER_11_256 VGND VGND VPWR VPWR sky130_fd_sc_hd__fill_1
XFILLER_109_111 VGND VGND VPWR VPWR sky130_fd_sc_hd__fill_1
XFILLER_3_400 VGND VGND VPWR VPWR sky130_fd_sc_hd__fill_1
XFILLER_112_309 VPWR VGND VPWR VGND sky130_ef_sc_hd__decap_12
XTAP_TAPCELL_ROW_111_1648 VGND VPWR sky130_fd_sc_hd__tapvpwrvgnd_1
XFILLER_93_204 VPWR VGND VPWR VGND sky130_ef_sc_hd__decap_12
XFILLER_47_610 VGND VGND VPWR VPWR sky130_fd_sc_hd__decap_6
XFILLER_46_120 VGND VGND VPWR VPWR sky130_fd_sc_hd__decap_8
XTAP_TAPCELL_ROW_45_822 VGND VPWR sky130_fd_sc_hd__tapvpwrvgnd_1
XFILLER_46_197 VPWR VGND VPWR VGND sky130_ef_sc_hd__decap_12
XFILLER_62_679 VGND VGND VPWR VPWR sky130_fd_sc_hd__fill_2
XFILLER_61_178 VPWR VGND VPWR VGND sky130_ef_sc_hd__decap_12
XFILLER_15_551 VGND VGND VPWR VPWR sky130_fd_sc_hd__decap_8
XTAP_TAPCELL_ROW_122_1799 VGND VPWR sky130_fd_sc_hd__tapvpwrvgnd_1
XTAP_TAPCELL_ROW_122_1788 VGND VPWR sky130_fd_sc_hd__tapvpwrvgnd_1
XFILLER_91_72 VGND VGND VPWR VPWR sky130_fd_sc_hd__decap_8
X_4570_ _2431_ _2450_ _1790_ VGND VGND VPWR VPWR _2451_ sky130_fd_sc_hd__mux2_1
XFILLER_30_576 VPWR VGND VPWR VGND sky130_ef_sc_hd__decap_12
X_3521_ MEMOFF\[13\] _1079_ _1096_ reg_file_inst.registry\[11\]\[13\] VGND VGND VPWR
+ VPWR _1452_ sky130_fd_sc_hd__a22o_1
XFILLER_116_637 VGND VGND VPWR VPWR sky130_fd_sc_hd__decap_6
XTAP_TAPCELL_ROW_77_1223 VGND VPWR sky130_fd_sc_hd__tapvpwrvgnd_1
XFILLER_115_125 VPWR VGND VPWR VGND sky130_ef_sc_hd__decap_12
X_3452_ reg_file_inst.registry\[15\]\[16\] _1122_ _1130_ JMPOFF\[16\] _1385_ VGND
+ VGND VPWR VPWR _1386_ sky130_fd_sc_hd__a221o_1
X_6240_ clknet_leaf_41_clk _0648_ _0173_ VGND VGND VPWR VPWR reg_file_inst.registry\[4\]\[5\]
+ sky130_fd_sc_hd__dfrtp_1
XFILLER_115_169 VPWR VGND VPWR VGND sky130_ef_sc_hd__decap_12
X_3383_ reg_file_inst.registry\[0\]\[20\] _1118_ _1316_ _1319_ VGND VGND VPWR VPWR
+ net85 sky130_fd_sc_hd__o22a_2
X_6171_ clknet_leaf_41_clk _0579_ _0104_ VGND VGND VPWR VPWR JMPOFF\[20\] sky130_fd_sc_hd__dfrtp_4
X_5122_ net3 net101 net47 _2308_ VGND VGND VPWR VPWR _2948_ sky130_fd_sc_hd__a22o_4
XFILLER_97_576 VPWR VGND VPWR VGND sky130_ef_sc_hd__decap_12
X_5053_ _1493_ _2286_ _2124_ _1480_ VGND VGND VPWR VPWR _2888_ sky130_fd_sc_hd__o2bb2a_1
X_4004_ net104 _1918_ VGND VGND VPWR VPWR _1920_ sky130_fd_sc_hd__xor2_1
XTAP_TAPCELL_ROW_88_1363 VGND VPWR sky130_fd_sc_hd__tapvpwrvgnd_1
XFILLER_1_81 VGND VGND VPWR VPWR sky130_fd_sc_hd__decap_6
XFILLER_25_315 VPWR VGND VPWR VGND sky130_ef_sc_hd__decap_12
XFILLER_37_153 VGND VGND VPWR VPWR sky130_fd_sc_hd__fill_1
XFILLER_111_27 VPWR VGND VPWR VGND sky130_ef_sc_hd__decap_12
XFILLER_80_421 VGND VGND VPWR VPWR sky130_fd_sc_hd__decap_8
X_5955_ net44 VGND VGND VPWR VPWR _0363_ sky130_fd_sc_hd__inv_2
XFILLER_40_307 VGND VGND VPWR VPWR sky130_fd_sc_hd__fill_1
X_5886_ net147 VGND VGND VPWR VPWR _0294_ sky130_fd_sc_hd__inv_2
X_4906_ _2757_ _2760_ _1765_ VGND VGND VPWR VPWR _2761_ sky130_fd_sc_hd__mux2_1
X_4837_ _2694_ _2695_ _1817_ VGND VGND VPWR VPWR _2696_ sky130_fd_sc_hd__mux2_1
XTAP_TAPCELL_ROW_23_549 VGND VPWR sky130_fd_sc_hd__tapvpwrvgnd_1
XFILLER_21_576 VGND VGND VPWR VPWR sky130_fd_sc_hd__decap_4
XFILLER_5_709 VPWR VGND VPWR VGND sky130_ef_sc_hd__decap_12
X_4768_ _2612_ _2616_ _2626_ _2613_ VGND VGND VPWR VPWR _2627_ sky130_fd_sc_hd__o211a_1
XFILLER_119_497 VGND VGND VPWR VPWR sky130_fd_sc_hd__decap_6
XFILLER_107_615 VGND VGND VPWR VPWR sky130_fd_sc_hd__fill_1
X_3719_ reg_file_inst.registry\[3\]\[7\] _1082_ _1085_ VGND VGND VPWR VPWR _1643_
+ sky130_fd_sc_hd__and3_1
X_4699_ _1480_ _2126_ _2557_ VGND VGND VPWR VPWR _2558_ sky130_fd_sc_hd__o21a_1
X_6507_ clknet_leaf_57_clk _0915_ _0440_ VGND VGND VPWR VPWR reg_file_inst.registry\[11\]\[0\]
+ sky130_fd_sc_hd__dfrtp_1
X_6438_ clknet_leaf_30_clk _0846_ _0371_ VGND VGND VPWR VPWR reg_file_inst.registry\[11\]\[23\]
+ sky130_fd_sc_hd__dfrtp_1
X_6369_ clknet_leaf_35_clk _0777_ _0302_ VGND VGND VPWR VPWR reg_file_inst.registry\[2\]\[22\]
+ sky130_fd_sc_hd__dfrtp_1
XFILLER_0_414 VGND VGND VPWR VPWR sky130_fd_sc_hd__decap_6
XFILLER_88_576 VPWR VGND VPWR VGND sky130_ef_sc_hd__decap_12
XFILLER_29_44 VPWR VGND VPWR VGND sky130_ef_sc_hd__decap_12
XFILLER_102_397 VGND VGND VPWR VPWR sky130_fd_sc_hd__decap_3
XFILLER_75_237 VPWR VGND VPWR VGND sky130_ef_sc_hd__decap_12
XFILLER_75_215 VGND VGND VPWR VPWR sky130_fd_sc_hd__decap_8
XFILLER_29_665 VGND VGND VPWR VPWR sky130_fd_sc_hd__decap_6
XTAP_TAPCELL_ROW_3_296 VGND VPWR sky130_fd_sc_hd__tapvpwrvgnd_1
XFILLER_45_21 VGND VGND VPWR VPWR sky130_fd_sc_hd__fill_2
XFILLER_71_443 VGND VGND VPWR VPWR sky130_fd_sc_hd__decap_4
XFILLER_28_197 VGND VGND VPWR VPWR sky130_fd_sc_hd__decap_6
XFILLER_44_657 VPWR VGND VPWR VGND sky130_ef_sc_hd__decap_12
XFILLER_45_43 VGND VGND VPWR VPWR sky130_fd_sc_hd__decap_8
XTAP_TAPCELL_ROW_61_1024 VGND VPWR sky130_fd_sc_hd__tapvpwrvgnd_1
XFILLER_61_42 VGND VGND VPWR VPWR sky130_fd_sc_hd__fill_1
XFILLER_12_576 VPWR VGND VPWR VGND sky130_ef_sc_hd__decap_12
XFILLER_8_569 VPWR VGND VPWR VGND sky130_ef_sc_hd__decap_12
XFILLER_6_15 VPWR VGND VPWR VGND sky130_ef_sc_hd__decap_12
XTAP_TAPCELL_ROW_50_891 VGND VPWR sky130_fd_sc_hd__tapvpwrvgnd_1
XANTENNA_8 _1131_ VGND VGND VPWR VPWR sky130_fd_sc_hd__diode_2
XFILLER_113_629 VPWR VGND VPWR VGND sky130_ef_sc_hd__decap_12
XFILLER_112_139 VGND VGND VPWR VPWR sky130_fd_sc_hd__fill_1
XFILLER_106_681 VPWR VGND VPWR VGND sky130_ef_sc_hd__decap_12
XFILLER_3_296 VPWR VGND VPWR VGND sky130_ef_sc_hd__decap_12
XTAP_TAPCELL_ROW_72_1164 VGND VPWR sky130_fd_sc_hd__tapvpwrvgnd_1
XFILLER_121_673 VPWR VGND VPWR VGND sky130_ef_sc_hd__decap_12
XFILLER_94_513 VGND VGND VPWR VPWR sky130_fd_sc_hd__decap_3
XFILLER_86_83 VGND VGND VPWR VPWR sky130_fd_sc_hd__fill_1
XFILLER_86_50 VGND VGND VPWR VPWR sky130_fd_sc_hd__decap_8
XFILLER_19_120 VGND VGND VPWR VPWR sky130_fd_sc_hd__decap_3
XFILLER_81_218 VGND VGND VPWR VPWR sky130_fd_sc_hd__decap_3
XFILLER_19_164 VGND VGND VPWR VPWR sky130_fd_sc_hd__fill_1
XFILLER_47_473 VPWR VGND VPWR VGND sky130_ef_sc_hd__decap_12
XFILLER_62_421 VGND VGND VPWR VPWR sky130_fd_sc_hd__decap_3
XTAP_TAPCELL_ROW_58_991 VGND VPWR sky130_fd_sc_hd__tapvpwrvgnd_1
XFILLER_22_307 VGND VGND VPWR VPWR sky130_fd_sc_hd__fill_1
XFILLER_15_370 VGND VGND VPWR VPWR sky130_fd_sc_hd__decap_3
X_5740_ net146 VGND VGND VPWR VPWR _0148_ sky130_fd_sc_hd__inv_2
X_5671_ net146 VGND VGND VPWR VPWR _0079_ sky130_fd_sc_hd__inv_2
XTAP_TAPCELL_ROW_20_508 VGND VPWR sky130_fd_sc_hd__tapvpwrvgnd_1
XTAP_TAPCELL_ROW_20_519 VGND VPWR sky130_fd_sc_hd__tapvpwrvgnd_1
X_4622_ _1709_ _2498_ _2484_ _2295_ VGND VGND VPWR VPWR _2499_ sky130_fd_sc_hd__o211a_1
XFILLER_116_401 VPWR VGND VPWR VGND sky130_ef_sc_hd__decap_12
X_4553_ _2301_ _2433_ _2297_ VGND VGND VPWR VPWR _2434_ sky130_fd_sc_hd__o21a_1
XFILLER_116_445 VPWR VGND VPWR VGND sky130_ef_sc_hd__decap_12
X_3504_ reg_file_inst.registry\[3\]\[12\] net145 _1119_ VGND VGND VPWR VPWR _1436_
+ sky130_fd_sc_hd__and3_1
X_4484_ _1790_ _2368_ _2191_ VGND VGND VPWR VPWR _2369_ sky130_fd_sc_hd__a21o_1
XFILLER_116_489 VPWR VGND VPWR VGND sky130_ef_sc_hd__decap_12
X_6223_ clknet_leaf_17_clk _0631_ _0156_ VGND VGND VPWR VPWR reg_file_inst.registry\[10\]\[16\]
+ sky130_fd_sc_hd__dfrtp_1
X_3435_ MEMOFF\[18\] net82 _1113_ VGND VGND VPWR VPWR _1369_ sky130_fd_sc_hd__mux2_4
XFILLER_106_27 VGND VGND VPWR VPWR sky130_fd_sc_hd__fill_1
X_3366_ reg_file_inst.registry\[14\]\[20\] _1081_ _1098_ reg_file_inst.registry\[10\]\[20\]
+ _1302_ VGND VGND VPWR VPWR _1303_ sky130_fd_sc_hd__a221o_1
X_6154_ clknet_leaf_55_clk _0562_ _0087_ VGND VGND VPWR VPWR JMPOFF\[3\] sky130_fd_sc_hd__dfrtp_4
XFILLER_111_161 VGND VGND VPWR VPWR sky130_fd_sc_hd__decap_6
X_3297_ reg_file_inst.registry\[15\]\[23\] _1122_ _1129_ MEMOFF\[23\] _1236_ VGND
+ VGND VPWR VPWR _1237_ sky130_fd_sc_hd__a221o_1
X_6085_ clknet_leaf_14_clk _0493_ _0018_ VGND VGND VPWR VPWR reg_file_inst.registry\[15\]\[18\]
+ sky130_fd_sc_hd__dfrtp_1
X_5105_ _2176_ _2633_ _2923_ _2928_ _2933_ VGND VGND VPWR VPWR net48 sky130_fd_sc_hd__a311o_1
X_5036_ reg_file_inst.registry\[7\]\[17\] _2873_ _2553_ VGND VGND VPWR VPWR _0892_
+ sky130_fd_sc_hd__mux2_1
XFILLER_122_15 VPWR VGND VPWR VGND sky130_ef_sc_hd__decap_12
XFILLER_26_613 VGND VGND VPWR VPWR sky130_fd_sc_hd__decap_6
XTAP_TAPCELL_ROW_28_608 VGND VPWR sky130_fd_sc_hd__tapvpwrvgnd_1
XTAP_TAPCELL_ROW_28_619 VGND VPWR sky130_fd_sc_hd__tapvpwrvgnd_1
XPHY_EDGE_ROW_69_Left_192 VGND VGND VPWR VPWR sky130_fd_sc_hd__decap_3
XFILLER_65_281 VPWR VGND VPWR VGND sky130_ef_sc_hd__decap_12
XFILLER_26_657 VGND VGND VPWR VPWR sky130_fd_sc_hd__decap_6
XTAP_TAPCELL_ROW_0_255 VGND VPWR sky130_fd_sc_hd__tapvpwrvgnd_1
XTAP_TAPCELL_ROW_0_266 VGND VPWR sky130_fd_sc_hd__tapvpwrvgnd_1
X_5938_ net148 VGND VGND VPWR VPWR _0346_ sky130_fd_sc_hd__inv_2
XFILLER_40_115 VGND VGND VPWR VPWR sky130_fd_sc_hd__decap_4
XFILLER_41_649 VGND VGND VPWR VPWR sky130_fd_sc_hd__fill_1
X_5869_ net44 VGND VGND VPWR VPWR _0277_ sky130_fd_sc_hd__inv_2
XFILLER_21_340 VPWR VGND VPWR VGND sky130_ef_sc_hd__decap_12
XFILLER_119_261 VPWR VGND VPWR VGND sky130_ef_sc_hd__decap_12
XFILLER_5_517 VPWR VGND VPWR VGND sky130_ef_sc_hd__decap_12
XFILLER_31_78 VGND VGND VPWR VPWR sky130_fd_sc_hd__decap_4
Xoutput67 net67 VGND VGND VPWR VPWR DataAddress[4] sky130_fd_sc_hd__buf_1
Xoutput56 net56 VGND VGND VPWR VPWR DataAddress[1] sky130_fd_sc_hd__buf_1
Xoutput45 net45 VGND VGND VPWR VPWR DataAddress[0] sky130_fd_sc_hd__buf_1
Xoutput89 net89 VGND VGND VPWR VPWR DataMemoryWrite[24] sky130_fd_sc_hd__buf_1
Xoutput78 net78 VGND VGND VPWR VPWR DataMemoryWrite[14] sky130_fd_sc_hd__buf_1
XTAP_TAPCELL_ROW_8_366 VGND VPWR sky130_fd_sc_hd__tapvpwrvgnd_1
XFILLER_103_673 VPWR VGND VPWR VGND sky130_ef_sc_hd__decap_12
XFILLER_88_362 VGND VGND VPWR VPWR sky130_fd_sc_hd__fill_2
XFILLER_48_215 VGND VGND VPWR VPWR sky130_fd_sc_hd__fill_2
XFILLER_102_194 VGND VGND VPWR VPWR sky130_fd_sc_hd__fill_2
XFILLER_91_505 VPWR VGND VPWR VGND sky130_ef_sc_hd__decap_12
XFILLER_64_719 VGND VGND VPWR VPWR sky130_fd_sc_hd__decap_4
XFILLER_17_646 VPWR VGND VPWR VGND sky130_ef_sc_hd__decap_12
XPHY_EDGE_ROW_113_Right_113 VGND VGND VPWR VPWR sky130_fd_sc_hd__decap_3
XTAP_TAPCELL_ROW_55_950 VGND VPWR sky130_fd_sc_hd__tapvpwrvgnd_1
XFILLER_71_273 VGND VGND VPWR VPWR sky130_fd_sc_hd__decap_6
XFILLER_16_178 VGND VGND VPWR VPWR sky130_fd_sc_hd__decap_3
XFILLER_8_344 VGND VGND VPWR VPWR sky130_fd_sc_hd__decap_8
XFILLER_12_373 VGND VGND VPWR VPWR sky130_fd_sc_hd__fill_2
XFILLER_8_388 VGND VGND VPWR VPWR sky130_fd_sc_hd__decap_6
XFILLER_8_399 VGND VGND VPWR VPWR sky130_fd_sc_hd__fill_2
XFILLER_97_71 VGND VGND VPWR VPWR sky130_fd_sc_hd__decap_4
X_3220_ reg_file_inst.registry\[14\]\[26\] _1138_ _1139_ reg_file_inst.registry\[5\]\[26\]
+ VGND VGND VPWR VPWR _1163_ sky130_fd_sc_hd__a22o_1
XFILLER_39_215 VGND VGND VPWR VPWR sky130_fd_sc_hd__decap_8
X_3151_ _1074_ _1077_ VGND VGND VPWR VPWR _1095_ sky130_fd_sc_hd__and2_4
XFILLER_94_321 VGND VGND VPWR VPWR sky130_fd_sc_hd__decap_3
XFILLER_11_3 VPWR VGND VPWR VGND sky130_ef_sc_hd__decap_12
XFILLER_94_365 VGND VGND VPWR VPWR sky130_fd_sc_hd__decap_4
XFILLER_82_527 VGND VGND VPWR VPWR sky130_fd_sc_hd__decap_4
X_3082_ JMPOFF\[8\] net141 net41 VGND VGND VPWR VPWR _1026_ sky130_fd_sc_hd__a21o_1
XFILLER_94_398 VPWR VGND VPWR VGND sky130_ef_sc_hd__decap_12
XTAP_TAPCELL_ROW_85_1322 VGND VPWR sky130_fd_sc_hd__tapvpwrvgnd_1
XFILLER_47_281 VPWR VGND VPWR VGND sky130_ef_sc_hd__decap_12
XFILLER_35_498 VGND VGND VPWR VPWR sky130_fd_sc_hd__decap_6
XFILLER_50_402 VPWR VGND VPWR VGND sky130_ef_sc_hd__decap_12
XFILLER_22_126 VPWR VGND VPWR VGND sky130_ef_sc_hd__decap_12
X_3984_ net107 net131 _1898_ _1899_ VGND VGND VPWR VPWR _1900_ sky130_fd_sc_hd__and4_1
XFILLER_50_457 VPWR VGND VPWR VGND sky130_ef_sc_hd__decap_12
X_5723_ net147 VGND VGND VPWR VPWR _0131_ sky130_fd_sc_hd__inv_2
XFILLER_31_671 VGND VGND VPWR VPWR sky130_fd_sc_hd__fill_1
XTAP_TAPCELL_ROW_33_677 VGND VPWR sky130_fd_sc_hd__tapvpwrvgnd_1
X_5654_ net148 VGND VGND VPWR VPWR _0062_ sky130_fd_sc_hd__inv_2
XFILLER_117_721 VGND VGND VPWR VPWR sky130_fd_sc_hd__decap_4
XFILLER_108_209 VPWR VGND VPWR VGND sky130_ef_sc_hd__decap_12
X_4605_ _2334_ _2346_ _1790_ VGND VGND VPWR VPWR _2482_ sky130_fd_sc_hd__mux2_1
XTAP_TAPCELL_ROW_96_1462 VGND VPWR sky130_fd_sc_hd__tapvpwrvgnd_1
X_5585_ reg_file_inst.registry\[15\]\[7\] _2311_ _3003_ VGND VGND VPWR VPWR _0482_
+ sky130_fd_sc_hd__mux2_1
XFILLER_117_15 VPWR VGND VPWR VGND sky130_ef_sc_hd__decap_12
XFILLER_116_253 VPWR VGND VPWR VGND sky130_ef_sc_hd__decap_12
X_4536_ net39 _2117_ net101 net24 VGND VGND VPWR VPWR _2418_ sky130_fd_sc_hd__a22o_1
XFILLER_89_137 VGND VGND VPWR VPWR sky130_fd_sc_hd__decap_4
X_4467_ _1764_ _2347_ _2351_ _1708_ VGND VGND VPWR VPWR _2352_ sky130_fd_sc_hd__a211o_1
XFILLER_104_459 VPWR VGND VPWR VGND sky130_ef_sc_hd__decap_12
X_6206_ clknet_leaf_18_clk _0614_ _0139_ VGND VGND VPWR VPWR reg_file_inst.registry\[5\]\[27\]
+ sky130_fd_sc_hd__dfrtp_1
X_3418_ reg_file_inst.registry\[4\]\[18\] _1092_ _1094_ reg_file_inst.registry\[6\]\[18\]
+ _1352_ VGND VGND VPWR VPWR _1353_ sky130_fd_sc_hd__a221o_1
X_4398_ _1873_ _2281_ VGND VGND VPWR VPWR _2286_ sky130_fd_sc_hd__and2_4
XFILLER_98_693 VGND VGND VPWR VPWR sky130_fd_sc_hd__decap_6
X_3349_ reg_file_inst.registry\[11\]\[21\] _1119_ _1125_ VGND VGND VPWR VPWR _1287_
+ sky130_fd_sc_hd__and3_1
X_6137_ clknet_leaf_12_clk _0545_ _0070_ VGND VGND VPWR VPWR reg_file_inst.registry\[6\]\[14\]
+ sky130_fd_sc_hd__dfrtp_1
XTAP_TAPCELL_ROW_5_325 VGND VPWR sky130_fd_sc_hd__tapvpwrvgnd_1
XFILLER_100_643 VGND VGND VPWR VPWR sky130_fd_sc_hd__fill_1
XFILLER_97_181 VPWR VGND VPWR VGND sky130_ef_sc_hd__decap_12
XPHY_EDGE_ROW_77_Left_200 VGND VGND VPWR VPWR sky130_fd_sc_hd__decap_3
XFILLER_73_505 VGND VGND VPWR VPWR sky130_fd_sc_hd__fill_2
X_6068_ clknet_leaf_57_clk _0476_ _0001_ VGND VGND VPWR VPWR reg_file_inst.registry\[15\]\[1\]
+ sky130_fd_sc_hd__dfrtp_1
X_5019_ _2494_ _2802_ _2859_ VGND VGND VPWR VPWR _2860_ sky130_fd_sc_hd__o21ai_1
XFILLER_26_23 VGND VGND VPWR VPWR sky130_fd_sc_hd__decap_4
XFILLER_26_421 VGND VGND VPWR VPWR sky130_fd_sc_hd__decap_8
XFILLER_26_410 VGND VGND VPWR VPWR sky130_fd_sc_hd__decap_3
XTAP_TAPCELL_ROW_52_920 VGND VPWR sky130_fd_sc_hd__tapvpwrvgnd_1
XTAP_TAPCELL_ROW_105_1580 VGND VPWR sky130_fd_sc_hd__tapvpwrvgnd_1
XFILLER_41_468 VPWR VGND VPWR VGND sky130_ef_sc_hd__decap_12
XFILLER_42_33 VGND VGND VPWR VPWR sky130_fd_sc_hd__fill_1
XFILLER_21_181 VGND VGND VPWR VPWR sky130_fd_sc_hd__decap_8
XFILLER_5_325 VGND VGND VPWR VPWR sky130_fd_sc_hd__decap_8
XFILLER_3_27 VPWR VGND VPWR VGND sky130_ef_sc_hd__decap_12
XFILLER_1_553 VGND VGND VPWR VPWR sky130_fd_sc_hd__decap_6
XFILLER_107_81 VPWR VGND VPWR VGND sky130_ef_sc_hd__decap_12
XFILLER_89_671 VGND VGND VPWR VPWR sky130_fd_sc_hd__fill_1
XFILLER_1_597 VPWR VGND VPWR VGND sky130_ef_sc_hd__decap_12
XTAP_TAPCELL_ROW_108_1609 VGND VPWR sky130_fd_sc_hd__tapvpwrvgnd_1
XFILLER_76_365 VPWR VGND VPWR VGND sky130_ef_sc_hd__decap_12
XFILLER_29_270 VGND VGND VPWR VPWR sky130_fd_sc_hd__decap_3
XFILLER_83_40 VGND VGND VPWR VPWR sky130_fd_sc_hd__decap_6
XFILLER_17_498 VGND VGND VPWR VPWR sky130_fd_sc_hd__decap_6
XTAP_TAPCELL_ROW_67_1096 VGND VPWR sky130_fd_sc_hd__tapvpwrvgnd_1
XTAP_TAPCELL_ROW_80_1263 VGND VPWR sky130_fd_sc_hd__tapvpwrvgnd_1
XFILLER_80_6 VGND VGND VPWR VPWR sky130_fd_sc_hd__decap_8
XFILLER_12_170 VGND VGND VPWR VPWR sky130_fd_sc_hd__decap_8
XFILLER_9_653 VPWR VGND VPWR VGND sky130_ef_sc_hd__decap_12
XTAP_TAPCELL_ROW_30_636 VGND VPWR sky130_fd_sc_hd__tapvpwrvgnd_1
XTAP_TAPCELL_ROW_119_1749 VGND VPWR sky130_fd_sc_hd__tapvpwrvgnd_1
XFILLER_9_697 VPWR VGND VPWR VGND sky130_ef_sc_hd__decap_12
XFILLER_114_713 VPWR VGND VPWR VGND sky130_ef_sc_hd__decap_12
X_5370_ MEMOFF\[19\] _2854_ _2996_ VGND VGND VPWR VPWR _0690_ sky130_fd_sc_hd__mux2_1
XTAP_TAPCELL_ROW_10_393 VGND VPWR sky130_fd_sc_hd__tapvpwrvgnd_1
XFILLER_113_223 VGND VGND VPWR VPWR sky130_fd_sc_hd__fill_1
XFILLER_99_413 VGND VGND VPWR VPWR sky130_fd_sc_hd__fill_2
X_4321_ _1515_ _2190_ net132 VGND VGND VPWR VPWR _2209_ sky130_fd_sc_hd__a21oi_1
XFILLER_99_446 VGND VGND VPWR VPWR sky130_fd_sc_hd__fill_2
X_4252_ _2139_ VGND VGND VPWR VPWR _2140_ sky130_fd_sc_hd__inv_2
X_3203_ reg_file_inst.registry\[9\]\[27\] _1131_ _1135_ reg_file_inst.registry\[6\]\[27\]
+ VGND VGND VPWR VPWR _1147_ sky130_fd_sc_hd__a22o_1
XFILLER_95_641 VPWR VGND VPWR VGND sky130_ef_sc_hd__decap_12
X_4183_ _2087_ net109 net130 VGND VGND VPWR VPWR _0938_ sky130_fd_sc_hd__mux2_1
XFILLER_95_685 VPWR VGND VPWR VGND sky130_ef_sc_hd__decap_12
X_3134_ net34 net39 net38 VGND VGND VPWR VPWR _1078_ sky130_fd_sc_hd__nor3b_4
XFILLER_103_39 VPWR VGND VPWR VGND sky130_ef_sc_hd__decap_12
XFILLER_55_549 VGND VGND VPWR VPWR sky130_fd_sc_hd__decap_8
X_3065_ JMPOFF\[1\] _0966_ net35 VGND VGND VPWR VPWR _1009_ sky130_fd_sc_hd__a21o_1
XTAP_TAPCELL_ROW_38_736 VGND VPWR sky130_fd_sc_hd__tapvpwrvgnd_1
XFILLER_35_273 VGND VGND VPWR VPWR sky130_fd_sc_hd__decap_6
XTAP_TAPCELL_ROW_18_493 VGND VPWR sky130_fd_sc_hd__tapvpwrvgnd_1
XFILLER_50_210 VGND VGND VPWR VPWR sky130_fd_sc_hd__fill_1
X_3967_ _1072_ net131 _1881_ net119 VGND VGND VPWR VPWR _1883_ sky130_fd_sc_hd__a31o_1
XFILLER_50_243 VGND VGND VPWR VPWR sky130_fd_sc_hd__decap_8
XFILLER_10_129 VGND VGND VPWR VPWR sky130_fd_sc_hd__decap_8
X_5706_ net147 VGND VGND VPWR VPWR _0114_ sky130_fd_sc_hd__inv_2
XFILLER_109_529 VPWR VGND VPWR VGND sky130_ef_sc_hd__decap_12
Xclkbuf_leaf_30_clk clknet_3_6__leaf_clk VGND VGND VPWR VPWR clknet_leaf_30_clk sky130_fd_sc_hd__clkbuf_8
X_3898_ _1810_ _1811_ _1815_ net138 reg_file_inst.registry\[0\]\[1\] VGND VGND VPWR
+ VPWR _1816_ sky130_fd_sc_hd__o32a_4
X_5637_ net148 VGND VGND VPWR VPWR _0045_ sky130_fd_sc_hd__inv_2
X_5568_ reg_file_inst.registry\[15\]\[24\] _2787_ _3003_ VGND VGND VPWR VPWR _0499_
+ sky130_fd_sc_hd__mux2_1
XFILLER_88_18 VGND VGND VPWR VPWR sky130_fd_sc_hd__decap_8
XFILLER_117_573 VPWR VGND VPWR VGND sky130_ef_sc_hd__decap_12
X_4519_ _2191_ _2387_ VGND VGND VPWR VPWR _2402_ sky130_fd_sc_hd__nand2b_1
X_5499_ JMPOFF\[6\] _2375_ _3000_ VGND VGND VPWR VPWR _0565_ sky130_fd_sc_hd__mux2_1
XFILLER_77_118 VGND VGND VPWR VPWR sky130_fd_sc_hd__decap_4
XFILLER_58_321 VPWR VGND VPWR VGND sky130_ef_sc_hd__decap_12
XFILLER_100_462 VPWR VGND VPWR VGND sky130_ef_sc_hd__decap_12
XFILLER_58_365 VPWR VGND VPWR VGND sky130_ef_sc_hd__decap_12
XFILLER_37_55 VGND VGND VPWR VPWR sky130_fd_sc_hd__fill_1
XFILLER_26_251 VGND VGND VPWR VPWR sky130_fd_sc_hd__fill_1
XFILLER_53_54 VGND VGND VPWR VPWR sky130_fd_sc_hd__fill_2
XFILLER_26_295 VPWR VGND VPWR VGND sky130_ef_sc_hd__decap_12
XFILLER_14_468 VGND VGND VPWR VPWR sky130_fd_sc_hd__decap_8
Xclkbuf_leaf_21_clk clknet_3_3__leaf_clk VGND VGND VPWR VPWR clknet_leaf_21_clk sky130_fd_sc_hd__clkbuf_8
XFILLER_6_601 VPWR VGND VPWR VGND sky130_ef_sc_hd__decap_12
XFILLER_6_645 VPWR VGND VPWR VGND sky130_ef_sc_hd__decap_12
XFILLER_5_111 VGND VGND VPWR VPWR sky130_fd_sc_hd__fill_1
XFILLER_5_133 VGND VGND VPWR VPWR sky130_fd_sc_hd__decap_6
XFILLER_5_166 VGND VGND VPWR VPWR sky130_fd_sc_hd__fill_2
XFILLER_68_118 VGND VGND VPWR VPWR sky130_fd_sc_hd__fill_2
XFILLER_37_505 VPWR VGND VPWR VGND sky130_ef_sc_hd__decap_12
XFILLER_49_354 VPWR VGND VPWR VGND sky130_ef_sc_hd__decap_12
XTAP_TAPCELL_ROW_69_1125 VGND VPWR sky130_fd_sc_hd__tapvpwrvgnd_1
XFILLER_37_538 VPWR VGND VPWR VGND sky130_ef_sc_hd__decap_12
XFILLER_91_154 VPWR VGND VPWR VGND sky130_ef_sc_hd__decap_12
XFILLER_92_699 VGND VGND VPWR VPWR sky130_fd_sc_hd__fill_1
XTAP_TAPCELL_ROW_35_706 VGND VPWR sky130_fd_sc_hd__tapvpwrvgnd_1
XFILLER_91_198 VGND VGND VPWR VPWR sky130_fd_sc_hd__fill_1
X_4870_ _1840_ _2193_ _2340_ VGND VGND VPWR VPWR _2727_ sky130_fd_sc_hd__o21ba_1
XFILLER_32_221 VGND VGND VPWR VPWR sky130_fd_sc_hd__fill_2
X_3821_ reg_file_inst.registry\[8\]\[5\] _1114_ net144 VGND VGND VPWR VPWR _1742_
+ sky130_fd_sc_hd__and3_1
XTAP_TAPCELL_ROW_15_452 VGND VPWR sky130_fd_sc_hd__tapvpwrvgnd_1
XFILLER_32_265 VGND VGND VPWR VPWR sky130_fd_sc_hd__decap_4
X_6540_ clknet_leaf_39_clk _0948_ _0473_ VGND VGND VPWR VPWR net120 sky130_fd_sc_hd__dfrtp_1
XFILLER_32_287 VGND VGND VPWR VPWR sky130_fd_sc_hd__fill_2
Xclkbuf_leaf_12_clk clknet_3_2__leaf_clk VGND VGND VPWR VPWR clknet_leaf_12_clk sky130_fd_sc_hd__clkbuf_8
XFILLER_9_461 VPWR VGND VPWR VGND sky130_ef_sc_hd__decap_12
X_3752_ MEMOFF\[6\] _1079_ _1098_ reg_file_inst.registry\[10\]\[6\] VGND VGND VPWR
+ VPWR _1675_ sky130_fd_sc_hd__a22o_1
X_3683_ _1607_ VGND VGND VPWR VPWR _1608_ sky130_fd_sc_hd__inv_2
X_6471_ clknet_leaf_50_clk _0879_ _0404_ VGND VGND VPWR VPWR reg_file_inst.registry\[7\]\[4\]
+ sky130_fd_sc_hd__dfrtp_1
X_5422_ _2767_ reg_file_inst.registry\[10\]\[25\] _2998_ VGND VGND VPWR VPWR _0640_
+ sky130_fd_sc_hd__mux2_1
XFILLER_99_210 VGND VGND VPWR VPWR sky130_fd_sc_hd__fill_1
XTAP_TAPCELL_ROW_93_1432 VGND VPWR sky130_fd_sc_hd__tapvpwrvgnd_1
XTAP_TAPCELL_ROW_93_1421 VGND VPWR sky130_fd_sc_hd__tapvpwrvgnd_1
X_5353_ _2311_ reg_file_inst.registry\[3\]\[7\] _2995_ VGND VGND VPWR VPWR _0706_
+ sky130_fd_sc_hd__mux2_1
X_4304_ _1735_ _2191_ VGND VGND VPWR VPWR _2192_ sky130_fd_sc_hd__or2_4
XFILLER_114_587 VGND VGND VPWR VPWR sky130_fd_sc_hd__fill_1
XFILLER_87_405 VGND VGND VPWR VPWR sky130_fd_sc_hd__fill_2
X_5284_ _2863_ reg_file_inst.registry\[2\]\[18\] _2993_ VGND VGND VPWR VPWR _0773_
+ sky130_fd_sc_hd__mux2_1
XFILLER_101_237 VPWR VGND VPWR VGND sky130_ef_sc_hd__decap_12
XFILLER_87_449 VPWR VGND VPWR VGND sky130_ef_sc_hd__decap_12
X_4235_ _0960_ net42 _2115_ VGND VGND VPWR VPWR _2123_ sky130_fd_sc_hd__and3_4
XFILLER_114_27 VGND VGND VPWR VPWR sky130_fd_sc_hd__fill_1
X_4166_ net112 _2011_ _2074_ VGND VGND VPWR VPWR _2075_ sky130_fd_sc_hd__a21o_1
XFILLER_95_482 VPWR VGND VPWR VGND sky130_ef_sc_hd__decap_12
X_3117_ _1053_ _1058_ _1060_ VGND VGND VPWR VPWR _1061_ sky130_fd_sc_hd__a21o_1
X_4097_ net114 net131 _2007_ _2008_ VGND VGND VPWR VPWR _2013_ sky130_fd_sc_hd__nand4_1
XFILLER_55_335 VGND VGND VPWR VPWR sky130_fd_sc_hd__fill_1
XFILLER_82_176 VPWR VGND VPWR VGND sky130_ef_sc_hd__decap_12
XFILLER_24_722 VGND VGND VPWR VPWR sky130_fd_sc_hd__decap_4
X_3048_ JMPOFF\[7\] net41 net141 VGND VGND VPWR VPWR _0992_ sky130_fd_sc_hd__and3_1
XFILLER_51_530 VGND VGND VPWR VPWR sky130_fd_sc_hd__decap_3
XFILLER_36_593 VPWR VGND VPWR VGND sky130_ef_sc_hd__decap_12
X_4999_ reg_file_inst.registry\[7\]\[20\] _2842_ _2553_ VGND VGND VPWR VPWR _0895_
+ sky130_fd_sc_hd__mux2_1
XFILLER_23_276 VGND VGND VPWR VPWR sky130_fd_sc_hd__decap_4
XFILLER_23_57 VGND VGND VPWR VPWR sky130_fd_sc_hd__decap_3
XFILLER_109_337 VPWR VGND VPWR VGND sky130_ef_sc_hd__decap_12
XFILLER_99_39 VPWR VGND VPWR VGND sky130_ef_sc_hd__decap_12
XFILLER_3_615 VGND VGND VPWR VPWR sky130_fd_sc_hd__fill_1
XFILLER_120_513 VPWR VGND VPWR VGND sky130_ef_sc_hd__decap_12
XFILLER_48_43 VGND VGND VPWR VPWR sky130_fd_sc_hd__fill_1
XFILLER_120_557 VPWR VGND VPWR VGND sky130_ef_sc_hd__decap_12
XFILLER_74_633 VGND VGND VPWR VPWR sky130_fd_sc_hd__decap_8
XFILLER_19_516 VPWR VGND VPWR VGND sky130_ef_sc_hd__decap_12
XFILLER_61_327 VGND VGND VPWR VPWR sky130_fd_sc_hd__decap_8
XFILLER_64_75 VGND VGND VPWR VPWR sky130_fd_sc_hd__fill_1
XPHY_EDGE_ROW_14_Left_137 VGND VGND VPWR VPWR sky130_fd_sc_hd__decap_3
XTAP_TAPCELL_ROW_64_1066 VGND VPWR sky130_fd_sc_hd__tapvpwrvgnd_1
XFILLER_9_15 VPWR VGND VPWR VGND sky130_ef_sc_hd__decap_12
XFILLER_30_714 VGND VGND VPWR VPWR sky130_fd_sc_hd__decap_4
XFILLER_80_41 VGND VGND VPWR VPWR sky130_fd_sc_hd__fill_2
XTAP_TAPCELL_ROW_12_411 VGND VPWR sky130_fd_sc_hd__tapvpwrvgnd_1
XFILLER_80_96 VGND VGND VPWR VPWR sky130_fd_sc_hd__fill_2
XFILLER_80_85 VGND VGND VPWR VPWR sky130_fd_sc_hd__decap_3
XTAP_TAPCELL_ROW_40_764 VGND VPWR sky130_fd_sc_hd__tapvpwrvgnd_1
XTAP_TAPCELL_ROW_116_1719 VGND VPWR sky130_fd_sc_hd__tapvpwrvgnd_1
XTAP_TAPCELL_ROW_116_1708 VGND VPWR sky130_fd_sc_hd__tapvpwrvgnd_1
XFILLER_6_453 VGND VGND VPWR VPWR sky130_fd_sc_hd__decap_8
XFILLER_115_329 VGND VGND VPWR VPWR sky130_fd_sc_hd__decap_6
XFILLER_6_475 VGND VGND VPWR VPWR sky130_fd_sc_hd__fill_1
XPHY_EDGE_ROW_23_Left_146 VGND VGND VPWR VPWR sky130_fd_sc_hd__decap_3
XFILLER_97_725 VGND VGND VPWR VPWR sky130_fd_sc_hd__fill_1
XFILLER_69_449 VGND VGND VPWR VPWR sky130_fd_sc_hd__decap_6
XFILLER_2_681 VPWR VGND VPWR VGND sky130_ef_sc_hd__decap_12
XFILLER_84_419 VGND VGND VPWR VPWR sky130_fd_sc_hd__fill_1
X_4020_ _1878_ _1932_ net127 VGND VGND VPWR VPWR _1936_ sky130_fd_sc_hd__a21oi_1
Xclkbuf_leaf_1_clk clknet_3_0__leaf_clk VGND VGND VPWR VPWR clknet_leaf_1_clk sky130_fd_sc_hd__clkbuf_8
XFILLER_49_162 VGND VGND VPWR VPWR sky130_fd_sc_hd__decap_6
XFILLER_37_335 VGND VGND VPWR VPWR sky130_fd_sc_hd__fill_1
X_5971_ net149 VGND VGND VPWR VPWR _0379_ sky130_fd_sc_hd__inv_2
XPHY_EDGE_ROW_32_Left_155 VGND VGND VPWR VPWR sky130_fd_sc_hd__decap_3
XTAP_TAPCELL_ROW_48_864 VGND VPWR sky130_fd_sc_hd__tapvpwrvgnd_1
X_4922_ _1790_ _2772_ _2774_ VGND VGND VPWR VPWR _2775_ sky130_fd_sc_hd__a21o_1
XFILLER_100_29 VPWR VGND VPWR VGND sky130_ef_sc_hd__decap_12
X_4853_ _2205_ _2231_ _1841_ VGND VGND VPWR VPWR _2712_ sky130_fd_sc_hd__mux2_1
XFILLER_21_725 VGND VGND VPWR VPWR sky130_fd_sc_hd__fill_1
X_3804_ reg_file_inst.registry\[3\]\[5\] _1082_ _1085_ VGND VGND VPWR VPWR _1725_
+ sky130_fd_sc_hd__and3_1
X_4784_ _1516_ _2641_ VGND VGND VPWR VPWR _2643_ sky130_fd_sc_hd__and2_1
X_3735_ reg_file_inst.registry\[11\]\[7\] _1119_ _1125_ VGND VGND VPWR VPWR _1659_
+ sky130_fd_sc_hd__and3_1
X_6523_ clknet_leaf_52_clk _0931_ _0456_ VGND VGND VPWR VPWR net129 sky130_fd_sc_hd__dfrtp_1
XFILLER_109_27 VPWR VGND VPWR VGND sky130_ef_sc_hd__decap_12
X_6454_ clknet_leaf_13_clk _0862_ _0387_ VGND VGND VPWR VPWR reg_file_inst.registry\[0\]\[15\]
+ sky130_fd_sc_hd__dfrtp_1
XFILLER_9_291 VGND VGND VPWR VPWR sky130_fd_sc_hd__decap_8
XPHY_EDGE_ROW_41_Left_164 VGND VGND VPWR VPWR sky130_fd_sc_hd__decap_3
XFILLER_118_189 VGND VGND VPWR VPWR sky130_fd_sc_hd__decap_6
XFILLER_106_307 VGND VGND VPWR VPWR sky130_fd_sc_hd__fill_1
Xclkload50 clknet_leaf_33_clk VGND VGND VPWR VPWR clkload50/Y sky130_fd_sc_hd__inv_6
X_3666_ reg_file_inst.registry\[9\]\[9\] _1131_ _1584_ _1585_ _1586_ VGND VGND VPWR
+ VPWR _1592_ sky130_fd_sc_hd__a2111o_1
X_5405_ reg_file_inst.registry\[4\]\[13\] _2922_ _2997_ VGND VGND VPWR VPWR _0656_
+ sky130_fd_sc_hd__mux2_1
X_6385_ clknet_leaf_27_clk _0793_ _0318_ VGND VGND VPWR VPWR reg_file_inst.registry\[14\]\[10\]
+ sky130_fd_sc_hd__dfrtp_1
X_3597_ MEMOFF\[11\] _1079_ _1090_ reg_file_inst.registry\[8\]\[11\] _1524_ VGND VGND
+ VPWR VPWR _1525_ sky130_fd_sc_hd__a221o_1
X_5336_ _2787_ reg_file_inst.registry\[3\]\[24\] _2995_ VGND VGND VPWR VPWR _0723_
+ sky130_fd_sc_hd__mux2_1
X_5267_ reg_file_inst.registry\[14\]\[6\] _2375_ _2992_ VGND VGND VPWR VPWR _0789_
+ sky130_fd_sc_hd__mux2_1
XFILLER_102_557 VPWR VGND VPWR VGND sky130_ef_sc_hd__decap_12
X_4218_ _2109_ net123 net130 VGND VGND VPWR VPWR _0925_ sky130_fd_sc_hd__mux2_1
X_5198_ _2311_ reg_file_inst.registry\[0\]\[7\] _2988_ VGND VGND VPWR VPWR _0854_
+ sky130_fd_sc_hd__mux2_1
XFILLER_56_633 VGND VGND VPWR VPWR sky130_fd_sc_hd__fill_1
XFILLER_95_290 VGND VGND VPWR VPWR sky130_fd_sc_hd__fill_2
X_4149_ _2054_ _2063_ VGND VGND VPWR VPWR _2064_ sky130_fd_sc_hd__xnor2_1
XFILLER_56_655 VPWR VGND VPWR VGND sky130_ef_sc_hd__decap_12
XFILLER_18_57 VGND VGND VPWR VPWR sky130_fd_sc_hd__fill_2
XFILLER_28_357 VGND VGND VPWR VPWR sky130_fd_sc_hd__fill_1
XPHY_EDGE_ROW_50_Left_173 VGND VGND VPWR VPWR sky130_fd_sc_hd__decap_3
XFILLER_56_699 VGND VGND VPWR VPWR sky130_fd_sc_hd__fill_1
XFILLER_28_368 VGND VGND VPWR VPWR sky130_fd_sc_hd__decap_4
XFILLER_34_23 VGND VGND VPWR VPWR sky130_fd_sc_hd__decap_4
XTAP_TAPCELL_ROW_100_1509 VGND VPWR sky130_fd_sc_hd__tapvpwrvgnd_1
XFILLER_11_213 VGND VGND VPWR VPWR sky130_fd_sc_hd__decap_8
XFILLER_24_596 VGND VGND VPWR VPWR sky130_fd_sc_hd__decap_8
XFILLER_11_246 VGND VGND VPWR VPWR sky130_fd_sc_hd__fill_1
Xclkload0 clknet_3_1__leaf_clk VGND VGND VPWR VPWR clkload0/Y sky130_fd_sc_hd__inv_6
XFILLER_7_239 VGND VGND VPWR VPWR sky130_fd_sc_hd__decap_6
XFILLER_109_167 VGND VGND VPWR VPWR sky130_fd_sc_hd__fill_1
XFILLER_79_725 VGND VGND VPWR VPWR sky130_fd_sc_hd__fill_1
XFILLER_120_321 VPWR VGND VPWR VGND sky130_ef_sc_hd__decap_12
XTAP_TAPCELL_ROW_111_1649 VGND VPWR sky130_fd_sc_hd__tapvpwrvgnd_1
XFILLER_105_384 VGND VGND VPWR VPWR sky130_fd_sc_hd__decap_8
XFILLER_59_86 VPWR VGND VPWR VGND sky130_ef_sc_hd__decap_12
XFILLER_120_365 VPWR VGND VPWR VGND sky130_ef_sc_hd__decap_12
XFILLER_66_419 VGND VGND VPWR VPWR sky130_fd_sc_hd__fill_1
XFILLER_115_81 VPWR VGND VPWR VGND sky130_ef_sc_hd__decap_12
XFILLER_93_216 VGND VGND VPWR VPWR sky130_fd_sc_hd__fill_1
XFILLER_19_313 VPWR VGND VPWR VGND sky130_ef_sc_hd__decap_12
XFILLER_75_41 VGND VGND VPWR VPWR sky130_fd_sc_hd__decap_8
XFILLER_19_335 VGND VGND VPWR VPWR sky130_fd_sc_hd__fill_1
XFILLER_61_113 VPWR VGND VPWR VGND sky130_ef_sc_hd__decap_12
XTAP_TAPCELL_ROW_45_823 VGND VPWR sky130_fd_sc_hd__tapvpwrvgnd_1
XFILLER_46_187 VGND VGND VPWR VPWR sky130_fd_sc_hd__decap_8
XTAP_TAPCELL_ROW_122_1789 VGND VPWR sky130_fd_sc_hd__tapvpwrvgnd_1
XTAP_TAPCELL_ROW_25_580 VGND VPWR sky130_fd_sc_hd__tapvpwrvgnd_1
XFILLER_30_533 VGND VGND VPWR VPWR sky130_fd_sc_hd__fill_1
X_3520_ reg_file_inst.registry\[2\]\[13\] _1083_ _1448_ net140 VGND VGND VPWR VPWR
+ _1451_ sky130_fd_sc_hd__a211o_1
XTAP_TAPCELL_ROW_77_1224 VGND VPWR sky130_fd_sc_hd__tapvpwrvgnd_1
XFILLER_115_137 VPWR VGND VPWR VGND sky130_ef_sc_hd__decap_12
X_3451_ MEMOFF\[16\] _1129_ _1141_ reg_file_inst.registry\[11\]\[16\] _1117_ VGND
+ VGND VPWR VPWR _1385_ sky130_fd_sc_hd__a221o_1
XFILLER_97_500 VGND VGND VPWR VPWR sky130_fd_sc_hd__decap_4
X_6170_ clknet_leaf_24_clk _0578_ _0103_ VGND VGND VPWR VPWR JMPOFF\[19\] sky130_fd_sc_hd__dfrtp_4
X_3382_ reg_file_inst.registry\[2\]\[20\] _1137_ _1314_ _1317_ _1318_ VGND VGND VPWR
+ VPWR _1319_ sky130_fd_sc_hd__a2111o_1
XFILLER_69_202 VGND VGND VPWR VPWR sky130_fd_sc_hd__fill_1
XFILLER_41_3 VGND VGND VPWR VPWR sky130_fd_sc_hd__decap_6
X_5121_ _2177_ _2936_ _2937_ _2947_ VGND VGND VPWR VPWR net47 sky130_fd_sc_hd__o31ai_2
XFILLER_97_588 VPWR VGND VPWR VGND sky130_ef_sc_hd__decap_12
X_5052_ _2638_ _2642_ _2885_ VGND VGND VPWR VPWR _2887_ sky130_fd_sc_hd__or3_1
X_4003_ net104 _1918_ VGND VGND VPWR VPWR _1919_ sky130_fd_sc_hd__and2_1
XFILLER_38_633 VGND VGND VPWR VPWR sky130_fd_sc_hd__decap_8
XFILLER_92_260 VPWR VGND VPWR VGND sky130_ef_sc_hd__decap_12
XTAP_TAPCELL_ROW_88_1364 VGND VPWR sky130_fd_sc_hd__tapvpwrvgnd_1
XFILLER_53_658 VPWR VGND VPWR VGND sky130_ef_sc_hd__decap_12
XFILLER_53_647 VGND VGND VPWR VPWR sky130_fd_sc_hd__fill_1
XFILLER_25_327 VGND VGND VPWR VPWR sky130_fd_sc_hd__decap_8
XFILLER_111_39 VPWR VGND VPWR VGND sky130_ef_sc_hd__decap_12
X_5954_ net147 VGND VGND VPWR VPWR _0362_ sky130_fd_sc_hd__inv_2
XFILLER_61_691 VPWR VGND VPWR VGND sky130_ef_sc_hd__decap_12
X_5885_ net147 VGND VGND VPWR VPWR _0293_ sky130_fd_sc_hd__inv_2
X_4905_ _2758_ _2759_ _1790_ VGND VGND VPWR VPWR _2760_ sky130_fd_sc_hd__mux2_1
XFILLER_21_511 VGND VGND VPWR VPWR sky130_fd_sc_hd__decap_8
X_4836_ _1840_ _2202_ _2203_ _1242_ VGND VGND VPWR VPWR _2695_ sky130_fd_sc_hd__a22o_1
X_6506_ clknet_leaf_29_clk _0914_ _0439_ VGND VGND VPWR VPWR reg_file_inst.registry\[11\]\[15\]
+ sky130_fd_sc_hd__dfrtp_2
X_4767_ _2605_ _2609_ _2603_ VGND VGND VPWR VPWR _2626_ sky130_fd_sc_hd__o21ba_1
X_3718_ reg_file_inst.registry\[8\]\[7\] _1090_ _1092_ reg_file_inst.registry\[4\]\[7\]
+ VGND VGND VPWR VPWR _1642_ sky130_fd_sc_hd__a22o_1
X_4698_ _2185_ _2186_ _2555_ _2126_ VGND VGND VPWR VPWR _2557_ sky130_fd_sc_hd__a31o_1
XFILLER_4_209 VPWR VGND VPWR VGND sky130_ef_sc_hd__decap_12
X_6437_ clknet_leaf_30_clk _0845_ _0370_ VGND VGND VPWR VPWR reg_file_inst.registry\[11\]\[22\]
+ sky130_fd_sc_hd__dfrtp_1
X_3649_ reg_file_inst.registry\[14\]\[9\] _1081_ _1087_ reg_file_inst.registry\[1\]\[9\]
+ VGND VGND VPWR VPWR _1575_ sky130_fd_sc_hd__a22o_1
XFILLER_115_671 VGND VGND VPWR VPWR sky130_fd_sc_hd__fill_1
X_6368_ clknet_leaf_42_clk _0776_ _0301_ VGND VGND VPWR VPWR reg_file_inst.registry\[2\]\[21\]
+ sky130_fd_sc_hd__dfrtp_1
XFILLER_96_29 VGND VGND VPWR VPWR sky130_fd_sc_hd__decap_8
X_5319_ _2934_ reg_file_inst.registry\[8\]\[12\] _2994_ VGND VGND VPWR VPWR _0739_
+ sky130_fd_sc_hd__mux2_1
XFILLER_76_717 VGND VGND VPWR VPWR sky130_fd_sc_hd__fill_1
X_6299_ clknet_leaf_54_clk _0707_ _0232_ VGND VGND VPWR VPWR reg_file_inst.registry\[3\]\[8\]
+ sky130_fd_sc_hd__dfrtp_1
XFILLER_88_599 VGND VGND VPWR VPWR sky130_fd_sc_hd__fill_1
XFILLER_91_709 VPWR VGND VPWR VGND sky130_ef_sc_hd__decap_12
XFILLER_75_249 VGND VGND VPWR VPWR sky130_fd_sc_hd__fill_1
XFILLER_28_110 VGND VGND VPWR VPWR sky130_fd_sc_hd__fill_1
XFILLER_28_154 VGND VGND VPWR VPWR sky130_fd_sc_hd__decap_6
XFILLER_45_11 VGND VGND VPWR VPWR sky130_fd_sc_hd__fill_1
XTAP_TAPCELL_ROW_3_297 VGND VPWR sky130_fd_sc_hd__tapvpwrvgnd_1
XFILLER_16_327 VGND VGND VPWR VPWR sky130_fd_sc_hd__decap_8
XFILLER_44_669 VGND VGND VPWR VPWR sky130_fd_sc_hd__decap_6
XFILLER_12_511 VGND VGND VPWR VPWR sky130_fd_sc_hd__decap_6
XTAP_TAPCELL_ROW_61_1025 VGND VPWR sky130_fd_sc_hd__tapvpwrvgnd_1
XFILLER_12_533 VGND VGND VPWR VPWR sky130_fd_sc_hd__decap_8
XFILLER_61_65 VGND VGND VPWR VPWR sky130_fd_sc_hd__fill_1
XTAP_TAPCELL_ROW_50_892 VGND VPWR sky130_fd_sc_hd__tapvpwrvgnd_1
XANTENNA_9 _1131_ VGND VGND VPWR VPWR sky130_fd_sc_hd__diode_2
XFILLER_6_27 VGND VGND VPWR VPWR sky130_fd_sc_hd__fill_1
XFILLER_106_693 VGND VGND VPWR VPWR sky130_fd_sc_hd__decap_6
XFILLER_3_275 VGND VGND VPWR VPWR sky130_fd_sc_hd__decap_4
XFILLER_121_641 VPWR VGND VPWR VGND sky130_ef_sc_hd__decap_12
XFILLER_105_181 VPWR VGND VPWR VGND sky130_ef_sc_hd__decap_12
XTAP_TAPCELL_ROW_72_1165 VGND VPWR sky130_fd_sc_hd__tapvpwrvgnd_1
XFILLER_121_685 VPWR VGND VPWR VGND sky130_ef_sc_hd__decap_12
XFILLER_20_8 VPWR VGND VPWR VGND sky130_ef_sc_hd__decap_12
XFILLER_120_195 VGND VGND VPWR VPWR sky130_fd_sc_hd__fill_1
XFILLER_94_558 VGND VGND VPWR VPWR sky130_fd_sc_hd__fill_1
XFILLER_19_110 VGND VGND VPWR VPWR sky130_fd_sc_hd__fill_2
XTAP_TAPCELL_ROW_58_992 VGND VPWR sky130_fd_sc_hd__tapvpwrvgnd_1
XFILLER_47_485 VPWR VGND VPWR VGND sky130_ef_sc_hd__decap_12
XFILLER_62_444 VPWR VGND VPWR VGND sky130_ef_sc_hd__decap_12
XFILLER_35_658 VGND VGND VPWR VPWR sky130_fd_sc_hd__decap_6
XFILLER_62_477 VGND VGND VPWR VPWR sky130_fd_sc_hd__decap_4
X_5670_ net146 VGND VGND VPWR VPWR _0078_ sky130_fd_sc_hd__inv_2
XFILLER_89_3 VGND VGND VPWR VPWR sky130_fd_sc_hd__decap_6
X_4621_ _2486_ _2497_ _1764_ VGND VGND VPWR VPWR _2498_ sky130_fd_sc_hd__mux2_1
XTAP_TAPCELL_ROW_20_509 VGND VPWR sky130_fd_sc_hd__tapvpwrvgnd_1
XFILLER_116_413 VGND VGND VPWR VPWR sky130_fd_sc_hd__decap_6
X_4552_ _2430_ _2432_ net136 VGND VGND VPWR VPWR _2433_ sky130_fd_sc_hd__mux2_1
X_4483_ _1151_ _2367_ _1817_ VGND VGND VPWR VPWR _2368_ sky130_fd_sc_hd__mux2_1
X_3503_ reg_file_inst.registry\[0\]\[12\] _1118_ VGND VGND VPWR VPWR _1435_ sky130_fd_sc_hd__or2_1
XFILLER_116_457 VPWR VGND VPWR VGND sky130_ef_sc_hd__decap_12
X_6222_ clknet_leaf_15_clk _0630_ _0155_ VGND VGND VPWR VPWR reg_file_inst.registry\[10\]\[15\]
+ sky130_fd_sc_hd__dfrtp_1
X_3434_ _1364_ _1365_ _1368_ _1118_ reg_file_inst.registry\[0\]\[18\] VGND VGND VPWR
+ VPWR net82 sky130_fd_sc_hd__o32a_1
X_3365_ reg_file_inst.registry\[7\]\[20\] _1084_ _1085_ _1093_ reg_file_inst.registry\[15\]\[20\]
+ VGND VGND VPWR VPWR _1302_ sky130_fd_sc_hd__a32o_1
XFILLER_58_717 VGND VGND VPWR VPWR sky130_fd_sc_hd__fill_1
X_6153_ clknet_leaf_61_clk _0561_ _0086_ VGND VGND VPWR VPWR JMPOFF\[2\] sky130_fd_sc_hd__dfrtp_4
X_3296_ JMPOFF\[23\] _1130_ _1138_ reg_file_inst.registry\[14\]\[23\] _1117_ VGND
+ VGND VPWR VPWR _1236_ sky130_fd_sc_hd__a221o_1
X_6084_ clknet_leaf_8_clk _0492_ _0017_ VGND VGND VPWR VPWR reg_file_inst.registry\[15\]\[17\]
+ sky130_fd_sc_hd__dfrtp_1
X_5104_ _1765_ _2443_ _2929_ _2932_ VGND VGND VPWR VPWR _2933_ sky130_fd_sc_hd__o31a_1
X_5035_ net9 net101 net53 _2308_ VGND VGND VPWR VPWR _2873_ sky130_fd_sc_hd__a22o_4
XFILLER_122_27 VGND VGND VPWR VPWR sky130_fd_sc_hd__fill_1
XTAP_TAPCELL_ROW_28_609 VGND VPWR sky130_fd_sc_hd__tapvpwrvgnd_1
XFILLER_65_293 VPWR VGND VPWR VGND sky130_ef_sc_hd__decap_12
XTAP_TAPCELL_ROW_0_256 VGND VPWR sky130_fd_sc_hd__tapvpwrvgnd_1
XTAP_TAPCELL_ROW_0_267 VGND VPWR sky130_fd_sc_hd__tapvpwrvgnd_1
XFILLER_80_285 VGND VGND VPWR VPWR sky130_fd_sc_hd__fill_2
X_5937_ net148 VGND VGND VPWR VPWR _0345_ sky130_fd_sc_hd__inv_2
XFILLER_15_47 VGND VGND VPWR VPWR sky130_fd_sc_hd__decap_3
XFILLER_41_617 VPWR VGND VPWR VGND sky130_ef_sc_hd__decap_12
XFILLER_80_296 VPWR VGND VPWR VGND sky130_ef_sc_hd__decap_12
X_5868_ net146 VGND VGND VPWR VPWR _0276_ sky130_fd_sc_hd__inv_2
XFILLER_21_352 VGND VGND VPWR VPWR sky130_fd_sc_hd__fill_2
X_5799_ net147 VGND VGND VPWR VPWR _0207_ sky130_fd_sc_hd__inv_2
X_4819_ _2568_ _2677_ VGND VGND VPWR VPWR _2678_ sky130_fd_sc_hd__nor2_1
XFILLER_31_35 VGND VGND VPWR VPWR sky130_fd_sc_hd__fill_1
XFILLER_119_273 VGND VGND VPWR VPWR sky130_fd_sc_hd__decap_6
XFILLER_5_529 VPWR VGND VPWR VGND sky130_ef_sc_hd__decap_12
XFILLER_31_57 VGND VGND VPWR VPWR sky130_fd_sc_hd__fill_1
XFILLER_122_405 VPWR VGND VPWR VGND sky130_ef_sc_hd__decap_12
Xoutput46 net46 VGND VGND VPWR VPWR DataAddress[10] sky130_fd_sc_hd__buf_1
Xoutput57 net57 VGND VGND VPWR VPWR DataAddress[20] sky130_fd_sc_hd__buf_1
XFILLER_122_449 VPWR VGND VPWR VGND sky130_ef_sc_hd__decap_12
XFILLER_103_641 VPWR VGND VPWR VGND sky130_ef_sc_hd__decap_12
Xoutput79 net79 VGND VGND VPWR VPWR DataMemoryWrite[15] sky130_fd_sc_hd__buf_1
XTAP_TAPCELL_ROW_8_367 VGND VPWR sky130_fd_sc_hd__tapvpwrvgnd_1
XFILLER_0_223 VGND VGND VPWR VPWR sky130_fd_sc_hd__fill_1
Xoutput68 net68 VGND VGND VPWR VPWR DataAddress[5] sky130_fd_sc_hd__buf_1
XFILLER_0_245 VGND VGND VPWR VPWR sky130_fd_sc_hd__decap_6
XFILLER_103_685 VPWR VGND VPWR VGND sky130_ef_sc_hd__decap_12
XFILLER_0_267 VGND VGND VPWR VPWR sky130_fd_sc_hd__fill_1
XFILLER_91_517 VGND VGND VPWR VPWR sky130_fd_sc_hd__decap_3
XTAP_TAPCELL_ROW_55_951 VGND VPWR sky130_fd_sc_hd__tapvpwrvgnd_1
XFILLER_17_658 VPWR VGND VPWR VGND sky130_ef_sc_hd__decap_12
XPHY_EDGE_ROW_19_Right_19 VGND VGND VPWR VPWR sky130_fd_sc_hd__decap_3
XFILLER_44_477 VGND VGND VPWR VPWR sky130_fd_sc_hd__decap_8
Xclkbuf_3_1__f_clk clknet_0_clk VGND VGND VPWR VPWR clknet_3_1__leaf_clk sky130_fd_sc_hd__clkbuf_16
XFILLER_113_405 VPWR VGND VPWR VGND sky130_ef_sc_hd__decap_12
XFILLER_99_617 VPWR VGND VPWR VGND sky130_ef_sc_hd__decap_12
XPHY_EDGE_ROW_28_Right_28 VGND VGND VPWR VPWR sky130_fd_sc_hd__decap_3
XFILLER_98_138 VGND VGND VPWR VPWR sky130_fd_sc_hd__fill_2
XFILLER_113_449 VPWR VGND VPWR VGND sky130_ef_sc_hd__decap_12
XFILLER_67_514 VPWR VGND VPWR VGND sky130_ef_sc_hd__decap_12
XFILLER_67_503 VGND VGND VPWR VPWR sky130_fd_sc_hd__fill_1
X_3150_ _1080_ _1084_ VGND VGND VPWR VPWR _1094_ sky130_fd_sc_hd__and2_4
X_3081_ JMPOFF\[8\] _0967_ VGND VGND VPWR VPWR _1025_ sky130_fd_sc_hd__nand2_1
XFILLER_94_377 VGND VGND VPWR VPWR sky130_fd_sc_hd__fill_2
XTAP_TAPCELL_ROW_85_1323 VGND VPWR sky130_fd_sc_hd__tapvpwrvgnd_1
XPHY_EDGE_ROW_6_Left_129 VGND VGND VPWR VPWR sky130_fd_sc_hd__decap_3
XPHY_EDGE_ROW_37_Right_37 VGND VGND VPWR VPWR sky130_fd_sc_hd__decap_3
XFILLER_62_241 VGND VGND VPWR VPWR sky130_fd_sc_hd__decap_8
XFILLER_47_293 VGND VGND VPWR VPWR sky130_fd_sc_hd__decap_4
XFILLER_23_639 VGND VGND VPWR VPWR sky130_fd_sc_hd__fill_1
XFILLER_50_414 VGND VGND VPWR VPWR sky130_fd_sc_hd__decap_6
X_5722_ net147 VGND VGND VPWR VPWR _0130_ sky130_fd_sc_hd__inv_2
XFILLER_22_138 VGND VGND VPWR VPWR sky130_fd_sc_hd__fill_2
X_3983_ _1042_ _1886_ _1049_ VGND VGND VPWR VPWR _1899_ sky130_fd_sc_hd__a21o_1
XTAP_TAPCELL_ROW_33_678 VGND VPWR sky130_fd_sc_hd__tapvpwrvgnd_1
XFILLER_50_469 VGND VGND VPWR VPWR sky130_fd_sc_hd__decap_6
X_5653_ net149 VGND VGND VPWR VPWR _0061_ sky130_fd_sc_hd__inv_2
X_5584_ reg_file_inst.registry\[15\]\[8\] _2986_ _3003_ VGND VGND VPWR VPWR _0483_
+ sky130_fd_sc_hd__mux2_1
X_4604_ _1816_ _2421_ _2480_ VGND VGND VPWR VPWR _2481_ sky130_fd_sc_hd__a21o_1
XPHY_EDGE_ROW_46_Right_46 VGND VGND VPWR VPWR sky130_fd_sc_hd__decap_3
XFILLER_116_221 VPWR VGND VPWR VGND sky130_ef_sc_hd__decap_12
XFILLER_7_81 VGND VGND VPWR VPWR sky130_fd_sc_hd__fill_2
X_4535_ _1736_ _2417_ _2416_ _2413_ VGND VGND VPWR VPWR net68 sky130_fd_sc_hd__a211o_2
XFILLER_117_27 VPWR VGND VPWR VGND sky130_ef_sc_hd__decap_12
XTAP_TAPCELL_ROW_96_1463 VGND VPWR sky130_fd_sc_hd__tapvpwrvgnd_1
XFILLER_116_265 VPWR VGND VPWR VGND sky130_ef_sc_hd__decap_12
X_4466_ _1790_ _2350_ _2348_ net137 VGND VGND VPWR VPWR _2351_ sky130_fd_sc_hd__o211a_1
X_6205_ clknet_leaf_20_clk _0613_ _0138_ VGND VGND VPWR VPWR reg_file_inst.registry\[5\]\[26\]
+ sky130_fd_sc_hd__dfrtp_1
X_3417_ reg_file_inst.registry\[1\]\[18\] _1087_ _1093_ reg_file_inst.registry\[15\]\[18\]
+ VGND VGND VPWR VPWR _1352_ sky130_fd_sc_hd__a22o_1
X_4397_ net30 _0960_ _2125_ _2252_ VGND VGND VPWR VPWR _2285_ sky130_fd_sc_hd__or4_4
X_3348_ reg_file_inst.registry\[10\]\[21\] _1123_ _1125_ VGND VGND VPWR VPWR _1286_
+ sky130_fd_sc_hd__and3_1
X_6136_ clknet_leaf_1_clk _0544_ _0069_ VGND VGND VPWR VPWR reg_file_inst.registry\[6\]\[13\]
+ sky130_fd_sc_hd__dfrtp_1
XTAP_TAPCELL_ROW_5_326 VGND VPWR sky130_fd_sc_hd__tapvpwrvgnd_1
XFILLER_97_193 VGND VGND VPWR VPWR sky130_fd_sc_hd__decap_6
XFILLER_85_311 VGND VGND VPWR VPWR sky130_fd_sc_hd__fill_1
XPHY_EDGE_ROW_55_Right_55 VGND VGND VPWR VPWR sky130_fd_sc_hd__decap_3
X_6067_ clknet_leaf_55_clk _0475_ _0000_ VGND VGND VPWR VPWR reg_file_inst.registry\[15\]\[0\]
+ sky130_fd_sc_hd__dfrtp_1
X_3279_ _1207_ _1217_ VGND VGND VPWR VPWR _1219_ sky130_fd_sc_hd__or2_1
XFILLER_100_699 VGND VGND VPWR VPWR sky130_fd_sc_hd__fill_1
X_5018_ _1369_ _2282_ _2285_ _1370_ _2858_ VGND VGND VPWR VPWR _2859_ sky130_fd_sc_hd__o221a_1
XFILLER_38_271 VPWR VGND VPWR VGND sky130_ef_sc_hd__decap_12
XFILLER_45_219 VGND VGND VPWR VPWR sky130_fd_sc_hd__decap_4
XFILLER_81_561 VPWR VGND VPWR VGND sky130_ef_sc_hd__decap_12
XTAP_TAPCELL_ROW_52_910 VGND VPWR sky130_fd_sc_hd__tapvpwrvgnd_1
XFILLER_26_466 VGND VGND VPWR VPWR sky130_fd_sc_hd__fill_1
XTAP_TAPCELL_ROW_105_1581 VGND VPWR sky130_fd_sc_hd__tapvpwrvgnd_1
XFILLER_42_23 VGND VGND VPWR VPWR sky130_fd_sc_hd__decap_4
XPHY_EDGE_ROW_64_Right_64 VGND VGND VPWR VPWR sky130_fd_sc_hd__decap_3
XFILLER_110_419 VGND VGND VPWR VPWR sky130_fd_sc_hd__fill_1
XFILLER_107_93 VPWR VGND VPWR VGND sky130_ef_sc_hd__decap_12
XFILLER_67_31 VGND VGND VPWR VPWR sky130_fd_sc_hd__fill_1
XFILLER_3_39 VPWR VGND VPWR VGND sky130_ef_sc_hd__decap_12
XPHY_EDGE_ROW_73_Right_73 VGND VGND VPWR VPWR sky130_fd_sc_hd__decap_3
XFILLER_76_377 VPWR VGND VPWR VGND sky130_ef_sc_hd__decap_12
XFILLER_72_550 VGND VGND VPWR VPWR sky130_fd_sc_hd__decap_8
XFILLER_44_241 VGND VGND VPWR VPWR sky130_fd_sc_hd__decap_8
XFILLER_60_701 VPWR VGND VPWR VGND sky130_ef_sc_hd__decap_12
XFILLER_32_414 VGND VGND VPWR VPWR sky130_fd_sc_hd__decap_6
XTAP_TAPCELL_ROW_67_1097 VGND VPWR sky130_fd_sc_hd__tapvpwrvgnd_1
XPHY_EDGE_ROW_82_Right_82 VGND VGND VPWR VPWR sky130_fd_sc_hd__decap_3
XFILLER_13_650 VPWR VGND VPWR VGND sky130_ef_sc_hd__decap_12
XTAP_TAPCELL_ROW_80_1264 VGND VPWR sky130_fd_sc_hd__tapvpwrvgnd_1
XFILLER_12_160 VGND VGND VPWR VPWR sky130_fd_sc_hd__fill_2
XTAP_TAPCELL_ROW_30_637 VGND VPWR sky130_fd_sc_hd__tapvpwrvgnd_1
XFILLER_9_665 VGND VGND VPWR VPWR sky130_fd_sc_hd__decap_6
XFILLER_8_197 VPWR VGND VPWR VGND sky130_ef_sc_hd__decap_12
XTAP_TAPCELL_ROW_10_394 VGND VPWR sky130_fd_sc_hd__tapvpwrvgnd_1
XTAP_TAPCELL_ROW_10_383 VGND VPWR sky130_fd_sc_hd__tapvpwrvgnd_1
XFILLER_114_725 VGND VGND VPWR VPWR sky130_fd_sc_hd__fill_1
X_4320_ _2204_ _2207_ net134 VGND VGND VPWR VPWR _2208_ sky130_fd_sc_hd__mux2_1
X_4251_ _1692_ _2138_ VGND VGND VPWR VPWR _2139_ sky130_fd_sc_hd__and2_1
XFILLER_113_279 VGND VGND VPWR VPWR sky130_fd_sc_hd__fill_1
XPHY_EDGE_ROW_91_Right_91 VGND VGND VPWR VPWR sky130_fd_sc_hd__decap_3
X_3202_ reg_file_inst.registry\[15\]\[27\] _1122_ _1129_ MEMOFF\[27\] _1145_ VGND
+ VGND VPWR VPWR _1146_ sky130_fd_sc_hd__a221o_1
XFILLER_67_333 VGND VGND VPWR VPWR sky130_fd_sc_hd__decap_3
X_4182_ _1893_ _2086_ VGND VGND VPWR VPWR _2087_ sky130_fd_sc_hd__xor2_1
XFILLER_95_653 VPWR VGND VPWR VGND sky130_ef_sc_hd__decap_12
XFILLER_94_141 VGND VGND VPWR VPWR sky130_fd_sc_hd__decap_8
X_3133_ net40 net41 net34 VGND VGND VPWR VPWR _1077_ sky130_fd_sc_hd__a21o_1
XFILLER_95_697 VPWR VGND VPWR VGND sky130_ef_sc_hd__decap_12
X_3064_ _0954_ net33 _0961_ _0964_ _0957_ VGND VGND VPWR VPWR _1008_ sky130_fd_sc_hd__o41a_1
XFILLER_36_720 VGND VGND VPWR VPWR sky130_fd_sc_hd__decap_6
XTAP_TAPCELL_ROW_38_737 VGND VPWR sky130_fd_sc_hd__tapvpwrvgnd_1
XFILLER_63_561 VGND VGND VPWR VPWR sky130_fd_sc_hd__decap_6
XTAP_TAPCELL_ROW_18_483 VGND VPWR sky130_fd_sc_hd__tapvpwrvgnd_1
XTAP_TAPCELL_ROW_18_494 VGND VPWR sky130_fd_sc_hd__tapvpwrvgnd_1
X_3966_ net119 _1072_ net131 _1881_ VGND VGND VPWR VPWR _1882_ sky130_fd_sc_hd__and4_1
XFILLER_11_609 VGND VGND VPWR VPWR sky130_fd_sc_hd__decap_6
X_5705_ net149 VGND VGND VPWR VPWR _0113_ sky130_fd_sc_hd__inv_2
X_5636_ net44 VGND VGND VPWR VPWR _0044_ sky130_fd_sc_hd__inv_2
XFILLER_12_26 VGND VGND VPWR VPWR sky130_fd_sc_hd__fill_2
X_3897_ net140 _1806_ _1812_ _1814_ VGND VGND VPWR VPWR _1815_ sky130_fd_sc_hd__or4_2
XFILLER_117_541 VPWR VGND VPWR VGND sky130_ef_sc_hd__decap_12
X_5567_ reg_file_inst.registry\[15\]\[25\] _2767_ _3003_ VGND VGND VPWR VPWR _0500_
+ sky130_fd_sc_hd__mux2_1
XFILLER_117_585 VPWR VGND VPWR VGND sky130_ef_sc_hd__decap_12
X_5498_ JMPOFF\[7\] _2311_ _3000_ VGND VGND VPWR VPWR _0566_ sky130_fd_sc_hd__mux2_1
X_4518_ _1709_ _2400_ VGND VGND VPWR VPWR _2401_ sky130_fd_sc_hd__or2_1
XFILLER_2_318 VGND VGND VPWR VPWR sky130_fd_sc_hd__decap_8
X_4449_ _2330_ _2333_ net133 VGND VGND VPWR VPWR _2334_ sky130_fd_sc_hd__mux2_1
XFILLER_58_333 VPWR VGND VPWR VGND sky130_ef_sc_hd__decap_12
X_6119_ clknet_leaf_31_clk _0527_ _0052_ VGND VGND VPWR VPWR reg_file_inst.registry\[9\]\[24\]
+ sky130_fd_sc_hd__dfrtp_1
XFILLER_100_474 VGND VGND VPWR VPWR sky130_fd_sc_hd__fill_2
XFILLER_58_377 VGND VGND VPWR VPWR sky130_fd_sc_hd__decap_3
XFILLER_42_701 VGND VGND VPWR VPWR sky130_fd_sc_hd__decap_4
XFILLER_41_222 VGND VGND VPWR VPWR sky130_fd_sc_hd__fill_2
XFILLER_6_613 VPWR VGND VPWR VGND sky130_ef_sc_hd__decap_12
XFILLER_5_101 VGND VGND VPWR VPWR sky130_fd_sc_hd__fill_2
XFILLER_6_657 VPWR VGND VPWR VGND sky130_ef_sc_hd__decap_12
XFILLER_78_41 VGND VGND VPWR VPWR sky130_fd_sc_hd__decap_6
XFILLER_78_85 VPWR VGND VPWR VGND sky130_ef_sc_hd__decap_12
XFILLER_77_620 VGND VGND VPWR VPWR sky130_fd_sc_hd__decap_8
XFILLER_49_322 VGND VGND VPWR VPWR sky130_fd_sc_hd__fill_1
XFILLER_92_601 VPWR VGND VPWR VGND sky130_ef_sc_hd__decap_12
XFILLER_76_141 VGND VGND VPWR VPWR sky130_fd_sc_hd__fill_2
XFILLER_49_366 VGND VGND VPWR VPWR sky130_fd_sc_hd__fill_2
XTAP_TAPCELL_ROW_69_1126 VGND VPWR sky130_fd_sc_hd__tapvpwrvgnd_1
XFILLER_37_517 VGND VGND VPWR VPWR sky130_fd_sc_hd__fill_2
XFILLER_49_388 VGND VGND VPWR VPWR sky130_fd_sc_hd__decap_4
XFILLER_49_399 VGND VGND VPWR VPWR sky130_fd_sc_hd__fill_1
XFILLER_92_645 VPWR VGND VPWR VGND sky130_ef_sc_hd__decap_12
XFILLER_91_144 VGND VGND VPWR VPWR sky130_fd_sc_hd__decap_3
XFILLER_91_166 VGND VGND VPWR VPWR sky130_fd_sc_hd__fill_2
XFILLER_33_712 VGND VGND VPWR VPWR sky130_fd_sc_hd__decap_4
XTAP_TAPCELL_ROW_35_707 VGND VPWR sky130_fd_sc_hd__tapvpwrvgnd_1
XPHY_EDGE_ROW_96_Left_219 VGND VGND VPWR VPWR sky130_fd_sc_hd__decap_3
XFILLER_72_391 VPWR VGND VPWR VGND sky130_ef_sc_hd__decap_12
X_3820_ reg_file_inst.registry\[1\]\[5\] _1116_ _1127_ VGND VGND VPWR VPWR _1741_
+ sky130_fd_sc_hd__and3_1
XTAP_TAPCELL_ROW_15_453 VGND VPWR sky130_fd_sc_hd__tapvpwrvgnd_1
XFILLER_20_406 VGND VGND VPWR VPWR sky130_fd_sc_hd__decap_3
XFILLER_32_244 VGND VGND VPWR VPWR sky130_fd_sc_hd__decap_8
XFILLER_20_417 VGND VGND VPWR VPWR sky130_fd_sc_hd__decap_3
XFILLER_32_299 VGND VGND VPWR VPWR sky130_fd_sc_hd__fill_1
X_3751_ reg_file_inst.registry\[2\]\[6\] _1083_ _1096_ reg_file_inst.registry\[11\]\[6\]
+ VGND VGND VPWR VPWR _1674_ sky130_fd_sc_hd__a22o_1
X_6470_ clknet_leaf_6_clk _0878_ _0403_ VGND VGND VPWR VPWR reg_file_inst.registry\[7\]\[3\]
+ sky130_fd_sc_hd__dfrtp_1
XFILLER_9_473 VGND VGND VPWR VPWR sky130_fd_sc_hd__fill_1
X_3682_ reg_file_inst.registry\[0\]\[8\] _1076_ _1601_ _1606_ VGND VGND VPWR VPWR
+ _1607_ sky130_fd_sc_hd__o22a_4
X_5421_ _2747_ reg_file_inst.registry\[10\]\[26\] _2998_ VGND VGND VPWR VPWR _0641_
+ sky130_fd_sc_hd__mux2_1
XTAP_TAPCELL_ROW_93_1422 VGND VPWR sky130_fd_sc_hd__tapvpwrvgnd_1
X_5352_ _2986_ reg_file_inst.registry\[3\]\[8\] _2995_ VGND VGND VPWR VPWR _0707_
+ sky130_fd_sc_hd__mux2_1
XFILLER_114_533 VPWR VGND VPWR VGND sky130_ef_sc_hd__decap_12
X_4303_ _2190_ _1151_ VGND VGND VPWR VPWR _2191_ sky130_fd_sc_hd__and2b_2
X_5283_ _2854_ reg_file_inst.registry\[2\]\[19\] _2993_ VGND VGND VPWR VPWR _0774_
+ sky130_fd_sc_hd__mux2_1
XFILLER_99_288 VGND VGND VPWR VPWR sky130_fd_sc_hd__fill_1
X_4234_ _1119_ _2117_ _2118_ _2121_ VGND VGND VPWR VPWR _2122_ sky130_fd_sc_hd__o211a_4
XFILLER_101_249 VGND VGND VPWR VPWR sky130_fd_sc_hd__decap_8
XFILLER_68_642 VGND VGND VPWR VPWR sky130_fd_sc_hd__fill_2
X_4165_ _2005_ _2014_ _2017_ VGND VGND VPWR VPWR _2074_ sky130_fd_sc_hd__a21oi_1
XFILLER_95_494 VGND VGND VPWR VPWR sky130_fd_sc_hd__decap_8
XFILLER_68_697 VGND VGND VPWR VPWR sky130_fd_sc_hd__decap_3
XFILLER_68_686 VGND VGND VPWR VPWR sky130_fd_sc_hd__fill_1
X_3116_ _0972_ _1059_ VGND VGND VPWR VPWR _1060_ sky130_fd_sc_hd__nand2_1
X_4096_ net112 _2011_ VGND VGND VPWR VPWR _2012_ sky130_fd_sc_hd__nand2_1
XFILLER_55_347 VGND VGND VPWR VPWR sky130_fd_sc_hd__fill_2
X_3047_ JMPOFF\[17\] _0967_ _0990_ VGND VGND VPWR VPWR _0991_ sky130_fd_sc_hd__a21o_1
XFILLER_24_701 VGND VGND VPWR VPWR sky130_fd_sc_hd__decap_3
XFILLER_36_561 VPWR VGND VPWR VGND sky130_ef_sc_hd__decap_12
XFILLER_82_188 VGND VGND VPWR VPWR sky130_fd_sc_hd__decap_8
XFILLER_23_200 VGND VGND VPWR VPWR sky130_fd_sc_hd__decap_8
XTAP_TAPCELL_ROW_102_1540 VGND VPWR sky130_fd_sc_hd__tapvpwrvgnd_1
XFILLER_23_233 VGND VGND VPWR VPWR sky130_fd_sc_hd__decap_3
X_4998_ net13 net101 net57 _2308_ VGND VGND VPWR VPWR _2842_ sky130_fd_sc_hd__a22o_4
XFILLER_109_305 VPWR VGND VPWR VGND sky130_ef_sc_hd__decap_12
X_3949_ _1197_ _1208_ _1217_ _1194_ _1185_ VGND VGND VPWR VPWR _1865_ sky130_fd_sc_hd__o32a_1
XFILLER_109_349 VPWR VGND VPWR VGND sky130_ef_sc_hd__decap_12
X_5619_ net44 VGND VGND VPWR VPWR _0027_ sky130_fd_sc_hd__inv_2
XFILLER_117_393 VPWR VGND VPWR VGND sky130_ef_sc_hd__decap_12
XFILLER_120_525 VGND VGND VPWR VPWR sky130_fd_sc_hd__decap_6
XTAP_TAPCELL_ROW_113_1680 VGND VPWR sky130_fd_sc_hd__tapvpwrvgnd_1
XFILLER_120_569 VPWR VGND VPWR VGND sky130_ef_sc_hd__decap_12
XFILLER_58_141 VGND VGND VPWR VPWR sky130_fd_sc_hd__fill_1
XFILLER_74_601 VGND VGND VPWR VPWR sky130_fd_sc_hd__fill_2
XFILLER_19_528 VGND VGND VPWR VPWR sky130_fd_sc_hd__decap_8
XFILLER_74_645 VGND VGND VPWR VPWR sky130_fd_sc_hd__decap_6
XFILLER_0_29 VGND VGND VPWR VPWR sky130_fd_sc_hd__decap_3
XFILLER_104_83 VGND VGND VPWR VPWR sky130_fd_sc_hd__fill_1
XFILLER_9_27 VPWR VGND VPWR VGND sky130_ef_sc_hd__decap_12
XTAP_TAPCELL_ROW_64_1067 VGND VPWR sky130_fd_sc_hd__tapvpwrvgnd_1
XFILLER_14_288 VPWR VGND VPWR VGND sky130_ef_sc_hd__decap_12
XTAP_TAPCELL_ROW_12_412 VGND VPWR sky130_fd_sc_hd__tapvpwrvgnd_1
XTAP_TAPCELL_ROW_40_765 VGND VPWR sky130_fd_sc_hd__tapvpwrvgnd_1
XTAP_TAPCELL_ROW_116_1709 VGND VPWR sky130_fd_sc_hd__tapvpwrvgnd_1
XFILLER_6_421 VGND VGND VPWR VPWR sky130_fd_sc_hd__fill_1
XFILLER_13_91 VGND VGND VPWR VPWR sky130_fd_sc_hd__decap_3
XPHY_EDGE_ROW_108_Right_108 VGND VGND VPWR VPWR sky130_fd_sc_hd__decap_3
XFILLER_111_503 VGND VGND VPWR VPWR sky130_fd_sc_hd__fill_1
XTAP_TAPCELL_ROW_75_1196 VGND VPWR sky130_fd_sc_hd__tapvpwrvgnd_1
XFILLER_69_417 VPWR VGND VPWR VGND sky130_ef_sc_hd__decap_12
XFILLER_2_693 VGND VGND VPWR VPWR sky130_fd_sc_hd__decap_6
XFILLER_65_623 VGND VGND VPWR VPWR sky130_fd_sc_hd__decap_8
X_5970_ net148 VGND VGND VPWR VPWR _0378_ sky130_fd_sc_hd__inv_2
XTAP_TAPCELL_ROW_48_865 VGND VPWR sky130_fd_sc_hd__tapvpwrvgnd_1
X_4921_ _1817_ _2733_ _2773_ net136 VGND VGND VPWR VPWR _2774_ sky130_fd_sc_hd__o211a_1
X_4852_ _1765_ _2278_ VGND VGND VPWR VPWR _2711_ sky130_fd_sc_hd__nor2_4
X_3803_ reg_file_inst.registry\[9\]\[5\] _1078_ _1088_ VGND VGND VPWR VPWR _1724_
+ sky130_fd_sc_hd__and3_1
X_4783_ _1516_ _2641_ VGND VGND VPWR VPWR _2642_ sky130_fd_sc_hd__nor2_1
X_3734_ _1654_ _1655_ _1656_ _1657_ VGND VGND VPWR VPWR _1658_ sky130_fd_sc_hd__or4_1
X_6522_ clknet_leaf_52_clk _0930_ _0455_ VGND VGND VPWR VPWR net128 sky130_fd_sc_hd__dfrtp_1
X_3665_ reg_file_inst.registry\[8\]\[9\] _1136_ _1139_ reg_file_inst.registry\[5\]\[9\]
+ VGND VGND VPWR VPWR _1591_ sky130_fd_sc_hd__a22o_1
X_6453_ clknet_leaf_10_clk _0861_ _0386_ VGND VGND VPWR VPWR reg_file_inst.registry\[0\]\[14\]
+ sky130_fd_sc_hd__dfrtp_1
XFILLER_9_281 VGND VGND VPWR VPWR sky130_fd_sc_hd__fill_1
XFILLER_109_39 VPWR VGND VPWR VGND sky130_ef_sc_hd__decap_12
X_5404_ reg_file_inst.registry\[4\]\[14\] _2909_ _2997_ VGND VGND VPWR VPWR _0657_
+ sky130_fd_sc_hd__mux2_1
Xclkload51 clknet_leaf_43_clk VGND VGND VPWR VPWR clkload51/Y sky130_fd_sc_hd__inv_6
Xclkload40 clknet_leaf_47_clk VGND VGND VPWR VPWR clkload40/Y sky130_fd_sc_hd__bufinv_16
X_6384_ clknet_leaf_7_clk _0792_ _0317_ VGND VGND VPWR VPWR reg_file_inst.registry\[14\]\[9\]
+ sky130_fd_sc_hd__dfrtp_1
X_3596_ reg_file_inst.registry\[6\]\[11\] _1094_ _1098_ reg_file_inst.registry\[10\]\[11\]
+ VGND VGND VPWR VPWR _1524_ sky130_fd_sc_hd__a22o_1
XFILLER_114_363 VGND VGND VPWR VPWR sky130_fd_sc_hd__fill_1
X_5335_ _2767_ reg_file_inst.registry\[3\]\[25\] _2995_ VGND VGND VPWR VPWR _0724_
+ sky130_fd_sc_hd__mux2_1
X_5266_ reg_file_inst.registry\[14\]\[7\] _2311_ _2992_ VGND VGND VPWR VPWR _0790_
+ sky130_fd_sc_hd__mux2_1
XFILLER_102_569 VPWR VGND VPWR VGND sky130_ef_sc_hd__decap_12
X_4217_ _1964_ _2108_ VGND VGND VPWR VPWR _2109_ sky130_fd_sc_hd__and2b_1
XFILLER_68_483 VPWR VGND VPWR VGND sky130_ef_sc_hd__decap_12
XFILLER_68_472 VGND VGND VPWR VPWR sky130_fd_sc_hd__decap_4
XFILLER_56_601 VPWR VGND VPWR VGND sky130_ef_sc_hd__decap_12
X_5197_ _2986_ reg_file_inst.registry\[0\]\[8\] _2988_ VGND VGND VPWR VPWR _0855_
+ sky130_fd_sc_hd__mux2_1
X_4148_ _1882_ _2052_ VGND VGND VPWR VPWR _2063_ sky130_fd_sc_hd__nor2_1
XFILLER_55_111 VGND VGND VPWR VPWR sky130_fd_sc_hd__fill_1
X_4079_ _0972_ _1061_ _0991_ VGND VGND VPWR VPWR _1995_ sky130_fd_sc_hd__a21o_1
XFILLER_24_553 VGND VGND VPWR VPWR sky130_fd_sc_hd__decap_8
XFILLER_11_225 VGND VGND VPWR VPWR sky130_fd_sc_hd__decap_6
XFILLER_109_113 VPWR VGND VPWR VGND sky130_ef_sc_hd__decap_12
Xclkload1 clknet_3_4__leaf_clk VGND VGND VPWR VPWR clkload1/Y sky130_fd_sc_hd__inv_6
XFILLER_50_23 VGND VGND VPWR VPWR sky130_fd_sc_hd__fill_2
XFILLER_119_3 VPWR VGND VPWR VGND sky130_ef_sc_hd__decap_12
XFILLER_3_413 VGND VGND VPWR VPWR sky130_fd_sc_hd__decap_8
XFILLER_105_341 VGND VGND VPWR VPWR sky130_fd_sc_hd__fill_1
XFILLER_1_3 VPWR VGND VPWR VGND sky130_ef_sc_hd__decap_12
XFILLER_120_333 VPWR VGND VPWR VGND sky130_ef_sc_hd__decap_12
XFILLER_66_409 VGND VGND VPWR VPWR sky130_fd_sc_hd__fill_1
XFILLER_59_98 VPWR VGND VPWR VGND sky130_ef_sc_hd__decap_12
XFILLER_120_377 VPWR VGND VPWR VGND sky130_ef_sc_hd__decap_12
XFILLER_59_483 VGND VGND VPWR VPWR sky130_fd_sc_hd__fill_1
XFILLER_115_93 VPWR VGND VPWR VGND sky130_ef_sc_hd__decap_12
XFILLER_75_53 VGND VGND VPWR VPWR sky130_fd_sc_hd__decap_3
XFILLER_19_325 VGND VGND VPWR VPWR sky130_fd_sc_hd__fill_2
XFILLER_74_464 VPWR VGND VPWR VGND sky130_ef_sc_hd__decap_12
XFILLER_74_486 VPWR VGND VPWR VGND sky130_ef_sc_hd__decap_12
XFILLER_61_125 VGND VGND VPWR VPWR sky130_fd_sc_hd__decap_8
XTAP_TAPCELL_ROW_45_824 VGND VPWR sky130_fd_sc_hd__tapvpwrvgnd_1
XFILLER_91_41 VGND VGND VPWR VPWR sky130_fd_sc_hd__decap_4
XFILLER_61_158 VGND VGND VPWR VPWR sky130_fd_sc_hd__decap_8
XFILLER_27_391 VGND VGND VPWR VPWR sky130_fd_sc_hd__fill_1
XFILLER_30_512 VGND VGND VPWR VPWR sky130_fd_sc_hd__fill_1
XTAP_TAPCELL_ROW_25_581 VGND VPWR sky130_fd_sc_hd__tapvpwrvgnd_1
XFILLER_115_105 VGND VGND VPWR VPWR sky130_fd_sc_hd__decap_6
XTAP_TAPCELL_ROW_77_1225 VGND VPWR sky130_fd_sc_hd__tapvpwrvgnd_1
XFILLER_10_291 VPWR VGND VPWR VGND sky130_ef_sc_hd__decap_12
XFILLER_115_149 VPWR VGND VPWR VGND sky130_ef_sc_hd__decap_12
X_3450_ reg_file_inst.registry\[2\]\[16\] _1137_ _1142_ reg_file_inst.registry\[1\]\[16\]
+ VGND VGND VPWR VPWR _1384_ sky130_fd_sc_hd__a22o_1
X_3381_ reg_file_inst.registry\[5\]\[20\] _1139_ _1308_ _1309_ _1311_ VGND VGND VPWR
+ VPWR _1318_ sky130_fd_sc_hd__a2111o_1
XFILLER_69_225 VGND VGND VPWR VPWR sky130_fd_sc_hd__decap_4
X_5120_ _2944_ _2946_ _2943_ VGND VGND VPWR VPWR _2947_ sky130_fd_sc_hd__o21ba_1
XFILLER_69_269 VGND VGND VPWR VPWR sky130_fd_sc_hd__decap_8
X_5051_ _2642_ _2885_ _2638_ VGND VGND VPWR VPWR _2886_ sky130_fd_sc_hd__o21ai_1
X_4002_ _1917_ net131 _1911_ VGND VGND VPWR VPWR _1918_ sky130_fd_sc_hd__and3b_1
XTAP_TAPCELL_ROW_88_1365 VGND VPWR sky130_fd_sc_hd__tapvpwrvgnd_1
XFILLER_80_401 VPWR VGND VPWR VGND sky130_ef_sc_hd__decap_12
XFILLER_65_453 VGND VGND VPWR VPWR sky130_fd_sc_hd__decap_4
XFILLER_53_615 VGND VGND VPWR VPWR sky130_fd_sc_hd__fill_1
XFILLER_38_689 VGND VGND VPWR VPWR sky130_fd_sc_hd__decap_8
XFILLER_92_272 VPWR VGND VPWR VGND sky130_ef_sc_hd__decap_12
XFILLER_37_177 VGND VGND VPWR VPWR sky130_fd_sc_hd__fill_2
X_5953_ net149 VGND VGND VPWR VPWR _0361_ sky130_fd_sc_hd__inv_2
X_5884_ net147 VGND VGND VPWR VPWR _0292_ sky130_fd_sc_hd__inv_2
X_4904_ _2705_ _2712_ _1817_ VGND VGND VPWR VPWR _2759_ sky130_fd_sc_hd__mux2_1
XFILLER_33_361 VGND VGND VPWR VPWR sky130_fd_sc_hd__decap_4
XFILLER_33_372 VPWR VGND VPWR VGND sky130_ef_sc_hd__decap_12
XFILLER_40_309 VGND VGND VPWR VPWR sky130_fd_sc_hd__decap_6
X_4835_ _1294_ _2203_ _2205_ _1840_ VGND VGND VPWR VPWR _2694_ sky130_fd_sc_hd__a22o_1
X_4766_ _2603_ _2608_ VGND VGND VPWR VPWR _2625_ sky130_fd_sc_hd__nor2_1
X_6505_ clknet_leaf_10_clk _0913_ _0438_ VGND VGND VPWR VPWR reg_file_inst.registry\[11\]\[14\]
+ sky130_fd_sc_hd__dfrtp_1
X_3717_ _1639_ _1640_ _1519_ _1569_ _1622_ VGND VGND VPWR VPWR _1641_ sky130_fd_sc_hd__a2111oi_2
XFILLER_107_617 VPWR VGND VPWR VGND sky130_ef_sc_hd__decap_12
X_4697_ _2186_ _2555_ VGND VGND VPWR VPWR _2556_ sky130_fd_sc_hd__and2_1
X_6436_ clknet_leaf_42_clk _0844_ _0369_ VGND VGND VPWR VPWR reg_file_inst.registry\[11\]\[21\]
+ sky130_fd_sc_hd__dfrtp_1
X_3648_ reg_file_inst.registry\[8\]\[9\] _1090_ _1094_ reg_file_inst.registry\[6\]\[9\]
+ VGND VGND VPWR VPWR _1574_ sky130_fd_sc_hd__a22o_1
XFILLER_20_48 VGND VGND VPWR VPWR sky130_fd_sc_hd__decap_8
X_6367_ clknet_leaf_30_clk _0775_ _0300_ VGND VGND VPWR VPWR reg_file_inst.registry\[2\]\[20\]
+ sky130_fd_sc_hd__dfrtp_1
X_3579_ reg_file_inst.registry\[10\]\[14\] _1126_ _1142_ reg_file_inst.registry\[1\]\[14\]
+ _1505_ VGND VGND VPWR VPWR _1508_ sky130_fd_sc_hd__a221o_1
XFILLER_88_512 VPWR VGND VPWR VGND sky130_ef_sc_hd__decap_12
X_5318_ _2922_ reg_file_inst.registry\[8\]\[13\] _2994_ VGND VGND VPWR VPWR _0740_
+ sky130_fd_sc_hd__mux2_1
XFILLER_0_427 VGND VGND VPWR VPWR sky130_fd_sc_hd__decap_6
X_6298_ clknet_leaf_41_clk _0706_ _0231_ VGND VGND VPWR VPWR reg_file_inst.registry\[3\]\[7\]
+ sky130_fd_sc_hd__dfrtp_1
XFILLER_0_449 VGND VGND VPWR VPWR sky130_fd_sc_hd__fill_1
X_5249_ reg_file_inst.registry\[14\]\[24\] _2787_ _2992_ VGND VGND VPWR VPWR _0807_
+ sky130_fd_sc_hd__mux2_1
XFILLER_88_589 VGND VGND VPWR VPWR sky130_fd_sc_hd__fill_1
XFILLER_29_601 VGND VGND VPWR VPWR sky130_fd_sc_hd__fill_1
XFILLER_90_209 VPWR VGND VPWR VGND sky130_ef_sc_hd__decap_12
XFILLER_56_475 VGND VGND VPWR VPWR sky130_fd_sc_hd__fill_1
XFILLER_71_401 VGND VGND VPWR VPWR sky130_fd_sc_hd__fill_2
XFILLER_56_497 VGND VGND VPWR VPWR sky130_fd_sc_hd__decap_8
XTAP_TAPCELL_ROW_3_298 VGND VPWR sky130_fd_sc_hd__tapvpwrvgnd_1
XFILLER_16_317 VGND VGND VPWR VPWR sky130_fd_sc_hd__decap_4
XFILLER_43_125 VGND VGND VPWR VPWR sky130_fd_sc_hd__fill_2
XFILLER_43_147 VGND VGND VPWR VPWR sky130_fd_sc_hd__decap_6
XFILLER_101_51 VGND VGND VPWR VPWR sky130_fd_sc_hd__decap_4
XFILLER_71_478 VGND VGND VPWR VPWR sky130_fd_sc_hd__decap_8
XFILLER_31_309 VPWR VGND VPWR VGND sky130_ef_sc_hd__decap_12
XFILLER_43_169 VGND VGND VPWR VPWR sky130_fd_sc_hd__decap_4
XTAP_TAPCELL_ROW_61_1026 VGND VPWR sky130_fd_sc_hd__tapvpwrvgnd_1
XFILLER_52_692 VGND VGND VPWR VPWR sky130_fd_sc_hd__decap_8
XFILLER_12_589 VGND VGND VPWR VPWR sky130_fd_sc_hd__fill_1
XTAP_TAPCELL_ROW_22_540 VGND VPWR sky130_fd_sc_hd__tapvpwrvgnd_1
XTAP_TAPCELL_ROW_50_893 VGND VPWR sky130_fd_sc_hd__tapvpwrvgnd_1
XFILLER_113_609 VGND VGND VPWR VPWR sky130_fd_sc_hd__decap_6
XFILLER_98_309 VGND VGND VPWR VPWR sky130_fd_sc_hd__decap_6
XFILLER_3_265 VGND VGND VPWR VPWR sky130_fd_sc_hd__decap_6
XFILLER_121_653 VPWR VGND VPWR VGND sky130_ef_sc_hd__decap_12
XFILLER_105_193 VPWR VGND VPWR VGND sky130_ef_sc_hd__decap_12
XTAP_TAPCELL_ROW_72_1166 VGND VPWR sky130_fd_sc_hd__tapvpwrvgnd_1
XFILLER_121_697 VPWR VGND VPWR VGND sky130_ef_sc_hd__decap_12
XFILLER_120_141 VPWR VGND VPWR VGND sky130_ef_sc_hd__decap_12
XFILLER_86_85 VPWR VGND VPWR VGND sky130_ef_sc_hd__decap_12
XFILLER_74_261 VGND VGND VPWR VPWR sky130_fd_sc_hd__fill_1
XFILLER_62_401 VGND VGND VPWR VPWR sky130_fd_sc_hd__decap_8
XTAP_TAPCELL_ROW_58_993 VGND VPWR sky130_fd_sc_hd__tapvpwrvgnd_1
XFILLER_19_177 VPWR VGND VPWR VGND sky130_ef_sc_hd__decap_12
XFILLER_47_497 VGND VGND VPWR VPWR sky130_fd_sc_hd__decap_6
XFILLER_62_456 VGND VGND VPWR VPWR sky130_fd_sc_hd__decap_4
XFILLER_62_489 VGND VGND VPWR VPWR sky130_fd_sc_hd__decap_4
XFILLER_50_629 VGND VGND VPWR VPWR sky130_fd_sc_hd__decap_3
XFILLER_43_670 VGND VGND VPWR VPWR sky130_fd_sc_hd__fill_2
XFILLER_30_331 VPWR VGND VPWR VGND sky130_ef_sc_hd__decap_12
X_4620_ net136 net134 _2364_ VGND VGND VPWR VPWR _2497_ sky130_fd_sc_hd__and3_1
X_4551_ _2431_ VGND VGND VPWR VPWR _2432_ sky130_fd_sc_hd__inv_2
X_4482_ _1151_ _1841_ _2363_ VGND VGND VPWR VPWR _2367_ sky130_fd_sc_hd__o21ba_1
X_3502_ _1433_ VGND VGND VPWR VPWR _1434_ sky130_fd_sc_hd__inv_2
XFILLER_116_469 VGND VGND VPWR VPWR sky130_fd_sc_hd__decap_6
X_3433_ reg_file_inst.registry\[6\]\[18\] _1135_ _1362_ _1366_ _1367_ VGND VGND VPWR
+ VPWR _1368_ sky130_fd_sc_hd__a2111o_1
X_6221_ clknet_leaf_12_clk _0629_ _0154_ VGND VGND VPWR VPWR reg_file_inst.registry\[10\]\[14\]
+ sky130_fd_sc_hd__dfrtp_1
X_6152_ clknet_leaf_55_clk _0560_ _0085_ VGND VGND VPWR VPWR JMPOFF\[1\] sky130_fd_sc_hd__dfrtp_4
XFILLER_106_29 VPWR VGND VPWR VGND sky130_ef_sc_hd__decap_12
X_3364_ reg_file_inst.registry\[2\]\[20\] _1083_ _1091_ reg_file_inst.registry\[3\]\[20\]
+ VGND VGND VPWR VPWR _1301_ sky130_fd_sc_hd__a22o_1
X_5103_ _2424_ _2930_ _2931_ VGND VGND VPWR VPWR _2932_ sky130_fd_sc_hd__a21o_1
XFILLER_97_364 VGND VGND VPWR VPWR sky130_fd_sc_hd__decap_4
X_3295_ reg_file_inst.registry\[6\]\[23\] _1135_ _1140_ reg_file_inst.registry\[3\]\[23\]
+ VGND VGND VPWR VPWR _1235_ sky130_fd_sc_hd__a22o_1
X_6083_ clknet_leaf_16_clk _0491_ _0016_ VGND VGND VPWR VPWR reg_file_inst.registry\[15\]\[16\]
+ sky130_fd_sc_hd__dfrtp_1
XFILLER_85_559 VGND VGND VPWR VPWR sky130_fd_sc_hd__fill_1
XFILLER_57_228 VPWR VGND VPWR VGND sky130_ef_sc_hd__decap_12
X_5034_ _2176_ _2865_ _2872_ _2721_ _2871_ VGND VGND VPWR VPWR net53 sky130_fd_sc_hd__a221o_1
XFILLER_81_710 VPWR VGND VPWR VGND sky130_ef_sc_hd__decap_12
XFILLER_38_486 VGND VGND VPWR VPWR sky130_fd_sc_hd__decap_3
XFILLER_80_220 VGND VGND VPWR VPWR sky130_fd_sc_hd__decap_8
XTAP_TAPCELL_ROW_0_246 VGND VPWR sky130_fd_sc_hd__tapvpwrvgnd_1
XTAP_TAPCELL_ROW_0_257 VGND VPWR sky130_fd_sc_hd__tapvpwrvgnd_1
XTAP_TAPCELL_ROW_0_268 VGND VPWR sky130_fd_sc_hd__tapvpwrvgnd_1
XFILLER_80_253 VPWR VGND VPWR VGND sky130_ef_sc_hd__decap_12
XFILLER_15_15 VPWR VGND VPWR VGND sky130_ef_sc_hd__decap_12
X_5936_ net146 VGND VGND VPWR VPWR _0344_ sky130_fd_sc_hd__inv_2
XFILLER_41_629 VPWR VGND VPWR VGND sky130_ef_sc_hd__decap_12
XFILLER_40_139 VGND VGND VPWR VPWR sky130_fd_sc_hd__fill_1
X_5867_ net146 VGND VGND VPWR VPWR _0275_ sky130_fd_sc_hd__inv_2
XFILLER_33_191 VGND VGND VPWR VPWR sky130_fd_sc_hd__decap_8
X_5798_ net149 VGND VGND VPWR VPWR _0206_ sky130_fd_sc_hd__inv_2
X_4818_ _1172_ _2567_ VGND VGND VPWR VPWR _2677_ sky130_fd_sc_hd__and2_1
X_4749_ _1566_ _2607_ VGND VGND VPWR VPWR _2608_ sky130_fd_sc_hd__nand2_1
XFILLER_107_447 VGND VGND VPWR VPWR sky130_fd_sc_hd__fill_1
X_6419_ clknet_leaf_16_clk _0827_ _0352_ VGND VGND VPWR VPWR reg_file_inst.registry\[1\]\[16\]
+ sky130_fd_sc_hd__dfrtp_1
XFILLER_122_417 VGND VGND VPWR VPWR sky130_fd_sc_hd__decap_3
Xoutput47 net47 VGND VGND VPWR VPWR DataAddress[11] sky130_fd_sc_hd__buf_1
Xoutput58 net58 VGND VGND VPWR VPWR DataAddress[21] sky130_fd_sc_hd__buf_1
XFILLER_1_725 VGND VGND VPWR VPWR sky130_fd_sc_hd__fill_1
XFILLER_103_653 VPWR VGND VPWR VGND sky130_ef_sc_hd__decap_12
XFILLER_88_342 VPWR VGND VPWR VGND sky130_ef_sc_hd__decap_12
XTAP_TAPCELL_ROW_8_368 VGND VPWR sky130_fd_sc_hd__tapvpwrvgnd_1
Xoutput69 net69 VGND VGND VPWR VPWR DataAddress[6] sky130_fd_sc_hd__buf_1
XFILLER_102_141 VGND VGND VPWR VPWR sky130_fd_sc_hd__decap_8
XFILLER_0_279 VGND VGND VPWR VPWR sky130_fd_sc_hd__fill_1
XFILLER_48_206 VGND VGND VPWR VPWR sky130_fd_sc_hd__fill_2
XFILLER_103_697 VPWR VGND VPWR VGND sky130_ef_sc_hd__decap_12
XFILLER_102_174 VPWR VGND VPWR VGND sky130_ef_sc_hd__decap_12
XFILLER_88_397 VGND VGND VPWR VPWR sky130_fd_sc_hd__decap_3
XFILLER_56_22 VGND VGND VPWR VPWR sky130_fd_sc_hd__decap_6
XFILLER_71_220 VGND VGND VPWR VPWR sky130_fd_sc_hd__decap_4
XTAP_TAPCELL_ROW_55_952 VGND VPWR sky130_fd_sc_hd__tapvpwrvgnd_1
XFILLER_44_445 VPWR VGND VPWR VGND sky130_ef_sc_hd__decap_12
XFILLER_112_83 VGND VGND VPWR VPWR sky130_fd_sc_hd__fill_1
XFILLER_72_43 VGND VGND VPWR VPWR sky130_fd_sc_hd__fill_2
XFILLER_31_106 VGND VGND VPWR VPWR sky130_fd_sc_hd__decap_6
XFILLER_72_65 VGND VGND VPWR VPWR sky130_fd_sc_hd__decap_4
XFILLER_25_681 VGND VGND VPWR VPWR sky130_fd_sc_hd__decap_8
XFILLER_31_139 VPWR VGND VPWR VGND sky130_ef_sc_hd__decap_12
XFILLER_72_98 VGND VGND VPWR VPWR sky130_fd_sc_hd__fill_1
XFILLER_12_331 VGND VGND VPWR VPWR sky130_fd_sc_hd__fill_1
XFILLER_8_324 VGND VGND VPWR VPWR sky130_fd_sc_hd__fill_2
XFILLER_113_417 VPWR VGND VPWR VGND sky130_ef_sc_hd__decap_12
XFILLER_99_629 VPWR VGND VPWR VGND sky130_ef_sc_hd__decap_12
XFILLER_121_461 VPWR VGND VPWR VGND sky130_ef_sc_hd__decap_12
XFILLER_67_526 VGND VGND VPWR VPWR sky130_fd_sc_hd__decap_8
X_3080_ _0995_ _1023_ _0993_ _0994_ VGND VGND VPWR VPWR _1024_ sky130_fd_sc_hd__o211a_1
XTAP_TAPCELL_ROW_85_1324 VGND VPWR sky130_fd_sc_hd__tapvpwrvgnd_1
XFILLER_62_231 VGND VGND VPWR VPWR sky130_fd_sc_hd__fill_1
XFILLER_35_445 VGND VGND VPWR VPWR sky130_fd_sc_hd__decap_3
X_3982_ _1042_ _1049_ _1886_ VGND VGND VPWR VPWR _1898_ sky130_fd_sc_hd__nand3_1
X_5721_ net147 VGND VGND VPWR VPWR _0129_ sky130_fd_sc_hd__inv_2
XTAP_TAPCELL_ROW_33_679 VGND VPWR sky130_fd_sc_hd__tapvpwrvgnd_1
X_5652_ net146 VGND VGND VPWR VPWR _0060_ sky130_fd_sc_hd__inv_2
XFILLER_31_673 VGND VGND VPWR VPWR sky130_fd_sc_hd__fill_2
X_5583_ reg_file_inst.registry\[15\]\[9\] _2974_ _3003_ VGND VGND VPWR VPWR _0484_
+ sky130_fd_sc_hd__mux2_1
X_4603_ net135 _2479_ _1790_ VGND VGND VPWR VPWR _2480_ sky130_fd_sc_hd__a21o_1
X_4534_ _2253_ _2401_ _2402_ _2396_ VGND VGND VPWR VPWR _2417_ sky130_fd_sc_hd__a31o_1
XFILLER_116_233 VPWR VGND VPWR VGND sky130_ef_sc_hd__decap_12
XTAP_TAPCELL_ROW_96_1464 VGND VPWR sky130_fd_sc_hd__tapvpwrvgnd_1
XFILLER_117_39 VPWR VGND VPWR VGND sky130_ef_sc_hd__decap_12
XFILLER_116_277 VPWR VGND VPWR VGND sky130_ef_sc_hd__decap_12
XFILLER_104_417 VGND VGND VPWR VPWR sky130_fd_sc_hd__decap_3
X_4465_ _2336_ _2349_ net133 VGND VGND VPWR VPWR _2350_ sky130_fd_sc_hd__mux2_1
X_6204_ clknet_leaf_22_clk _0612_ _0137_ VGND VGND VPWR VPWR reg_file_inst.registry\[5\]\[25\]
+ sky130_fd_sc_hd__dfrtp_1
X_3416_ reg_file_inst.registry\[14\]\[18\] _1081_ _1348_ net139 VGND VGND VPWR VPWR
+ _1351_ sky130_fd_sc_hd__a211o_1
X_4396_ net43 _2127_ _2251_ _2281_ VGND VGND VPWR VPWR _2284_ sky130_fd_sc_hd__and4_4
XFILLER_100_601 VPWR VGND VPWR VGND sky130_ef_sc_hd__decap_12
XFILLER_97_161 VGND VGND VPWR VPWR sky130_fd_sc_hd__decap_6
X_3347_ reg_file_inst.registry\[7\]\[21\] _1119_ _1132_ VGND VGND VPWR VPWR _1285_
+ sky130_fd_sc_hd__and3_1
X_6135_ clknet_leaf_10_clk _0543_ _0068_ VGND VGND VPWR VPWR reg_file_inst.registry\[6\]\[12\]
+ sky130_fd_sc_hd__dfrtp_1
XFILLER_58_504 VPWR VGND VPWR VGND sky130_ef_sc_hd__decap_12
XTAP_TAPCELL_ROW_5_327 VGND VPWR sky130_fd_sc_hd__tapvpwrvgnd_1
XFILLER_100_645 VPWR VGND VPWR VGND sky130_ef_sc_hd__decap_12
X_6066_ net146 VGND VGND VPWR VPWR _0474_ sky130_fd_sc_hd__inv_2
XFILLER_58_548 VGND VGND VPWR VPWR sky130_fd_sc_hd__decap_4
X_3278_ _1207_ _1217_ VGND VGND VPWR VPWR _1218_ sky130_fd_sc_hd__nand2_1
X_5017_ _1357_ _1369_ _2289_ _2857_ VGND VGND VPWR VPWR _2858_ sky130_fd_sc_hd__a2bb2o_1
XPHY_EDGE_ROW_116_Left_239 VGND VGND VPWR VPWR sky130_fd_sc_hd__decap_3
XFILLER_38_283 VPWR VGND VPWR VGND sky130_ef_sc_hd__decap_12
XFILLER_81_573 VGND VGND VPWR VPWR sky130_fd_sc_hd__decap_8
XFILLER_81_551 VGND VGND VPWR VPWR sky130_fd_sc_hd__decap_8
XTAP_TAPCELL_ROW_52_911 VGND VPWR sky130_fd_sc_hd__tapvpwrvgnd_1
XFILLER_26_489 VGND VGND VPWR VPWR sky130_fd_sc_hd__fill_1
XTAP_TAPCELL_ROW_105_1582 VGND VPWR sky130_fd_sc_hd__tapvpwrvgnd_1
XTAP_TAPCELL_ROW_105_1571 VGND VPWR sky130_fd_sc_hd__tapvpwrvgnd_1
XFILLER_53_297 VPWR VGND VPWR VGND sky130_ef_sc_hd__decap_12
XFILLER_13_128 VGND VGND VPWR VPWR sky130_fd_sc_hd__decap_4
X_5919_ net147 VGND VGND VPWR VPWR _0327_ sky130_fd_sc_hd__inv_2
XFILLER_22_640 VGND VGND VPWR VPWR sky130_fd_sc_hd__decap_4
XFILLER_21_161 VGND VGND VPWR VPWR sky130_fd_sc_hd__decap_4
XFILLER_42_57 VGND VGND VPWR VPWR sky130_fd_sc_hd__decap_4
XFILLER_108_701 VPWR VGND VPWR VGND sky130_ef_sc_hd__decap_12
XFILLER_5_349 VPWR VGND VPWR VGND sky130_ef_sc_hd__decap_12
XFILLER_101_3 VPWR VGND VPWR VGND sky130_ef_sc_hd__decap_12
XFILLER_122_225 VPWR VGND VPWR VGND sky130_ef_sc_hd__decap_12
XFILLER_103_461 VGND VGND VPWR VPWR sky130_fd_sc_hd__fill_1
XFILLER_89_673 VPWR VGND VPWR VGND sky130_ef_sc_hd__decap_12
XFILLER_88_194 VGND VGND VPWR VPWR sky130_fd_sc_hd__fill_2
XFILLER_91_304 VPWR VGND VPWR VGND sky130_ef_sc_hd__decap_12
XFILLER_76_389 VPWR VGND VPWR VGND sky130_ef_sc_hd__decap_12
XFILLER_29_250 VPWR VGND VPWR VGND sky130_ef_sc_hd__decap_12
XFILLER_91_337 VGND VGND VPWR VPWR sky130_fd_sc_hd__decap_8
XFILLER_60_713 VGND VGND VPWR VPWR sky130_fd_sc_hd__decap_8
XFILLER_17_456 VGND VGND VPWR VPWR sky130_fd_sc_hd__decap_6
XTAP_TAPCELL_ROW_67_1098 VGND VPWR sky130_fd_sc_hd__tapvpwrvgnd_1
XFILLER_13_662 VGND VGND VPWR VPWR sky130_fd_sc_hd__decap_8
XTAP_TAPCELL_ROW_80_1265 VGND VPWR sky130_fd_sc_hd__tapvpwrvgnd_1
XFILLER_8_110 VGND VGND VPWR VPWR sky130_fd_sc_hd__decap_4
XFILLER_13_673 VGND VGND VPWR VPWR sky130_fd_sc_hd__decap_6
XTAP_TAPCELL_ROW_30_638 VGND VPWR sky130_fd_sc_hd__tapvpwrvgnd_1
XFILLER_8_154 VPWR VGND VPWR VGND sky130_ef_sc_hd__decap_12
XTAP_TAPCELL_ROW_10_395 VGND VPWR sky130_fd_sc_hd__tapvpwrvgnd_1
XTAP_TAPCELL_ROW_10_384 VGND VPWR sky130_fd_sc_hd__tapvpwrvgnd_1
XFILLER_113_225 VPWR VGND VPWR VGND sky130_ef_sc_hd__decap_12
X_4250_ _1679_ _2132_ VGND VGND VPWR VPWR _2138_ sky130_fd_sc_hd__xnor2_1
X_3201_ JMPOFF\[27\] _1130_ _1141_ reg_file_inst.registry\[11\]\[27\] _1117_ VGND
+ VGND VPWR VPWR _1145_ sky130_fd_sc_hd__a221o_1
X_4181_ _1897_ _2085_ _1896_ VGND VGND VPWR VPWR _2086_ sky130_fd_sc_hd__o21ba_1
X_3132_ net40 net41 _1074_ VGND VGND VPWR VPWR _1076_ sky130_fd_sc_hd__or3b_4
XFILLER_95_665 VGND VGND VPWR VPWR sky130_fd_sc_hd__decap_6
XFILLER_94_186 VGND VGND VPWR VPWR sky130_fd_sc_hd__decap_8
XFILLER_94_164 VGND VGND VPWR VPWR sky130_fd_sc_hd__decap_6
X_3063_ _0954_ _1006_ VGND VGND VPWR VPWR _1007_ sky130_fd_sc_hd__or2_1
XTAP_TAPCELL_ROW_38_738 VGND VPWR sky130_fd_sc_hd__tapvpwrvgnd_1
XFILLER_94_197 VPWR VGND VPWR VGND sky130_ef_sc_hd__decap_12
XFILLER_63_551 VGND VGND VPWR VPWR sky130_fd_sc_hd__decap_8
XTAP_TAPCELL_ROW_18_484 VGND VPWR sky130_fd_sc_hd__tapvpwrvgnd_1
XTAP_TAPCELL_ROW_18_495 VGND VPWR sky130_fd_sc_hd__tapvpwrvgnd_1
X_3965_ _0980_ _1069_ _1071_ VGND VGND VPWR VPWR _1881_ sky130_fd_sc_hd__nand3_1
XFILLER_50_256 VPWR VGND VPWR VGND sky130_ef_sc_hd__decap_12
XFILLER_10_109 VGND VGND VPWR VPWR sky130_fd_sc_hd__decap_6
X_5704_ net149 VGND VGND VPWR VPWR _0112_ sky130_fd_sc_hd__inv_2
X_3896_ reg_file_inst.registry\[7\]\[1\] _1086_ _1804_ _1805_ _1813_ VGND VGND VPWR
+ VPWR _1814_ sky130_fd_sc_hd__a2111o_1
X_5635_ net44 VGND VGND VPWR VPWR _0043_ sky130_fd_sc_hd__inv_2
XFILLER_117_553 VGND VGND VPWR VPWR sky130_fd_sc_hd__decap_6
X_5566_ reg_file_inst.registry\[15\]\[26\] _2747_ _3003_ VGND VGND VPWR VPWR _0501_
+ sky130_fd_sc_hd__mux2_1
XFILLER_117_597 VPWR VGND VPWR VGND sky130_ef_sc_hd__decap_12
X_4517_ _1765_ _2399_ _2236_ VGND VGND VPWR VPWR _2400_ sky130_fd_sc_hd__a21oi_1
X_5497_ JMPOFF\[8\] _2986_ _3000_ VGND VGND VPWR VPWR _0567_ sky130_fd_sc_hd__mux2_1
X_4448_ _2331_ _2332_ VGND VGND VPWR VPWR _2333_ sky130_fd_sc_hd__nor2_1
X_4379_ _1751_ _2190_ VGND VGND VPWR VPWR _2267_ sky130_fd_sc_hd__and2_1
X_6118_ clknet_leaf_33_clk _0526_ _0051_ VGND VGND VPWR VPWR reg_file_inst.registry\[9\]\[23\]
+ sky130_fd_sc_hd__dfrtp_1
XFILLER_86_643 VGND VGND VPWR VPWR sky130_fd_sc_hd__fill_1
XFILLER_58_345 VGND VGND VPWR VPWR sky130_fd_sc_hd__decap_6
XTAP_TAPCELL_ROW_107_1600 VGND VPWR sky130_fd_sc_hd__tapvpwrvgnd_1
XFILLER_85_164 VGND VGND VPWR VPWR sky130_fd_sc_hd__decap_4
X_6049_ net146 VGND VGND VPWR VPWR _0457_ sky130_fd_sc_hd__inv_2
XFILLER_37_57 VPWR VGND VPWR VGND sky130_ef_sc_hd__decap_12
XFILLER_73_337 VGND VGND VPWR VPWR sky130_fd_sc_hd__decap_8
XFILLER_26_253 VGND VGND VPWR VPWR sky130_fd_sc_hd__fill_1
XFILLER_14_426 VPWR VGND VPWR VGND sky130_ef_sc_hd__decap_12
XFILLER_26_275 VGND VGND VPWR VPWR sky130_fd_sc_hd__fill_1
XFILLER_10_643 VGND VGND VPWR VPWR sky130_fd_sc_hd__fill_1
XFILLER_6_625 VPWR VGND VPWR VGND sky130_ef_sc_hd__decap_12
XFILLER_5_113 VGND VGND VPWR VPWR sky130_fd_sc_hd__decap_8
XTAP_TAPCELL_ROW_118_1740 VGND VPWR sky130_fd_sc_hd__tapvpwrvgnd_1
XFILLER_108_531 VGND VGND VPWR VPWR sky130_fd_sc_hd__fill_1
XFILLER_6_669 VPWR VGND VPWR VGND sky130_ef_sc_hd__decap_12
XFILLER_78_97 VPWR VGND VPWR VGND sky130_ef_sc_hd__decap_12
XFILLER_92_613 VPWR VGND VPWR VGND sky130_ef_sc_hd__decap_12
XTAP_TAPCELL_ROW_69_1127 VGND VPWR sky130_fd_sc_hd__tapvpwrvgnd_1
XFILLER_94_85 VGND VGND VPWR VPWR sky130_fd_sc_hd__fill_2
XFILLER_92_657 VPWR VGND VPWR VGND sky130_ef_sc_hd__decap_12
XFILLER_76_197 VPWR VGND VPWR VGND sky130_ef_sc_hd__decap_12
XFILLER_18_721 VGND VGND VPWR VPWR sky130_fd_sc_hd__fill_2
XFILLER_17_297 VGND VGND VPWR VPWR sky130_fd_sc_hd__fill_1
XFILLER_60_565 VGND VGND VPWR VPWR sky130_fd_sc_hd__fill_2
XFILLER_60_576 VPWR VGND VPWR VGND sky130_ef_sc_hd__decap_12
XTAP_TAPCELL_ROW_15_454 VGND VPWR sky130_fd_sc_hd__tapvpwrvgnd_1
XTAP_TAPCELL_ROW_43_796 VGND VPWR sky130_fd_sc_hd__tapvpwrvgnd_1
X_3750_ reg_file_inst.registry\[3\]\[6\] _1091_ _1671_ _1672_ net140 VGND VGND VPWR
+ VPWR _1673_ sky130_fd_sc_hd__a2111o_1
X_3681_ _1595_ _1603_ _1604_ _1605_ VGND VGND VPWR VPWR _1606_ sky130_fd_sc_hd__or4_1
X_5420_ _2715_ reg_file_inst.registry\[10\]\[27\] _2998_ VGND VGND VPWR VPWR _0642_
+ sky130_fd_sc_hd__mux2_1
XFILLER_114_501 VPWR VGND VPWR VGND sky130_ef_sc_hd__decap_12
XTAP_TAPCELL_ROW_93_1423 VGND VPWR sky130_fd_sc_hd__tapvpwrvgnd_1
X_5351_ _2974_ reg_file_inst.registry\[3\]\[9\] _2995_ VGND VGND VPWR VPWR _0708_
+ sky130_fd_sc_hd__mux2_1
XFILLER_114_545 VPWR VGND VPWR VGND sky130_ef_sc_hd__decap_12
X_5282_ _2842_ reg_file_inst.registry\[2\]\[20\] _2993_ VGND VGND VPWR VPWR _0775_
+ sky130_fd_sc_hd__mux2_1
X_4302_ _2180_ _2182_ _2184_ _2189_ VGND VGND VPWR VPWR _2190_ sky130_fd_sc_hd__and4_4
X_4233_ _2116_ _2120_ VGND VGND VPWR VPWR _2121_ sky130_fd_sc_hd__nor2_1
XFILLER_114_589 VPWR VGND VPWR VGND sky130_ef_sc_hd__decap_12
XFILLER_4_83 VGND VGND VPWR VPWR sky130_fd_sc_hd__fill_1
XFILLER_114_29 VPWR VGND VPWR VGND sky130_ef_sc_hd__decap_12
X_4164_ _2073_ net115 net130 VGND VGND VPWR VPWR _0943_ sky130_fd_sc_hd__mux2_1
X_4095_ net131 _2006_ _2010_ VGND VGND VPWR VPWR _2011_ sky130_fd_sc_hd__and3_1
X_3115_ JMPOFF\[16\] net141 net41 VGND VGND VPWR VPWR _1059_ sky130_fd_sc_hd__a21o_1
X_3046_ JMPOFF\[17\] net141 net41 VGND VGND VPWR VPWR _0990_ sky130_fd_sc_hd__a21oi_1
XFILLER_55_337 VGND VGND VPWR VPWR sky130_fd_sc_hd__fill_2
XFILLER_70_318 VGND VGND VPWR VPWR sky130_fd_sc_hd__decap_4
XFILLER_36_540 VGND VGND VPWR VPWR sky130_fd_sc_hd__decap_3
XFILLER_36_573 VPWR VGND VPWR VGND sky130_ef_sc_hd__decap_12
XFILLER_23_245 VGND VGND VPWR VPWR sky130_fd_sc_hd__decap_8
XTAP_TAPCELL_ROW_102_1541 VGND VPWR sky130_fd_sc_hd__tapvpwrvgnd_1
XFILLER_51_598 VGND VGND VPWR VPWR sky130_fd_sc_hd__fill_2
X_4997_ _2176_ _2788_ _2830_ _2841_ VGND VGND VPWR VPWR net57 sky130_fd_sc_hd__a31o_1
X_3948_ _1152_ _1162_ _1171_ _1151_ _1109_ VGND VGND VPWR VPWR _1864_ sky130_fd_sc_hd__o32a_1
XFILLER_109_317 VPWR VGND VPWR VGND sky130_ef_sc_hd__decap_12
X_3879_ reg_file_inst.registry\[14\]\[2\] _1138_ _1140_ reg_file_inst.registry\[3\]\[2\]
+ VGND VGND VPWR VPWR _1798_ sky130_fd_sc_hd__a22o_1
X_5618_ net148 VGND VGND VPWR VPWR _0026_ sky130_fd_sc_hd__inv_2
XFILLER_117_361 VPWR VGND VPWR VGND sky130_ef_sc_hd__decap_12
X_5549_ _2909_ reg_file_inst.registry\[9\]\[14\] _3002_ VGND VGND VPWR VPWR _0517_
+ sky130_fd_sc_hd__mux2_1
XFILLER_3_617 VPWR VGND VPWR VGND sky130_ef_sc_hd__decap_12
XFILLER_78_418 VGND VGND VPWR VPWR sky130_fd_sc_hd__fill_2
XTAP_TAPCELL_ROW_113_1681 VGND VPWR sky130_fd_sc_hd__tapvpwrvgnd_1
XFILLER_48_67 VPWR VGND VPWR VGND sky130_ef_sc_hd__decap_12
XFILLER_73_134 VGND VGND VPWR VPWR sky130_fd_sc_hd__fill_1
XFILLER_58_197 VPWR VGND VPWR VGND sky130_ef_sc_hd__decap_12
XFILLER_0_19 VGND VGND VPWR VPWR sky130_fd_sc_hd__fill_2
XFILLER_73_167 VGND VGND VPWR VPWR sky130_fd_sc_hd__fill_1
XFILLER_73_189 VPWR VGND VPWR VGND sky130_ef_sc_hd__decap_12
XFILLER_14_245 VGND VGND VPWR VPWR sky130_fd_sc_hd__fill_1
XFILLER_120_83 VGND VGND VPWR VPWR sky130_fd_sc_hd__fill_1
XTAP_TAPCELL_ROW_64_1068 VGND VPWR sky130_fd_sc_hd__tapvpwrvgnd_1
XFILLER_9_39 VPWR VGND VPWR VGND sky130_ef_sc_hd__decap_12
XTAP_TAPCELL_ROW_12_413 VGND VPWR sky130_fd_sc_hd__tapvpwrvgnd_1
XFILLER_6_411 VGND VGND VPWR VPWR sky130_fd_sc_hd__fill_1
XTAP_TAPCELL_ROW_40_766 VGND VPWR sky130_fd_sc_hd__tapvpwrvgnd_1
XFILLER_89_96 VPWR VGND VPWR VGND sky130_ef_sc_hd__decap_12
XFILLER_69_407 VGND VGND VPWR VPWR sky130_fd_sc_hd__fill_1
XFILLER_96_237 VPWR VGND VPWR VGND sky130_ef_sc_hd__decap_12
XTAP_TAPCELL_ROW_75_1197 VGND VPWR sky130_fd_sc_hd__tapvpwrvgnd_1
XFILLER_69_429 VPWR VGND VPWR VGND sky130_ef_sc_hd__decap_12
XFILLER_111_559 VGND VGND VPWR VPWR sky130_fd_sc_hd__fill_1
XFILLER_37_315 VGND VGND VPWR VPWR sky130_fd_sc_hd__decap_3
XFILLER_52_307 VGND VGND VPWR VPWR sky130_fd_sc_hd__fill_1
XTAP_TAPCELL_ROW_48_866 VGND VPWR sky130_fd_sc_hd__tapvpwrvgnd_1
XFILLER_80_627 VPWR VGND VPWR VGND sky130_ef_sc_hd__decap_12
XFILLER_52_329 VGND VGND VPWR VPWR sky130_fd_sc_hd__decap_4
X_4920_ _1816_ _2731_ VGND VGND VPWR VPWR _2773_ sky130_fd_sc_hd__or2_1
XFILLER_45_370 VPWR VGND VPWR VGND sky130_ef_sc_hd__decap_12
X_4851_ _2706_ _2709_ _1790_ VGND VGND VPWR VPWR _2710_ sky130_fd_sc_hd__mux2_1
XFILLER_33_532 VGND VGND VPWR VPWR sky130_fd_sc_hd__decap_4
X_3802_ _1708_ _1721_ VGND VGND VPWR VPWR _1723_ sky130_fd_sc_hd__xnor2_1
X_4782_ _1504_ _2640_ VGND VGND VPWR VPWR _2641_ sky130_fd_sc_hd__xor2_1
XFILLER_119_615 VGND VGND VPWR VPWR sky130_fd_sc_hd__fill_1
X_3733_ reg_file_inst.registry\[15\]\[7\] _1119_ _1121_ VGND VGND VPWR VPWR _1657_
+ sky130_fd_sc_hd__and3_1
X_6521_ clknet_leaf_52_clk _0929_ _0454_ VGND VGND VPWR VPWR net127 sky130_fd_sc_hd__dfrtp_1
X_3664_ reg_file_inst.registry\[10\]\[9\] _1126_ _1133_ reg_file_inst.registry\[7\]\[9\]
+ VGND VGND VPWR VPWR _1590_ sky130_fd_sc_hd__a22o_1
X_6452_ clknet_leaf_2_clk _0860_ _0385_ VGND VGND VPWR VPWR reg_file_inst.registry\[0\]\[13\]
+ sky130_fd_sc_hd__dfrtp_1
XFILLER_106_309 VPWR VGND VPWR VGND sky130_ef_sc_hd__decap_12
Xclkload52 clknet_leaf_34_clk VGND VGND VPWR VPWR clkload52/Y sky130_fd_sc_hd__inv_6
Xclkload30 clknet_leaf_24_clk VGND VGND VPWR VPWR clkload30/Y sky130_fd_sc_hd__inv_6
X_5403_ reg_file_inst.registry\[4\]\[15\] _2897_ _2997_ VGND VGND VPWR VPWR _0658_
+ sky130_fd_sc_hd__mux2_1
Xclkload41 clknet_leaf_48_clk VGND VGND VPWR VPWR clkload41/Y sky130_fd_sc_hd__clkinvlp_4
X_6383_ clknet_leaf_55_clk _0791_ _0316_ VGND VGND VPWR VPWR reg_file_inst.registry\[14\]\[8\]
+ sky130_fd_sc_hd__dfrtp_1
X_3595_ reg_file_inst.registry\[11\]\[11\] _1096_ _1521_ _1522_ net140 VGND VGND VPWR
+ VPWR _1523_ sky130_fd_sc_hd__a2111o_1
X_5334_ _2747_ reg_file_inst.registry\[3\]\[26\] _2995_ VGND VGND VPWR VPWR _0725_
+ sky130_fd_sc_hd__mux2_1
XFILLER_102_526 VGND VGND VPWR VPWR sky130_fd_sc_hd__decap_6
X_5265_ reg_file_inst.registry\[14\]\[8\] _2986_ _2992_ VGND VGND VPWR VPWR _0791_
+ sky130_fd_sc_hd__mux2_1
X_5196_ _2974_ reg_file_inst.registry\[0\]\[9\] _2988_ VGND VGND VPWR VPWR _0856_
+ sky130_fd_sc_hd__mux2_1
X_4216_ _1961_ _1963_ VGND VGND VPWR VPWR _2108_ sky130_fd_sc_hd__nand2_1
X_4147_ _2062_ net121 net130 VGND VGND VPWR VPWR _0949_ sky130_fd_sc_hd__mux2_1
XFILLER_56_613 VPWR VGND VPWR VGND sky130_ef_sc_hd__decap_12
XFILLER_18_15 VPWR VGND VPWR VGND sky130_ef_sc_hd__decap_12
XFILLER_110_581 VGND VGND VPWR VPWR sky130_fd_sc_hd__decap_6
XFILLER_68_495 VGND VGND VPWR VPWR sky130_fd_sc_hd__fill_1
X_4078_ _0972_ _0991_ _1061_ VGND VGND VPWR VPWR _1994_ sky130_fd_sc_hd__nand3_1
XFILLER_55_167 VGND VGND VPWR VPWR sky130_fd_sc_hd__fill_1
X_3029_ JMPOFF\[17\] JMPOFF\[16\] _0967_ VGND VGND VPWR VPWR _0973_ sky130_fd_sc_hd__o21ai_1
XFILLER_7_219 VGND VGND VPWR VPWR sky130_fd_sc_hd__decap_4
Xclkload2 clknet_3_5__leaf_clk VGND VGND VPWR VPWR clkload2/X sky130_fd_sc_hd__clkbuf_2
XFILLER_109_125 VPWR VGND VPWR VGND sky130_ef_sc_hd__decap_12
XFILLER_109_169 VPWR VGND VPWR VGND sky130_ef_sc_hd__decap_12
XFILLER_50_68 VGND VGND VPWR VPWR sky130_fd_sc_hd__decap_3
XFILLER_50_79 VGND VGND VPWR VPWR sky130_fd_sc_hd__decap_4
XFILLER_118_681 VPWR VGND VPWR VGND sky130_ef_sc_hd__decap_12
XFILLER_3_447 VGND VGND VPWR VPWR sky130_fd_sc_hd__fill_1
XFILLER_120_301 VGND VGND VPWR VPWR sky130_fd_sc_hd__decap_6
XFILLER_59_66 VGND VGND VPWR VPWR sky130_fd_sc_hd__decap_6
XFILLER_120_345 VPWR VGND VPWR VGND sky130_ef_sc_hd__decap_12
XFILLER_120_389 VPWR VGND VPWR VGND sky130_ef_sc_hd__decap_12
XFILLER_59_473 VGND VGND VPWR VPWR sky130_fd_sc_hd__fill_1
XFILLER_19_337 VPWR VGND VPWR VGND sky130_ef_sc_hd__decap_12
XFILLER_47_679 VPWR VGND VPWR VGND sky130_ef_sc_hd__decap_12
XFILLER_74_498 VPWR VGND VPWR VGND sky130_ef_sc_hd__decap_12
XFILLER_34_329 VGND VGND VPWR VPWR sky130_fd_sc_hd__decap_8
XTAP_TAPCELL_ROW_45_825 VGND VPWR sky130_fd_sc_hd__tapvpwrvgnd_1
XFILLER_91_31 VGND VGND VPWR VPWR sky130_fd_sc_hd__fill_1
XFILLER_55_690 VPWR VGND VPWR VGND sky130_ef_sc_hd__decap_12
XFILLER_15_565 VPWR VGND VPWR VGND sky130_ef_sc_hd__decap_12
XTAP_TAPCELL_ROW_25_571 VGND VPWR sky130_fd_sc_hd__tapvpwrvgnd_1
XTAP_TAPCELL_ROW_25_582 VGND VPWR sky130_fd_sc_hd__tapvpwrvgnd_1
XTAP_TAPCELL_ROW_77_1226 VGND VPWR sky130_fd_sc_hd__tapvpwrvgnd_1
XFILLER_6_241 VGND VGND VPWR VPWR sky130_fd_sc_hd__decap_8
X_3380_ reg_file_inst.registry\[14\]\[20\] _1138_ _1310_ _1312_ _1313_ VGND VGND VPWR
+ VPWR _1317_ sky130_fd_sc_hd__a2111o_1
X_5050_ _2644_ _2884_ VGND VGND VPWR VPWR _2885_ sky130_fd_sc_hd__and2b_1
XFILLER_27_3 VGND VGND VPWR VPWR sky130_fd_sc_hd__decap_8
X_4001_ _1033_ _1036_ _1054_ VGND VGND VPWR VPWR _1917_ sky130_fd_sc_hd__and3_1
XFILLER_77_281 VGND VGND VPWR VPWR sky130_fd_sc_hd__decap_6
XTAP_TAPCELL_ROW_88_1366 VGND VPWR sky130_fd_sc_hd__tapvpwrvgnd_1
XFILLER_1_51 VGND VGND VPWR VPWR sky130_fd_sc_hd__decap_4
X_5952_ net146 VGND VGND VPWR VPWR _0360_ sky130_fd_sc_hd__inv_2
XFILLER_92_284 VPWR VGND VPWR VGND sky130_ef_sc_hd__decap_12
XFILLER_80_413 VGND VGND VPWR VPWR sky130_fd_sc_hd__decap_6
XFILLER_65_498 VGND VGND VPWR VPWR sky130_fd_sc_hd__decap_6
XFILLER_65_476 VGND VGND VPWR VPWR sky130_fd_sc_hd__fill_2
XFILLER_1_95 VPWR VGND VPWR VGND sky130_ef_sc_hd__decap_12
X_4903_ _2692_ _2695_ _1816_ VGND VGND VPWR VPWR _2758_ sky130_fd_sc_hd__mux2_1
XFILLER_18_381 VPWR VGND VPWR VGND sky130_ef_sc_hd__decap_12
XFILLER_61_671 VGND VGND VPWR VPWR sky130_fd_sc_hd__fill_1
X_5883_ net147 VGND VGND VPWR VPWR _0291_ sky130_fd_sc_hd__inv_2
X_4834_ _1817_ _2692_ _2691_ net136 VGND VGND VPWR VPWR _2693_ sky130_fd_sc_hd__o211a_1
XFILLER_33_384 VGND VGND VPWR VPWR sky130_fd_sc_hd__decap_8
X_4765_ _2609_ _2623_ VGND VGND VPWR VPWR _2624_ sky130_fd_sc_hd__nand2_1
X_6504_ clknet_leaf_4_clk _0912_ _0437_ VGND VGND VPWR VPWR reg_file_inst.registry\[11\]\[13\]
+ sky130_fd_sc_hd__dfrtp_1
X_3716_ _1607_ _1620_ VGND VGND VPWR VPWR _1640_ sky130_fd_sc_hd__or2_1
XFILLER_107_629 VPWR VGND VPWR VGND sky130_ef_sc_hd__decap_12
X_4696_ _1581_ _2554_ VGND VGND VPWR VPWR _2555_ sky130_fd_sc_hd__nor2_2
XFILLER_106_139 VGND VGND VPWR VPWR sky130_fd_sc_hd__fill_1
X_6435_ clknet_leaf_43_clk _0843_ _0368_ VGND VGND VPWR VPWR reg_file_inst.registry\[11\]\[20\]
+ sky130_fd_sc_hd__dfrtp_1
X_3647_ reg_file_inst.registry\[9\]\[9\] _1078_ _1088_ VGND VGND VPWR VPWR _1573_
+ sky130_fd_sc_hd__and3_1
X_6366_ clknet_leaf_20_clk _0774_ _0299_ VGND VGND VPWR VPWR reg_file_inst.registry\[2\]\[19\]
+ sky130_fd_sc_hd__dfrtp_1
X_3578_ reg_file_inst.registry\[8\]\[14\] _1114_ net143 VGND VGND VPWR VPWR _1507_
+ sky130_fd_sc_hd__and3_1
XFILLER_115_673 VPWR VGND VPWR VGND sky130_ef_sc_hd__decap_12
XFILLER_88_524 VGND VGND VPWR VPWR sky130_fd_sc_hd__decap_8
X_5317_ _2909_ reg_file_inst.registry\[8\]\[14\] _2994_ VGND VGND VPWR VPWR _0741_
+ sky130_fd_sc_hd__mux2_1
XTAP_TAPCELL_ROW_110_1640 VGND VPWR sky130_fd_sc_hd__tapvpwrvgnd_1
XFILLER_29_14 VGND VGND VPWR VPWR sky130_fd_sc_hd__decap_4
X_6297_ clknet_leaf_4_clk _0705_ _0230_ VGND VGND VPWR VPWR reg_file_inst.registry\[3\]\[6\]
+ sky130_fd_sc_hd__dfrtp_1
X_5248_ reg_file_inst.registry\[14\]\[25\] _2767_ _2992_ VGND VGND VPWR VPWR _0808_
+ sky130_fd_sc_hd__mux2_1
XFILLER_29_613 VGND VGND VPWR VPWR sky130_fd_sc_hd__decap_3
X_5179_ _2747_ reg_file_inst.registry\[0\]\[26\] _2988_ VGND VGND VPWR VPWR _0873_
+ sky130_fd_sc_hd__mux2_1
XFILLER_56_421 VGND VGND VPWR VPWR sky130_fd_sc_hd__decap_3
XFILLER_56_410 VGND VGND VPWR VPWR sky130_fd_sc_hd__decap_8
XFILLER_56_443 VPWR VGND VPWR VGND sky130_ef_sc_hd__decap_12
XTAP_TAPCELL_ROW_3_299 VGND VPWR sky130_fd_sc_hd__tapvpwrvgnd_1
XFILLER_16_307 VGND VGND VPWR VPWR sky130_fd_sc_hd__fill_1
XFILLER_24_340 VGND VGND VPWR VPWR sky130_fd_sc_hd__fill_2
XFILLER_24_351 VGND VGND VPWR VPWR sky130_fd_sc_hd__fill_2
XFILLER_24_362 VGND VGND VPWR VPWR sky130_fd_sc_hd__fill_2
XTAP_TAPCELL_ROW_121_1780 VGND VPWR sky130_fd_sc_hd__tapvpwrvgnd_1
XTAP_TAPCELL_ROW_61_1027 VGND VPWR sky130_fd_sc_hd__tapvpwrvgnd_1
XFILLER_24_373 VPWR VGND VPWR VGND sky130_ef_sc_hd__decap_12
XFILLER_101_96 VPWR VGND VPWR VGND sky130_ef_sc_hd__decap_12
XTAP_TAPCELL_ROW_22_541 VGND VPWR sky130_fd_sc_hd__tapvpwrvgnd_1
XTAP_TAPCELL_ROW_50_894 VGND VPWR sky130_fd_sc_hd__tapvpwrvgnd_1
XTAP_TAPCELL_ROW_50_883 VGND VPWR sky130_fd_sc_hd__tapvpwrvgnd_1
XFILLER_6_29 VPWR VGND VPWR VGND sky130_ef_sc_hd__decap_12
XFILLER_4_701 VPWR VGND VPWR VGND sky130_ef_sc_hd__decap_12
XFILLER_112_109 VPWR VGND VPWR VGND sky130_ef_sc_hd__decap_12
XFILLER_105_161 VGND VGND VPWR VPWR sky130_fd_sc_hd__decap_6
XTAP_TAPCELL_ROW_72_1167 VGND VPWR sky130_fd_sc_hd__tapvpwrvgnd_1
XFILLER_121_665 VGND VGND VPWR VPWR sky130_fd_sc_hd__decap_6
XFILLER_120_153 VPWR VGND VPWR VGND sky130_ef_sc_hd__decap_12
XFILLER_120_197 VPWR VGND VPWR VGND sky130_ef_sc_hd__decap_12
XFILLER_87_590 VPWR VGND VPWR VGND sky130_ef_sc_hd__decap_12
XFILLER_86_97 VGND VGND VPWR VPWR sky130_fd_sc_hd__fill_2
XFILLER_59_281 VGND VGND VPWR VPWR sky130_fd_sc_hd__decap_4
XFILLER_47_410 VPWR VGND VPWR VGND sky130_ef_sc_hd__decap_12
XTAP_TAPCELL_ROW_58_994 VGND VPWR sky130_fd_sc_hd__tapvpwrvgnd_1
XTAP_TAPCELL_ROW_58_983 VGND VPWR sky130_fd_sc_hd__tapvpwrvgnd_1
XFILLER_19_189 VGND VGND VPWR VPWR sky130_fd_sc_hd__decap_4
XFILLER_15_362 VGND VGND VPWR VPWR sky130_fd_sc_hd__decap_4
XTAP_TAPCELL_ROW_83_1296 VGND VPWR sky130_fd_sc_hd__tapvpwrvgnd_1
XFILLER_30_343 VGND VGND VPWR VPWR sky130_fd_sc_hd__decap_4
XFILLER_30_365 VGND VGND VPWR VPWR sky130_fd_sc_hd__decap_4
X_4550_ _2337_ _2358_ _1816_ VGND VGND VPWR VPWR _2431_ sky130_fd_sc_hd__mux2_1
XFILLER_7_561 VPWR VGND VPWR VGND sky130_ef_sc_hd__decap_12
X_4481_ net137 _2295_ _2365_ _2296_ VGND VGND VPWR VPWR _2366_ sky130_fd_sc_hd__a31o_1
X_3501_ reg_file_inst.registry\[0\]\[12\] net138 _1423_ _1432_ VGND VGND VPWR VPWR
+ _1433_ sky130_fd_sc_hd__a2bb2o_2
X_3432_ reg_file_inst.registry\[5\]\[18\] _1139_ _1359_ _1360_ _1361_ VGND VGND VPWR
+ VPWR _1367_ sky130_fd_sc_hd__a2111o_1
X_6220_ clknet_leaf_11_clk _0628_ _0153_ VGND VGND VPWR VPWR reg_file_inst.registry\[10\]\[13\]
+ sky130_fd_sc_hd__dfrtp_1
X_3363_ reg_file_inst.registry\[1\]\[20\] _1087_ _1089_ reg_file_inst.registry\[9\]\[20\]
+ VGND VGND VPWR VPWR _1300_ sky130_fd_sc_hd__a22o_1
X_6151_ clknet_leaf_54_clk _0559_ _0084_ VGND VGND VPWR VPWR JMPOFF\[0\] sky130_fd_sc_hd__dfrtp_2
XFILLER_112_643 VGND VGND VPWR VPWR sky130_fd_sc_hd__fill_1
X_5102_ _1765_ _2836_ VGND VGND VPWR VPWR _2931_ sky130_fd_sc_hd__nand2_1
XFILLER_97_354 VGND VGND VPWR VPWR sky130_fd_sc_hd__fill_1
X_3294_ reg_file_inst.registry\[11\]\[23\] _1119_ _1125_ VGND VGND VPWR VPWR _1234_
+ sky130_fd_sc_hd__and3_1
XFILLER_85_505 VPWR VGND VPWR VGND sky130_ef_sc_hd__decap_12
X_6082_ clknet_leaf_12_clk _0490_ _0015_ VGND VGND VPWR VPWR reg_file_inst.registry\[15\]\[15\]
+ sky130_fd_sc_hd__dfrtp_1
XPHY_EDGE_ROW_29_Left_152 VGND VGND VPWR VPWR sky130_fd_sc_hd__decap_3
XFILLER_85_527 VGND VGND VPWR VPWR sky130_fd_sc_hd__decap_6
X_5033_ _2129_ _2524_ VGND VGND VPWR VPWR _2872_ sky130_fd_sc_hd__or2_1
XFILLER_38_421 VGND VGND VPWR VPWR sky130_fd_sc_hd__decap_4
XFILLER_122_29 VPWR VGND VPWR VGND sky130_ef_sc_hd__decap_12
XFILLER_81_722 VGND VGND VPWR VPWR sky130_fd_sc_hd__decap_4
XFILLER_65_262 VGND VGND VPWR VPWR sky130_fd_sc_hd__fill_1
XFILLER_53_435 VGND VGND VPWR VPWR sky130_fd_sc_hd__fill_2
XTAP_TAPCELL_ROW_0_247 VGND VPWR sky130_fd_sc_hd__tapvpwrvgnd_1
XTAP_TAPCELL_ROW_0_258 VGND VPWR sky130_fd_sc_hd__tapvpwrvgnd_1
XTAP_TAPCELL_ROW_0_269 VGND VPWR sky130_fd_sc_hd__tapvpwrvgnd_1
XFILLER_80_265 VPWR VGND VPWR VGND sky130_ef_sc_hd__decap_12
X_5935_ net146 VGND VGND VPWR VPWR _0343_ sky130_fd_sc_hd__inv_2
XFILLER_15_27 VPWR VGND VPWR VGND sky130_ef_sc_hd__decap_12
XFILLER_41_608 VGND VGND VPWR VPWR sky130_fd_sc_hd__decap_8
X_5866_ net146 VGND VGND VPWR VPWR _0274_ sky130_fd_sc_hd__inv_2
XPHY_EDGE_ROW_38_Left_161 VGND VGND VPWR VPWR sky130_fd_sc_hd__decap_3
X_4817_ _2574_ _2675_ _2572_ VGND VGND VPWR VPWR _2676_ sky130_fd_sc_hd__a21oi_1
Xclkbuf_leaf_60_clk clknet_3_1__leaf_clk VGND VGND VPWR VPWR clknet_leaf_60_clk sky130_fd_sc_hd__clkbuf_8
X_5797_ net148 VGND VGND VPWR VPWR _0205_ sky130_fd_sc_hd__inv_2
X_4748_ _1552_ _2606_ VGND VGND VPWR VPWR _2607_ sky130_fd_sc_hd__xnor2_1
X_4679_ reg_file_inst.registry\[11\]\[0\] _2550_ _2122_ VGND VGND VPWR VPWR _0915_
+ sky130_fd_sc_hd__mux2_1
X_6418_ clknet_leaf_12_clk _0826_ _0351_ VGND VGND VPWR VPWR reg_file_inst.registry\[1\]\[15\]
+ sky130_fd_sc_hd__dfrtp_1
XPHY_EDGE_ROW_1_Right_1 VGND VGND VPWR VPWR sky130_fd_sc_hd__decap_3
Xoutput48 net48 VGND VGND VPWR VPWR DataAddress[12] sky130_fd_sc_hd__buf_1
XTAP_TAPCELL_ROW_8_369 VGND VPWR sky130_fd_sc_hd__tapvpwrvgnd_1
XTAP_TAPCELL_ROW_8_358 VGND VPWR sky130_fd_sc_hd__tapvpwrvgnd_1
XFILLER_0_214 VGND VGND VPWR VPWR sky130_fd_sc_hd__fill_2
XFILLER_0_225 VGND VGND VPWR VPWR sky130_fd_sc_hd__decap_4
Xoutput59 net59 VGND VGND VPWR VPWR DataAddress[22] sky130_fd_sc_hd__buf_1
XPHY_EDGE_ROW_47_Left_170 VGND VGND VPWR VPWR sky130_fd_sc_hd__decap_3
X_6349_ clknet_leaf_1_clk _0757_ _0282_ VGND VGND VPWR VPWR reg_file_inst.registry\[2\]\[2\]
+ sky130_fd_sc_hd__dfrtp_1
XFILLER_103_665 VGND VGND VPWR VPWR sky130_fd_sc_hd__decap_6
XFILLER_88_365 VPWR VGND VPWR VGND sky130_ef_sc_hd__decap_12
XFILLER_88_354 VGND VGND VPWR VPWR sky130_fd_sc_hd__decap_8
XFILLER_102_197 VGND VGND VPWR VPWR sky130_fd_sc_hd__decap_8
XFILLER_102_186 VGND VGND VPWR VPWR sky130_fd_sc_hd__decap_8
XFILLER_102_164 VGND VGND VPWR VPWR sky130_fd_sc_hd__fill_1
XFILLER_56_12 VGND VGND VPWR VPWR sky130_fd_sc_hd__fill_1
XFILLER_29_421 VGND VGND VPWR VPWR sky130_fd_sc_hd__fill_2
XFILLER_56_56 VPWR VGND VPWR VGND sky130_ef_sc_hd__decap_12
XFILLER_29_432 VPWR VGND VPWR VGND sky130_ef_sc_hd__decap_12
XFILLER_84_560 VPWR VGND VPWR VGND sky130_ef_sc_hd__decap_12
XFILLER_56_262 VGND VGND VPWR VPWR sky130_fd_sc_hd__decap_3
XTAP_TAPCELL_ROW_27_600 VGND VPWR sky130_fd_sc_hd__tapvpwrvgnd_1
XTAP_TAPCELL_ROW_55_953 VGND VPWR sky130_fd_sc_hd__tapvpwrvgnd_1
XFILLER_16_137 VGND VGND VPWR VPWR sky130_fd_sc_hd__decap_3
XFILLER_44_457 VGND VGND VPWR VPWR sky130_fd_sc_hd__decap_4
XFILLER_12_365 VGND VGND VPWR VPWR sky130_fd_sc_hd__decap_8
XFILLER_12_398 VGND VGND VPWR VPWR sky130_fd_sc_hd__fill_1
XFILLER_113_429 VPWR VGND VPWR VGND sky130_ef_sc_hd__decap_12
XFILLER_79_365 VPWR VGND VPWR VGND sky130_ef_sc_hd__decap_12
XFILLER_67_505 VGND VGND VPWR VPWR sky130_fd_sc_hd__fill_2
XFILLER_121_473 VPWR VGND VPWR VGND sky130_ef_sc_hd__decap_12
XFILLER_82_508 VGND VGND VPWR VPWR sky130_fd_sc_hd__fill_1
XFILLER_35_402 VPWR VGND VPWR VGND sky130_ef_sc_hd__decap_12
XTAP_TAPCELL_ROW_85_1325 VGND VPWR sky130_fd_sc_hd__tapvpwrvgnd_1
X_3981_ _0952_ _1895_ VGND VGND VPWR VPWR _1897_ sky130_fd_sc_hd__xnor2_2
X_5720_ net44 VGND VGND VPWR VPWR _0128_ sky130_fd_sc_hd__inv_2
XFILLER_94_3 VGND VGND VPWR VPWR sky130_fd_sc_hd__decap_4
Xclkbuf_leaf_42_clk clknet_3_7__leaf_clk VGND VGND VPWR VPWR clknet_leaf_42_clk sky130_fd_sc_hd__clkbuf_8
XFILLER_15_192 VGND VGND VPWR VPWR sky130_fd_sc_hd__fill_1
X_5651_ net149 VGND VGND VPWR VPWR _0059_ sky130_fd_sc_hd__inv_2
X_5582_ reg_file_inst.registry\[15\]\[10\] _2960_ _3003_ VGND VGND VPWR VPWR _0485_
+ sky130_fd_sc_hd__mux2_1
X_4602_ _1802_ _2203_ _2319_ VGND VGND VPWR VPWR _2479_ sky130_fd_sc_hd__a21o_1
X_4533_ _2171_ _2414_ _2415_ VGND VGND VPWR VPWR _2416_ sky130_fd_sc_hd__o21ba_1
XFILLER_116_245 VGND VGND VPWR VPWR sky130_fd_sc_hd__decap_6
XTAP_TAPCELL_ROW_96_1465 VGND VPWR sky130_fd_sc_hd__tapvpwrvgnd_1
XFILLER_116_289 VPWR VGND VPWR VGND sky130_ef_sc_hd__decap_12
X_6203_ clknet_leaf_32_clk _0611_ _0136_ VGND VGND VPWR VPWR reg_file_inst.registry\[5\]\[24\]
+ sky130_fd_sc_hd__dfrtp_1
X_4464_ _2224_ _2270_ net132 VGND VGND VPWR VPWR _2349_ sky130_fd_sc_hd__mux2_1
X_3415_ MEMOFF\[18\] _1079_ _1098_ reg_file_inst.registry\[10\]\[18\] _1349_ VGND
+ VGND VPWR VPWR _1350_ sky130_fd_sc_hd__a221oi_1
X_4395_ _2282_ VGND VGND VPWR VPWR _2283_ sky130_fd_sc_hd__inv_2
X_3346_ reg_file_inst.registry\[4\]\[21\] _1114_ _1132_ VGND VGND VPWR VPWR _1284_
+ sky130_fd_sc_hd__and3_1
XFILLER_58_516 VGND VGND VPWR VPWR sky130_fd_sc_hd__fill_1
XTAP_TAPCELL_ROW_5_328 VGND VPWR sky130_fd_sc_hd__tapvpwrvgnd_1
X_6134_ clknet_leaf_61_clk _0542_ _0067_ VGND VGND VPWR VPWR reg_file_inst.registry\[6\]\[11\]
+ sky130_fd_sc_hd__dfrtp_1
XFILLER_100_613 VPWR VGND VPWR VGND sky130_ef_sc_hd__decap_12
XFILLER_85_324 VPWR VGND VPWR VGND sky130_ef_sc_hd__decap_12
X_6065_ net146 VGND VGND VPWR VPWR _0473_ sky130_fd_sc_hd__inv_2
XFILLER_100_657 VPWR VGND VPWR VGND sky130_ef_sc_hd__decap_12
X_3277_ MEMOFF\[24\] net89 _1113_ VGND VGND VPWR VPWR _1217_ sky130_fd_sc_hd__mux2_4
X_5016_ _1370_ _2286_ _2124_ _1358_ VGND VGND VPWR VPWR _2857_ sky130_fd_sc_hd__o2bb2a_1
XFILLER_38_295 VPWR VGND VPWR VGND sky130_ef_sc_hd__decap_12
XTAP_TAPCELL_ROW_52_912 VGND VPWR sky130_fd_sc_hd__tapvpwrvgnd_1
XTAP_TAPCELL_ROW_105_1572 VGND VPWR sky130_fd_sc_hd__tapvpwrvgnd_1
X_5918_ net147 VGND VGND VPWR VPWR _0326_ sky130_fd_sc_hd__inv_2
XFILLER_53_287 VGND VGND VPWR VPWR sky130_fd_sc_hd__fill_1
Xclkbuf_leaf_33_clk clknet_3_6__leaf_clk VGND VGND VPWR VPWR clknet_leaf_33_clk sky130_fd_sc_hd__clkbuf_8
X_5849_ net149 VGND VGND VPWR VPWR _0257_ sky130_fd_sc_hd__inv_2
XFILLER_108_713 VGND VGND VPWR VPWR sky130_fd_sc_hd__decap_6
XFILLER_107_223 VGND VGND VPWR VPWR sky130_fd_sc_hd__fill_1
XFILLER_122_237 VPWR VGND VPWR VGND sky130_ef_sc_hd__decap_12
XFILLER_89_641 VPWR VGND VPWR VGND sky130_ef_sc_hd__decap_12
XFILLER_107_51 VGND VGND VPWR VPWR sky130_fd_sc_hd__decap_4
XFILLER_89_685 VPWR VGND VPWR VGND sky130_ef_sc_hd__decap_12
XFILLER_67_55 VGND VGND VPWR VPWR sky130_fd_sc_hd__fill_1
XFILLER_91_316 VGND VGND VPWR VPWR sky130_fd_sc_hd__decap_4
XFILLER_29_262 VGND VGND VPWR VPWR sky130_fd_sc_hd__decap_8
XFILLER_45_711 VGND VGND VPWR VPWR sky130_fd_sc_hd__decap_8
XFILLER_45_722 VGND VGND VPWR VPWR sky130_fd_sc_hd__fill_1
XFILLER_17_479 VGND VGND VPWR VPWR sky130_fd_sc_hd__decap_3
XTAP_TAPCELL_ROW_67_1099 VGND VPWR sky130_fd_sc_hd__tapvpwrvgnd_1
Xclkbuf_leaf_24_clk clknet_3_3__leaf_clk VGND VGND VPWR VPWR clknet_leaf_24_clk sky130_fd_sc_hd__clkbuf_8
XTAP_TAPCELL_ROW_80_1266 VGND VPWR sky130_fd_sc_hd__tapvpwrvgnd_1
XFILLER_13_685 VGND VGND VPWR VPWR sky130_fd_sc_hd__fill_1
XFILLER_8_122 VPWR VGND VPWR VGND sky130_ef_sc_hd__decap_12
XTAP_TAPCELL_ROW_30_639 VGND VPWR sky130_fd_sc_hd__tapvpwrvgnd_1
XFILLER_8_166 VGND VGND VPWR VPWR sky130_fd_sc_hd__fill_2
XTAP_TAPCELL_ROW_10_385 VGND VPWR sky130_fd_sc_hd__tapvpwrvgnd_1
XFILLER_99_405 VGND VGND VPWR VPWR sky130_fd_sc_hd__decap_8
XFILLER_59_6 VGND VGND VPWR VPWR sky130_fd_sc_hd__decap_8
XFILLER_113_237 VPWR VGND VPWR VGND sky130_ef_sc_hd__decap_12
XFILLER_99_438 VGND VGND VPWR VPWR sky130_fd_sc_hd__decap_8
X_3200_ reg_file_inst.registry\[8\]\[27\] _1136_ _1137_ reg_file_inst.registry\[2\]\[27\]
+ VGND VGND VPWR VPWR _1144_ sky130_fd_sc_hd__a22o_1
X_4180_ _1902_ _1909_ _2084_ _1923_ VGND VGND VPWR VPWR _2085_ sky130_fd_sc_hd__a31oi_2
X_3131_ net40 net41 _1074_ VGND VGND VPWR VPWR _1075_ sky130_fd_sc_hd__nor3b_4
XFILLER_121_281 VPWR VGND VPWR VGND sky130_ef_sc_hd__decap_12
X_3062_ _0957_ net33 _0961_ _0964_ VGND VGND VPWR VPWR _1006_ sky130_fd_sc_hd__or4_1
XFILLER_75_390 VGND VGND VPWR VPWR sky130_fd_sc_hd__fill_2
XFILLER_35_221 VGND VGND VPWR VPWR sky130_fd_sc_hd__decap_3
XTAP_TAPCELL_ROW_38_739 VGND VPWR sky130_fd_sc_hd__tapvpwrvgnd_1
XFILLER_48_582 VGND VGND VPWR VPWR sky130_fd_sc_hd__decap_6
XFILLER_23_405 VPWR VGND VPWR VGND sky130_ef_sc_hd__decap_12
XTAP_TAPCELL_ROW_18_485 VGND VPWR sky130_fd_sc_hd__tapvpwrvgnd_1
Xclkbuf_leaf_15_clk clknet_3_2__leaf_clk VGND VGND VPWR VPWR clknet_leaf_15_clk sky130_fd_sc_hd__clkbuf_8
X_3964_ _1073_ _1879_ net131 VGND VGND VPWR VPWR _1880_ sky130_fd_sc_hd__or3b_1
XFILLER_23_449 VGND VGND VPWR VPWR sky130_fd_sc_hd__decap_3
X_5703_ net147 VGND VGND VPWR VPWR _0111_ sky130_fd_sc_hd__inv_2
X_3895_ reg_file_inst.registry\[6\]\[1\] _1080_ _1084_ _1093_ reg_file_inst.registry\[15\]\[1\]
+ VGND VGND VPWR VPWR _1813_ sky130_fd_sc_hd__a32o_1
XFILLER_50_268 VPWR VGND VPWR VGND sky130_ef_sc_hd__decap_12
X_5634_ net147 VGND VGND VPWR VPWR _0042_ sky130_fd_sc_hd__inv_2
X_5565_ reg_file_inst.registry\[15\]\[27\] _2715_ _3003_ VGND VGND VPWR VPWR _0502_
+ sky130_fd_sc_hd__mux2_1
X_5496_ JMPOFF\[9\] _2974_ _3000_ VGND VGND VPWR VPWR _0568_ sky130_fd_sc_hd__mux2_1
X_4516_ _1790_ _2397_ _2398_ VGND VGND VPWR VPWR _2399_ sky130_fd_sc_hd__a21oi_1
XFILLER_104_215 VPWR VGND VPWR VGND sky130_ef_sc_hd__decap_12
X_4447_ _1840_ _2219_ VGND VGND VPWR VPWR _2332_ sky130_fd_sc_hd__nor2_1
X_6117_ clknet_leaf_35_clk _0525_ _0050_ VGND VGND VPWR VPWR reg_file_inst.registry\[9\]\[22\]
+ sky130_fd_sc_hd__dfrtp_1
XFILLER_58_302 VGND VGND VPWR VPWR sky130_fd_sc_hd__decap_6
X_4378_ _1721_ _2190_ net132 VGND VGND VPWR VPWR _2266_ sky130_fd_sc_hd__a21oi_1
XFILLER_100_432 VGND VGND VPWR VPWR sky130_fd_sc_hd__decap_6
X_3329_ MEMOFF\[22\] net87 _1113_ VGND VGND VPWR VPWR _1267_ sky130_fd_sc_hd__mux2_4
XTAP_TAPCELL_ROW_107_1601 VGND VPWR sky130_fd_sc_hd__tapvpwrvgnd_1
XFILLER_86_699 VGND VGND VPWR VPWR sky130_fd_sc_hd__fill_1
X_6048_ net146 VGND VGND VPWR VPWR _0456_ sky130_fd_sc_hd__inv_2
XFILLER_54_530 VGND VGND VPWR VPWR sky130_fd_sc_hd__fill_2
XFILLER_37_69 VPWR VGND VPWR VGND sky130_ef_sc_hd__decap_12
XFILLER_54_585 VGND VGND VPWR VPWR sky130_fd_sc_hd__decap_3
XFILLER_14_438 VGND VGND VPWR VPWR sky130_fd_sc_hd__fill_1
XFILLER_81_393 VGND VGND VPWR VPWR sky130_fd_sc_hd__decap_6
XFILLER_53_57 VPWR VGND VPWR VGND sky130_ef_sc_hd__decap_12
XTAP_TAPCELL_ROW_118_1741 VGND VPWR sky130_fd_sc_hd__tapvpwrvgnd_1
XFILLER_10_699 VGND VGND VPWR VPWR sky130_fd_sc_hd__fill_1
XFILLER_6_637 VGND VGND VPWR VPWR sky130_fd_sc_hd__decap_6
XFILLER_108_587 VGND VGND VPWR VPWR sky130_fd_sc_hd__fill_1
XFILLER_118_83 VGND VGND VPWR VPWR sky130_fd_sc_hd__fill_1
XFILLER_78_54 VPWR VGND VPWR VGND sky130_ef_sc_hd__decap_12
XFILLER_1_331 VGND VGND VPWR VPWR sky130_fd_sc_hd__decap_4
XFILLER_103_281 VGND VGND VPWR VPWR sky130_fd_sc_hd__decap_6
XFILLER_49_335 VGND VGND VPWR VPWR sky130_fd_sc_hd__fill_1
XFILLER_92_625 VPWR VGND VPWR VGND sky130_ef_sc_hd__decap_12
XFILLER_76_165 VGND VGND VPWR VPWR sky130_fd_sc_hd__decap_6
XFILLER_64_316 VGND VGND VPWR VPWR sky130_fd_sc_hd__decap_4
XTAP_TAPCELL_ROW_69_1128 VGND VPWR sky130_fd_sc_hd__tapvpwrvgnd_1
XFILLER_57_390 VGND VGND VPWR VPWR sky130_fd_sc_hd__fill_2
XFILLER_92_669 VPWR VGND VPWR VGND sky130_ef_sc_hd__decap_12
XFILLER_72_360 VGND VGND VPWR VPWR sky130_fd_sc_hd__decap_4
XFILLER_60_533 VPWR VGND VPWR VGND sky130_ef_sc_hd__decap_12
XTAP_TAPCELL_ROW_15_455 VGND VPWR sky130_fd_sc_hd__tapvpwrvgnd_1
XTAP_TAPCELL_ROW_43_797 VGND VPWR sky130_fd_sc_hd__tapvpwrvgnd_1
XFILLER_118_307 VGND VGND VPWR VPWR sky130_fd_sc_hd__fill_1
X_3680_ JMPOFF\[8\] _1095_ _1596_ _1597_ _1600_ VGND VGND VPWR VPWR _1605_ sky130_fd_sc_hd__a2111o_1
XFILLER_99_202 VGND VGND VPWR VPWR sky130_fd_sc_hd__decap_8
XTAP_TAPCELL_ROW_93_1424 VGND VPWR sky130_fd_sc_hd__tapvpwrvgnd_1
X_5350_ _2960_ reg_file_inst.registry\[3\]\[10\] _2995_ VGND VGND VPWR VPWR _0709_
+ sky130_fd_sc_hd__mux2_1
XFILLER_114_513 VPWR VGND VPWR VGND sky130_ef_sc_hd__decap_12
X_5281_ _2829_ reg_file_inst.registry\[2\]\[21\] _2993_ VGND VGND VPWR VPWR _0776_
+ sky130_fd_sc_hd__mux2_1
X_4301_ _2185_ _2186_ _2188_ VGND VGND VPWR VPWR _2189_ sky130_fd_sc_hd__and3_1
XFILLER_114_557 VPWR VGND VPWR VGND sky130_ef_sc_hd__decap_12
X_4232_ _2114_ _2119_ VGND VGND VPWR VPWR _2120_ sky130_fd_sc_hd__or2_1
XFILLER_68_622 VGND VGND VPWR VPWR sky130_fd_sc_hd__decap_8
Xclkbuf_leaf_4_clk clknet_3_1__leaf_clk VGND VGND VPWR VPWR clknet_leaf_4_clk sky130_fd_sc_hd__clkbuf_8
X_4163_ _2021_ _2034_ VGND VGND VPWR VPWR _2073_ sky130_fd_sc_hd__xor2_1
XFILLER_82_102 VPWR VGND VPWR VGND sky130_ef_sc_hd__decap_12
X_4094_ _0973_ _1062_ _1066_ VGND VGND VPWR VPWR _2010_ sky130_fd_sc_hd__nand3_1
X_3114_ _1055_ _1056_ _1057_ VGND VGND VPWR VPWR _1058_ sky130_fd_sc_hd__and3_1
X_3045_ _0982_ _0986_ VGND VGND VPWR VPWR _0989_ sky130_fd_sc_hd__nand2b_1
XFILLER_63_360 VGND VGND VPWR VPWR sky130_fd_sc_hd__fill_1
XFILLER_36_585 VGND VGND VPWR VPWR sky130_fd_sc_hd__decap_3
XFILLER_90_190 VGND VGND VPWR VPWR sky130_fd_sc_hd__decap_6
X_4996_ _1764_ _2834_ _2840_ _2831_ VGND VGND VPWR VPWR _2841_ sky130_fd_sc_hd__o211ai_2
XTAP_TAPCELL_ROW_102_1542 VGND VPWR sky130_fd_sc_hd__tapvpwrvgnd_1
XFILLER_51_588 VGND VGND VPWR VPWR sky130_fd_sc_hd__fill_1
X_3947_ _1630_ _1638_ _1862_ _1221_ VGND VGND VPWR VPWR _1863_ sky130_fd_sc_hd__o31a_1
XFILLER_109_329 VGND VGND VPWR VPWR sky130_fd_sc_hd__decap_6
X_3878_ MEMOFF\[2\] _1129_ _1130_ JMPOFF\[2\] _1796_ VGND VGND VPWR VPWR _1797_ sky130_fd_sc_hd__a221o_1
X_5617_ net148 VGND VGND VPWR VPWR _0025_ sky130_fd_sc_hd__inv_2
X_5548_ _2897_ reg_file_inst.registry\[9\]\[15\] _3002_ VGND VGND VPWR VPWR _0518_
+ sky130_fd_sc_hd__mux2_1
XFILLER_117_373 VPWR VGND VPWR VGND sky130_ef_sc_hd__decap_12
XFILLER_3_629 VPWR VGND VPWR VGND sky130_ef_sc_hd__decap_12
X_5479_ JMPOFF\[26\] _2747_ _3000_ VGND VGND VPWR VPWR _0585_ sky130_fd_sc_hd__mux2_1
XTAP_TAPCELL_ROW_113_1682 VGND VPWR sky130_fd_sc_hd__tapvpwrvgnd_1
XTAP_TAPCELL_ROW_113_1671 VGND VPWR sky130_fd_sc_hd__tapvpwrvgnd_1
XFILLER_59_633 VGND VGND VPWR VPWR sky130_fd_sc_hd__fill_1
XPHY_EDGE_ROW_122_Right_122 VGND VGND VPWR VPWR sky130_fd_sc_hd__decap_3
XFILLER_100_251 VGND VGND VPWR VPWR sky130_fd_sc_hd__fill_1
XFILLER_86_474 VGND VGND VPWR VPWR sky130_fd_sc_hd__fill_2
XFILLER_86_452 VGND VGND VPWR VPWR sky130_fd_sc_hd__fill_2
XFILLER_59_699 VGND VGND VPWR VPWR sky130_fd_sc_hd__decap_6
XFILLER_48_79 VGND VGND VPWR VPWR sky130_fd_sc_hd__decap_4
XFILLER_104_41 VPWR VGND VPWR VGND sky130_ef_sc_hd__decap_12
XFILLER_100_273 VPWR VGND VPWR VGND sky130_ef_sc_hd__decap_12
XFILLER_73_113 VGND VGND VPWR VPWR sky130_fd_sc_hd__fill_1
XFILLER_46_327 VPWR VGND VPWR VGND sky130_ef_sc_hd__decap_12
XFILLER_104_85 VPWR VGND VPWR VGND sky130_ef_sc_hd__decap_12
XFILLER_64_23 VGND VGND VPWR VPWR sky130_fd_sc_hd__decap_4
XFILLER_27_596 VGND VGND VPWR VPWR sky130_fd_sc_hd__decap_4
XFILLER_42_533 VGND VGND VPWR VPWR sky130_fd_sc_hd__decap_3
XTAP_TAPCELL_ROW_64_1069 VGND VPWR sky130_fd_sc_hd__tapvpwrvgnd_1
XTAP_TAPCELL_ROW_64_1058 VGND VPWR sky130_fd_sc_hd__tapvpwrvgnd_1
XFILLER_80_66 VGND VGND VPWR VPWR sky130_fd_sc_hd__decap_6
XTAP_TAPCELL_ROW_12_414 VGND VPWR sky130_fd_sc_hd__tapvpwrvgnd_1
XFILLER_10_430 VPWR VGND VPWR VGND sky130_ef_sc_hd__decap_12
XTAP_TAPCELL_ROW_40_767 VGND VPWR sky130_fd_sc_hd__tapvpwrvgnd_1
XFILLER_6_467 VGND VGND VPWR VPWR sky130_fd_sc_hd__decap_8
XFILLER_111_505 VPWR VGND VPWR VGND sky130_ef_sc_hd__decap_12
XTAP_TAPCELL_ROW_75_1198 VGND VPWR sky130_fd_sc_hd__tapvpwrvgnd_1
XFILLER_96_249 VGND VGND VPWR VPWR sky130_fd_sc_hd__decap_3
XFILLER_49_110 VGND VGND VPWR VPWR sky130_fd_sc_hd__fill_2
XFILLER_92_400 VGND VGND VPWR VPWR sky130_fd_sc_hd__decap_4
XFILLER_92_433 VGND VGND VPWR VPWR sky130_fd_sc_hd__fill_1
XFILLER_80_606 VGND VGND VPWR VPWR sky130_fd_sc_hd__fill_1
Xclkbuf_3_7__f_clk clknet_0_clk VGND VGND VPWR VPWR clknet_3_7__leaf_clk sky130_fd_sc_hd__clkbuf_16
XTAP_TAPCELL_ROW_48_867 VGND VPWR sky130_fd_sc_hd__tapvpwrvgnd_1
XFILLER_80_639 VGND VGND VPWR VPWR sky130_fd_sc_hd__decap_4
XFILLER_45_360 VGND VGND VPWR VPWR sky130_fd_sc_hd__fill_1
X_4850_ _2707_ _2708_ net133 VGND VGND VPWR VPWR _2709_ sky130_fd_sc_hd__mux2_1
XFILLER_45_382 VGND VGND VPWR VPWR sky130_fd_sc_hd__decap_3
XFILLER_45_393 VPWR VGND VPWR VGND sky130_ef_sc_hd__decap_12
XFILLER_60_374 VPWR VGND VPWR VGND sky130_ef_sc_hd__decap_12
XFILLER_60_363 VGND VGND VPWR VPWR sky130_fd_sc_hd__fill_1
X_3801_ _1721_ VGND VGND VPWR VPWR _1722_ sky130_fd_sc_hd__inv_2
X_4781_ _1457_ _2126_ _2639_ VGND VGND VPWR VPWR _2640_ sky130_fd_sc_hd__o21a_1
XFILLER_20_216 VPWR VGND VPWR VGND sky130_ef_sc_hd__decap_12
X_6520_ clknet_leaf_52_clk _0928_ _0453_ VGND VGND VPWR VPWR net126 sky130_fd_sc_hd__dfrtp_1
X_3732_ JMPOFF\[7\] _1114_ _1121_ VGND VGND VPWR VPWR _1656_ sky130_fd_sc_hd__and3_1
Xclkload20 clknet_leaf_14_clk VGND VGND VPWR VPWR clkload20/X sky130_fd_sc_hd__clkbuf_8
X_3663_ MEMOFF\[9\] _1129_ _1130_ JMPOFF\[9\] _1588_ VGND VGND VPWR VPWR _1589_ sky130_fd_sc_hd__a221o_1
X_6451_ clknet_leaf_2_clk _0859_ _0384_ VGND VGND VPWR VPWR reg_file_inst.registry\[0\]\[12\]
+ sky130_fd_sc_hd__dfrtp_1
Xclkload53 clknet_leaf_35_clk VGND VGND VPWR VPWR clkload53/Y sky130_fd_sc_hd__inv_6
X_5402_ reg_file_inst.registry\[4\]\[16\] _2883_ _2997_ VGND VGND VPWR VPWR _0659_
+ sky130_fd_sc_hd__mux2_1
Xclkload31 clknet_leaf_25_clk VGND VGND VPWR VPWR clkload31/Y sky130_fd_sc_hd__inv_8
X_6382_ clknet_leaf_43_clk _0790_ _0315_ VGND VGND VPWR VPWR reg_file_inst.registry\[14\]\[7\]
+ sky130_fd_sc_hd__dfrtp_1
Xclkload42 clknet_leaf_49_clk VGND VGND VPWR VPWR clkload42/Y sky130_fd_sc_hd__inv_8
XFILLER_114_321 VPWR VGND VPWR VGND sky130_ef_sc_hd__decap_12
X_5333_ _2715_ reg_file_inst.registry\[3\]\[27\] _2995_ VGND VGND VPWR VPWR _0726_
+ sky130_fd_sc_hd__mux2_1
X_3594_ reg_file_inst.registry\[2\]\[11\] _1083_ _1089_ reg_file_inst.registry\[9\]\[11\]
+ VGND VGND VPWR VPWR _1522_ sky130_fd_sc_hd__a22o_1
XFILLER_114_365 VPWR VGND VPWR VGND sky130_ef_sc_hd__decap_12
X_5264_ reg_file_inst.registry\[14\]\[9\] _2974_ _2992_ VGND VGND VPWR VPWR _0792_
+ sky130_fd_sc_hd__mux2_1
XPHY_EDGE_ROW_10_Left_133 VGND VGND VPWR VPWR sky130_fd_sc_hd__decap_3
X_5195_ _2960_ reg_file_inst.registry\[0\]\[10\] _2988_ VGND VGND VPWR VPWR _0857_
+ sky130_fd_sc_hd__mux2_1
X_4215_ _2107_ net124 net130 VGND VGND VPWR VPWR _0926_ sky130_fd_sc_hd__mux2_1
X_4146_ _2055_ _2061_ VGND VGND VPWR VPWR _2062_ sky130_fd_sc_hd__xnor2_1
XFILLER_68_463 VGND VGND VPWR VPWR sky130_fd_sc_hd__fill_1
XFILLER_83_433 VPWR VGND VPWR VGND sky130_ef_sc_hd__decap_12
XFILLER_56_625 VGND VGND VPWR VPWR sky130_fd_sc_hd__decap_8
XFILLER_55_113 VPWR VGND VPWR VGND sky130_ef_sc_hd__decap_12
XFILLER_18_27 VGND VGND VPWR VPWR sky130_fd_sc_hd__fill_1
XFILLER_18_49 VGND VGND VPWR VPWR sky130_fd_sc_hd__decap_8
XFILLER_28_327 VGND VGND VPWR VPWR sky130_fd_sc_hd__fill_1
XFILLER_71_617 VPWR VGND VPWR VGND sky130_ef_sc_hd__decap_12
X_4077_ _1991_ _1992_ VGND VGND VPWR VPWR _1993_ sky130_fd_sc_hd__and2_1
X_3028_ JMPOFF\[16\] _0967_ VGND VGND VPWR VPWR _0972_ sky130_fd_sc_hd__nand2_1
XFILLER_36_371 VPWR VGND VPWR VGND sky130_ef_sc_hd__decap_12
XFILLER_51_363 VGND VGND VPWR VPWR sky130_fd_sc_hd__decap_4
X_4979_ _2407_ _2801_ _2825_ _2711_ _2824_ VGND VGND VPWR VPWR _2826_ sky130_fd_sc_hd__a221o_1
Xclkload3 clknet_3_6__leaf_clk VGND VGND VPWR VPWR clkload3/Y sky130_fd_sc_hd__clkinvlp_4
XFILLER_109_137 VPWR VGND VPWR VGND sky130_ef_sc_hd__decap_12
XTAP_TAPCELL_ROW_115_1700 VGND VPWR sky130_fd_sc_hd__tapvpwrvgnd_1
XFILLER_118_693 VGND VGND VPWR VPWR sky130_fd_sc_hd__decap_6
XFILLER_117_181 VPWR VGND VPWR VGND sky130_ef_sc_hd__decap_12
XFILLER_105_365 VPWR VGND VPWR VGND sky130_ef_sc_hd__decap_12
XFILLER_120_357 VGND VGND VPWR VPWR sky130_fd_sc_hd__decap_6
XFILLER_115_51 VGND VGND VPWR VPWR sky130_fd_sc_hd__decap_4
XFILLER_19_349 VGND VGND VPWR VPWR sky130_fd_sc_hd__decap_4
XFILLER_47_658 VPWR VGND VPWR VGND sky130_ef_sc_hd__decap_12
XFILLER_74_477 VGND VGND VPWR VPWR sky130_fd_sc_hd__decap_6
XTAP_TAPCELL_ROW_45_826 VGND VPWR sky130_fd_sc_hd__tapvpwrvgnd_1
XFILLER_15_577 VPWR VGND VPWR VGND sky130_ef_sc_hd__decap_12
XTAP_TAPCELL_ROW_25_572 VGND VPWR sky130_fd_sc_hd__tapvpwrvgnd_1
XFILLER_7_721 VGND VGND VPWR VPWR sky130_fd_sc_hd__decap_4
XTAP_TAPCELL_ROW_77_1227 VGND VPWR sky130_fd_sc_hd__tapvpwrvgnd_1
XFILLER_6_231 VGND VGND VPWR VPWR sky130_fd_sc_hd__fill_1
XFILLER_109_671 VGND VGND VPWR VPWR sky130_fd_sc_hd__fill_1
XFILLER_97_525 VPWR VGND VPWR VGND sky130_ef_sc_hd__decap_12
XFILLER_111_335 VGND VGND VPWR VPWR sky130_fd_sc_hd__fill_1
XFILLER_85_709 VGND VGND VPWR VPWR sky130_fd_sc_hd__decap_6
X_4000_ _1914_ _1915_ VGND VGND VPWR VPWR _1916_ sky130_fd_sc_hd__nor2_1
XFILLER_37_113 VPWR VGND VPWR VGND sky130_ef_sc_hd__decap_12
XTAP_TAPCELL_ROW_88_1367 VGND VPWR sky130_fd_sc_hd__tapvpwrvgnd_1
X_5951_ net146 VGND VGND VPWR VPWR _0359_ sky130_fd_sc_hd__inv_2
XFILLER_53_617 VPWR VGND VPWR VGND sky130_ef_sc_hd__decap_12
XFILLER_92_296 VGND VGND VPWR VPWR sky130_fd_sc_hd__decap_4
X_4902_ _2755_ _2756_ _1791_ VGND VGND VPWR VPWR _2757_ sky130_fd_sc_hd__mux2_1
XFILLER_18_393 VGND VGND VPWR VPWR sky130_fd_sc_hd__decap_3
X_5882_ net149 VGND VGND VPWR VPWR _0290_ sky130_fd_sc_hd__inv_2
XFILLER_21_503 VGND VGND VPWR VPWR sky130_fd_sc_hd__fill_1
X_4833_ _1194_ _2203_ _2238_ VGND VGND VPWR VPWR _2692_ sky130_fd_sc_hd__a21o_1
X_4764_ _2613_ _2616_ _2619_ _2612_ VGND VGND VPWR VPWR _2623_ sky130_fd_sc_hd__a31o_1
X_6503_ clknet_leaf_7_clk _0911_ _0436_ VGND VGND VPWR VPWR reg_file_inst.registry\[11\]\[12\]
+ sky130_fd_sc_hd__dfrtp_1
X_3715_ _1607_ _1620_ VGND VGND VPWR VPWR _1639_ sky130_fd_sc_hd__nand2_2
XTAP_TAPCELL_ROW_99_1496 VGND VPWR sky130_fd_sc_hd__tapvpwrvgnd_1
X_6434_ clknet_leaf_24_clk _0842_ _0367_ VGND VGND VPWR VPWR reg_file_inst.registry\[11\]\[19\]
+ sky130_fd_sc_hd__dfrtp_1
X_4695_ _1607_ _2129_ _2131_ _2187_ VGND VGND VPWR VPWR _2554_ sky130_fd_sc_hd__or4_2
X_3646_ reg_file_inst.registry\[5\]\[9\] _1078_ _1084_ VGND VGND VPWR VPWR _1572_
+ sky130_fd_sc_hd__and3_1
XFILLER_115_641 VPWR VGND VPWR VGND sky130_ef_sc_hd__decap_12
X_6365_ clknet_leaf_14_clk _0773_ _0298_ VGND VGND VPWR VPWR reg_file_inst.registry\[2\]\[18\]
+ sky130_fd_sc_hd__dfrtp_1
X_3577_ reg_file_inst.registry\[5\]\[14\] _1139_ _1140_ reg_file_inst.registry\[3\]\[14\]
+ VGND VGND VPWR VPWR _1506_ sky130_fd_sc_hd__a22o_1
XFILLER_115_685 VPWR VGND VPWR VGND sky130_ef_sc_hd__decap_12
X_5316_ _2897_ reg_file_inst.registry\[8\]\[15\] _2994_ VGND VGND VPWR VPWR _0742_
+ sky130_fd_sc_hd__mux2_1
X_6296_ clknet_leaf_41_clk _0704_ _0229_ VGND VGND VPWR VPWR reg_file_inst.registry\[3\]\[5\]
+ sky130_fd_sc_hd__dfrtp_1
XFILLER_114_195 VGND VGND VPWR VPWR sky130_fd_sc_hd__fill_1
XTAP_TAPCELL_ROW_110_1641 VGND VPWR sky130_fd_sc_hd__tapvpwrvgnd_1
X_5247_ reg_file_inst.registry\[14\]\[26\] _2747_ _2992_ VGND VGND VPWR VPWR _0809_
+ sky130_fd_sc_hd__mux2_1
X_5178_ _2715_ reg_file_inst.registry\[0\]\[27\] _2988_ VGND VGND VPWR VPWR _0874_
+ sky130_fd_sc_hd__mux2_1
X_4129_ net118 _2041_ _2044_ VGND VGND VPWR VPWR _2045_ sky130_fd_sc_hd__o21ai_1
XFILLER_56_455 VPWR VGND VPWR VGND sky130_ef_sc_hd__decap_12
XFILLER_56_433 VGND VGND VPWR VPWR sky130_fd_sc_hd__decap_3
XFILLER_71_447 VGND VGND VPWR VPWR sky130_fd_sc_hd__fill_1
XFILLER_36_190 VGND VGND VPWR VPWR sky130_fd_sc_hd__decap_6
XTAP_TAPCELL_ROW_61_1028 VGND VPWR sky130_fd_sc_hd__tapvpwrvgnd_1
XFILLER_24_385 VPWR VGND VPWR VGND sky130_ef_sc_hd__decap_12
XTAP_TAPCELL_ROW_121_1781 VGND VPWR sky130_fd_sc_hd__tapvpwrvgnd_1
XFILLER_61_57 VGND VGND VPWR VPWR sky130_fd_sc_hd__decap_8
XTAP_TAPCELL_ROW_22_542 VGND VPWR sky130_fd_sc_hd__tapvpwrvgnd_1
XTAP_TAPCELL_ROW_50_895 VGND VPWR sky130_fd_sc_hd__tapvpwrvgnd_1
XTAP_TAPCELL_ROW_50_884 VGND VPWR sky130_fd_sc_hd__tapvpwrvgnd_1
XFILLER_4_713 VPWR VGND VPWR VGND sky130_ef_sc_hd__decap_12
XFILLER_79_503 VGND VGND VPWR VPWR sky130_fd_sc_hd__fill_1
XFILLER_120_121 VPWR VGND VPWR VGND sky130_ef_sc_hd__decap_12
XTAP_TAPCELL_ROW_72_1168 VGND VPWR sky130_fd_sc_hd__tapvpwrvgnd_1
XFILLER_10_83 VGND VGND VPWR VPWR sky130_fd_sc_hd__fill_1
XFILLER_120_165 VPWR VGND VPWR VGND sky130_ef_sc_hd__decap_12
XFILLER_19_113 VGND VGND VPWR VPWR sky130_fd_sc_hd__fill_2
XFILLER_19_81 VPWR VGND VPWR VGND sky130_ef_sc_hd__decap_12
XFILLER_19_146 VGND VGND VPWR VPWR sky130_fd_sc_hd__fill_1
XFILLER_90_701 VPWR VGND VPWR VGND sky130_ef_sc_hd__decap_12
XTAP_TAPCELL_ROW_58_995 VGND VPWR sky130_fd_sc_hd__tapvpwrvgnd_1
XTAP_TAPCELL_ROW_58_984 VGND VPWR sky130_fd_sc_hd__tapvpwrvgnd_1
XFILLER_62_469 VGND VGND VPWR VPWR sky130_fd_sc_hd__decap_6
XFILLER_43_650 VPWR VGND VPWR VGND sky130_ef_sc_hd__decap_12
XFILLER_50_609 VPWR VGND VPWR VGND sky130_ef_sc_hd__decap_12
XTAP_TAPCELL_ROW_83_1297 VGND VPWR sky130_fd_sc_hd__tapvpwrvgnd_1
X_3500_ _1424_ _1429_ _1430_ _1431_ VGND VGND VPWR VPWR _1432_ sky130_fd_sc_hd__nor4_1
XFILLER_7_573 VPWR VGND VPWR VGND sky130_ef_sc_hd__decap_12
X_4480_ _1790_ net134 _2364_ _2362_ VGND VGND VPWR VPWR _2365_ sky130_fd_sc_hd__a31o_1
X_3431_ reg_file_inst.registry\[9\]\[18\] _1131_ _1138_ reg_file_inst.registry\[14\]\[18\]
+ VGND VGND VPWR VPWR _1366_ sky130_fd_sc_hd__a22o_1
X_6150_ clknet_leaf_18_clk _0558_ _0083_ VGND VGND VPWR VPWR reg_file_inst.registry\[6\]\[27\]
+ sky130_fd_sc_hd__dfrtp_1
X_3362_ MEMOFF\[20\] _1079_ _1094_ reg_file_inst.registry\[6\]\[20\] _1298_ VGND VGND
+ VPWR VPWR _1299_ sky130_fd_sc_hd__a221o_1
XFILLER_97_311 VPWR VGND VPWR VGND sky130_ef_sc_hd__decap_12
X_5101_ _2297_ _2720_ VGND VGND VPWR VPWR _2930_ sky130_fd_sc_hd__nand2_1
X_3293_ reg_file_inst.registry\[9\]\[23\] _1125_ _1127_ VGND VGND VPWR VPWR _1233_
+ sky130_fd_sc_hd__and3_1
XFILLER_85_517 VGND VGND VPWR VPWR sky130_fd_sc_hd__decap_3
X_6081_ clknet_leaf_12_clk _0489_ _0014_ VGND VGND VPWR VPWR reg_file_inst.registry\[15\]\[14\]
+ sky130_fd_sc_hd__dfrtp_1
XFILLER_112_699 VGND VGND VPWR VPWR sky130_fd_sc_hd__fill_1
X_5032_ _2512_ _2801_ _2868_ _2870_ VGND VGND VPWR VPWR _2871_ sky130_fd_sc_hd__a211o_1
XFILLER_93_572 VGND VGND VPWR VPWR sky130_fd_sc_hd__decap_6
XFILLER_93_561 VGND VGND VPWR VPWR sky130_fd_sc_hd__fill_2
XTAP_TAPCELL_ROW_0_248 VGND VPWR sky130_fd_sc_hd__tapvpwrvgnd_1
XTAP_TAPCELL_ROW_0_259 VGND VPWR sky130_fd_sc_hd__tapvpwrvgnd_1
XFILLER_19_691 VGND VGND VPWR VPWR sky130_fd_sc_hd__fill_1
X_5934_ net148 VGND VGND VPWR VPWR _0342_ sky130_fd_sc_hd__inv_2
XFILLER_15_39 VGND VGND VPWR VPWR sky130_fd_sc_hd__decap_8
XFILLER_34_650 VGND VGND VPWR VPWR sky130_fd_sc_hd__decap_8
X_5865_ net146 VGND VGND VPWR VPWR _0273_ sky130_fd_sc_hd__inv_2
XFILLER_80_277 VGND VGND VPWR VPWR sky130_fd_sc_hd__decap_8
X_4816_ _2596_ _2673_ _2674_ _2576_ VGND VGND VPWR VPWR _2675_ sky130_fd_sc_hd__o211ai_2
X_5796_ net149 VGND VGND VPWR VPWR _0204_ sky130_fd_sc_hd__inv_2
X_4747_ _2126_ _2555_ VGND VGND VPWR VPWR _2606_ sky130_fd_sc_hd__nor2_1
XFILLER_107_405 VPWR VGND VPWR VGND sky130_ef_sc_hd__decap_12
X_4678_ net1 _2309_ _2549_ VGND VGND VPWR VPWR _2550_ sky130_fd_sc_hd__o21a_4
XFILLER_107_449 VPWR VGND VPWR VGND sky130_ef_sc_hd__decap_12
X_3629_ reg_file_inst.registry\[3\]\[10\] net145 _1119_ VGND VGND VPWR VPWR _1556_
+ sky130_fd_sc_hd__and3_1
X_6417_ clknet_leaf_12_clk _0825_ _0350_ VGND VGND VPWR VPWR reg_file_inst.registry\[1\]\[14\]
+ sky130_fd_sc_hd__dfrtp_1
X_6348_ clknet_leaf_44_clk _0756_ _0281_ VGND VGND VPWR VPWR reg_file_inst.registry\[2\]\[1\]
+ sky130_fd_sc_hd__dfrtp_1
Xoutput49 net49 VGND VGND VPWR VPWR DataAddress[13] sky130_fd_sc_hd__buf_1
XTAP_TAPCELL_ROW_8_359 VGND VPWR sky130_fd_sc_hd__tapvpwrvgnd_1
XFILLER_102_121 VPWR VGND VPWR VGND sky130_ef_sc_hd__decap_12
XFILLER_88_377 VPWR VGND VPWR VGND sky130_ef_sc_hd__decap_12
X_6279_ clknet_leaf_15_clk _0687_ _0212_ VGND VGND VPWR VPWR MEMOFF\[16\] sky130_fd_sc_hd__dfrtp_1
XFILLER_56_35 VGND VGND VPWR VPWR sky130_fd_sc_hd__fill_1
XFILLER_29_444 VGND VGND VPWR VPWR sky130_fd_sc_hd__decap_4
XFILLER_84_572 VGND VGND VPWR VPWR sky130_fd_sc_hd__decap_6
XFILLER_72_701 VPWR VGND VPWR VGND sky130_ef_sc_hd__decap_12
XFILLER_56_68 VGND VGND VPWR VPWR sky130_fd_sc_hd__decap_4
XFILLER_17_617 VGND VGND VPWR VPWR sky130_fd_sc_hd__decap_4
XTAP_TAPCELL_ROW_27_601 VGND VPWR sky130_fd_sc_hd__tapvpwrvgnd_1
XFILLER_112_41 VPWR VGND VPWR VGND sky130_ef_sc_hd__decap_12
XFILLER_44_436 VGND VGND VPWR VPWR sky130_fd_sc_hd__fill_1
XFILLER_112_85 VPWR VGND VPWR VGND sky130_ef_sc_hd__decap_12
XFILLER_72_23 VGND VGND VPWR VPWR sky130_fd_sc_hd__decap_4
XTAP_TAPCELL_ROW_55_954 VGND VPWR sky130_fd_sc_hd__tapvpwrvgnd_1
XFILLER_32_609 VPWR VGND VPWR VGND sky130_ef_sc_hd__decap_12
XFILLER_52_491 VPWR VGND VPWR VGND sky130_ef_sc_hd__decap_12
XFILLER_40_642 VGND VGND VPWR VPWR sky130_fd_sc_hd__fill_2
XFILLER_8_359 VGND VGND VPWR VPWR sky130_fd_sc_hd__decap_4
XFILLER_99_609 VGND VGND VPWR VPWR sky130_fd_sc_hd__decap_6
XFILLER_4_587 VGND VGND VPWR VPWR sky130_fd_sc_hd__fill_1
XFILLER_121_441 VGND VGND VPWR VPWR sky130_fd_sc_hd__decap_6
XFILLER_121_485 VPWR VGND VPWR VGND sky130_ef_sc_hd__decap_12
XFILLER_79_377 VGND VGND VPWR VPWR sky130_fd_sc_hd__decap_3
XFILLER_75_561 VGND VGND VPWR VPWR sky130_fd_sc_hd__decap_8
XFILLER_35_414 VPWR VGND VPWR VGND sky130_ef_sc_hd__decap_12
XFILLER_90_531 VGND VGND VPWR VPWR sky130_fd_sc_hd__fill_1
XTAP_TAPCELL_ROW_85_1326 VGND VPWR sky130_fd_sc_hd__tapvpwrvgnd_1
X_3980_ _0952_ _1895_ VGND VGND VPWR VPWR _1896_ sky130_fd_sc_hd__nor2_1
XFILLER_90_586 VGND VGND VPWR VPWR sky130_fd_sc_hd__fill_2
Xclkbuf_0_clk clk VGND VGND VPWR VPWR clknet_0_clk sky130_fd_sc_hd__clkbuf_16
X_5650_ net147 VGND VGND VPWR VPWR _0058_ sky130_fd_sc_hd__inv_2
XFILLER_87_3 VPWR VGND VPWR VGND sky130_ef_sc_hd__decap_12
X_4601_ reg_file_inst.registry\[11\]\[3\] _2478_ _2122_ VGND VGND VPWR VPWR _0918_
+ sky130_fd_sc_hd__mux2_1
XFILLER_30_163 VGND VGND VPWR VPWR sky130_fd_sc_hd__fill_1
X_5581_ reg_file_inst.registry\[15\]\[11\] _2948_ _3003_ VGND VGND VPWR VPWR _0486_
+ sky130_fd_sc_hd__mux2_1
XFILLER_117_725 VGND VGND VPWR VPWR sky130_fd_sc_hd__fill_1
XFILLER_7_51 VGND VGND VPWR VPWR sky130_fd_sc_hd__decap_4
X_4532_ _2171_ _2414_ _2177_ VGND VGND VPWR VPWR _2415_ sky130_fd_sc_hd__a21o_1
XTAP_TAPCELL_ROW_96_1466 VGND VPWR sky130_fd_sc_hd__tapvpwrvgnd_1
XFILLER_7_381 VGND VGND VPWR VPWR sky130_fd_sc_hd__decap_8
X_4463_ _1791_ _2334_ VGND VGND VPWR VPWR _2348_ sky130_fd_sc_hd__or2_1
X_6202_ clknet_leaf_33_clk _0610_ _0135_ VGND VGND VPWR VPWR reg_file_inst.registry\[5\]\[23\]
+ sky130_fd_sc_hd__dfrtp_1
XFILLER_89_108 VGND VGND VPWR VPWR sky130_fd_sc_hd__decap_4
X_3414_ JMPOFF\[18\] _1095_ _1097_ reg_file_inst.registry\[5\]\[18\] VGND VGND VPWR
+ VPWR _1349_ sky130_fd_sc_hd__a22o_1
XPHY_EDGE_ROW_15_Right_15 VGND VGND VPWR VPWR sky130_fd_sc_hd__decap_3
X_4394_ net30 net43 _2125_ _2252_ VGND VGND VPWR VPWR _2282_ sky130_fd_sc_hd__or4_4
X_6133_ clknet_leaf_28_clk _0541_ _0066_ VGND VGND VPWR VPWR reg_file_inst.registry\[6\]\[10\]
+ sky130_fd_sc_hd__dfrtp_1
X_3345_ reg_file_inst.registry\[6\]\[21\] _1123_ _1132_ VGND VGND VPWR VPWR _1283_
+ sky130_fd_sc_hd__and3_1
XFILLER_100_625 VPWR VGND VPWR VGND sky130_ef_sc_hd__decap_12
X_3276_ _1209_ _1212_ _1216_ _1118_ reg_file_inst.registry\[0\]\[24\] VGND VGND VPWR
+ VPWR net89 sky130_fd_sc_hd__o32a_2
X_6064_ net146 VGND VGND VPWR VPWR _0472_ sky130_fd_sc_hd__inv_2
XTAP_TAPCELL_ROW_5_329 VGND VPWR sky130_fd_sc_hd__tapvpwrvgnd_1
XFILLER_100_669 VPWR VGND VPWR VGND sky130_ef_sc_hd__decap_12
X_5015_ _2129_ _2487_ _2721_ VGND VGND VPWR VPWR _2856_ sky130_fd_sc_hd__o21a_1
XFILLER_38_230 VPWR VGND VPWR VGND sky130_ef_sc_hd__decap_12
XFILLER_54_701 VPWR VGND VPWR VGND sky130_ef_sc_hd__decap_12
XFILLER_26_27 VGND VGND VPWR VPWR sky130_fd_sc_hd__fill_1
XPHY_EDGE_ROW_24_Right_24 VGND VGND VPWR VPWR sky130_fd_sc_hd__decap_3
XTAP_TAPCELL_ROW_105_1573 VGND VPWR sky130_fd_sc_hd__tapvpwrvgnd_1
X_5917_ net148 VGND VGND VPWR VPWR _0325_ sky130_fd_sc_hd__inv_2
XTAP_TAPCELL_ROW_52_913 VGND VPWR sky130_fd_sc_hd__tapvpwrvgnd_1
X_5848_ net146 VGND VGND VPWR VPWR _0256_ sky130_fd_sc_hd__inv_2
X_5779_ net44 VGND VGND VPWR VPWR _0187_ sky130_fd_sc_hd__inv_2
XTAP_TAPCELL_ROW_32_670 VGND VPWR sky130_fd_sc_hd__tapvpwrvgnd_1
XFILLER_5_307 VGND VGND VPWR VPWR sky130_fd_sc_hd__decap_4
XPHY_EDGE_ROW_2_Left_125 VGND VGND VPWR VPWR sky130_fd_sc_hd__decap_3
XFILLER_107_279 VGND VGND VPWR VPWR sky130_fd_sc_hd__fill_1
XFILLER_1_502 VGND VGND VPWR VPWR sky130_fd_sc_hd__fill_2
XPHY_EDGE_ROW_33_Right_33 VGND VGND VPWR VPWR sky130_fd_sc_hd__decap_3
XFILLER_122_249 VGND VGND VPWR VPWR sky130_fd_sc_hd__decap_3
XFILLER_89_653 VPWR VGND VPWR VGND sky130_ef_sc_hd__decap_12
XFILLER_88_141 VPWR VGND VPWR VGND sky130_ef_sc_hd__decap_12
XFILLER_89_697 VPWR VGND VPWR VGND sky130_ef_sc_hd__decap_12
XFILLER_57_572 VPWR VGND VPWR VGND sky130_ef_sc_hd__decap_12
XFILLER_57_561 VGND VGND VPWR VPWR sky130_fd_sc_hd__fill_2
XFILLER_72_531 VGND VGND VPWR VPWR sky130_fd_sc_hd__fill_1
XPHY_EDGE_ROW_42_Right_42 VGND VGND VPWR VPWR sky130_fd_sc_hd__decap_3
XFILLER_83_55 VGND VGND VPWR VPWR sky130_fd_sc_hd__fill_1
XFILLER_16_71 VGND VGND VPWR VPWR sky130_fd_sc_hd__fill_1
XTAP_TAPCELL_ROW_80_1267 VGND VPWR sky130_fd_sc_hd__tapvpwrvgnd_1
XFILLER_8_134 VGND VGND VPWR VPWR sky130_fd_sc_hd__decap_6
XPHY_EDGE_ROW_51_Right_51 VGND VGND VPWR VPWR sky130_fd_sc_hd__decap_3
XTAP_TAPCELL_ROW_10_386 VGND VPWR sky130_fd_sc_hd__tapvpwrvgnd_1
XFILLER_113_205 VPWR VGND VPWR VGND sky130_ef_sc_hd__decap_12
XFILLER_113_249 VPWR VGND VPWR VGND sky130_ef_sc_hd__decap_12
XTAP_TAPCELL_ROW_91_1396 VGND VPWR sky130_fd_sc_hd__tapvpwrvgnd_1
XFILLER_79_163 VGND VGND VPWR VPWR sky130_fd_sc_hd__decap_4
X_3130_ net34 net38 net39 VGND VGND VPWR VPWR _1074_ sky130_fd_sc_hd__nor3_2
XFILLER_121_293 VPWR VGND VPWR VGND sky130_ef_sc_hd__decap_12
XFILLER_79_185 VPWR VGND VPWR VGND sky130_ef_sc_hd__decap_12
XPHY_EDGE_ROW_66_Left_189 VGND VGND VPWR VPWR sky130_fd_sc_hd__decap_3
XPHY_EDGE_ROW_60_Right_60 VGND VGND VPWR VPWR sky130_fd_sc_hd__decap_3
X_3061_ JMPOFF\[2\] net36 _0966_ VGND VGND VPWR VPWR _1005_ sky130_fd_sc_hd__and3_1
XFILLER_36_701 VGND VGND VPWR VPWR sky130_fd_sc_hd__decap_4
XFILLER_48_572 VGND VGND VPWR VPWR sky130_fd_sc_hd__fill_1
XFILLER_63_597 VPWR VGND VPWR VGND sky130_ef_sc_hd__decap_12
XTAP_TAPCELL_ROW_18_486 VGND VPWR sky130_fd_sc_hd__tapvpwrvgnd_1
XFILLER_23_417 VGND VGND VPWR VPWR sky130_fd_sc_hd__decap_6
X_3963_ _0970_ _0971_ _1072_ VGND VGND VPWR VPWR _1879_ sky130_fd_sc_hd__and3_1
X_5702_ net148 VGND VGND VPWR VPWR _0110_ sky130_fd_sc_hd__inv_2
X_3894_ reg_file_inst.registry\[2\]\[1\] _1083_ _1807_ _1808_ _1809_ VGND VGND VPWR
+ VPWR _1812_ sky130_fd_sc_hd__a2111o_1
X_5633_ net147 VGND VGND VPWR VPWR _0041_ sky130_fd_sc_hd__inv_2
XFILLER_12_18 VGND VGND VPWR VPWR sky130_fd_sc_hd__decap_8
XFILLER_31_483 VGND VGND VPWR VPWR sky130_fd_sc_hd__fill_1
XPHY_EDGE_ROW_75_Left_198 VGND VGND VPWR VPWR sky130_fd_sc_hd__decap_3
XFILLER_12_29 VPWR VGND VPWR VGND sky130_ef_sc_hd__decap_12
X_5564_ _1120_ _2991_ VGND VGND VPWR VPWR _3003_ sky130_fd_sc_hd__nor2_8
X_4515_ net136 _2391_ _2191_ VGND VGND VPWR VPWR _2398_ sky130_fd_sc_hd__a21o_1
XFILLER_105_717 VGND VGND VPWR VPWR sky130_fd_sc_hd__decap_3
XPHY_EDGE_ROW_103_Right_103 VGND VGND VPWR VPWR sky130_fd_sc_hd__decap_3
X_5495_ JMPOFF\[10\] _2960_ _3000_ VGND VGND VPWR VPWR _0569_ sky130_fd_sc_hd__mux2_1
XFILLER_104_227 VPWR VGND VPWR VGND sky130_ef_sc_hd__decap_12
X_4446_ net132 _2215_ VGND VGND VPWR VPWR _2331_ sky130_fd_sc_hd__nor2_1
X_4377_ _2261_ _2264_ net135 VGND VGND VPWR VPWR _2265_ sky130_fd_sc_hd__mux2_1
XFILLER_98_483 VGND VGND VPWR VPWR sky130_fd_sc_hd__fill_1
X_3328_ _1262_ _1263_ _1266_ _1118_ reg_file_inst.registry\[0\]\[22\] VGND VGND VPWR
+ VPWR net87 sky130_fd_sc_hd__o32a_2
XFILLER_86_601 VPWR VGND VPWR VGND sky130_ef_sc_hd__decap_12
X_6116_ clknet_leaf_42_clk _0524_ _0049_ VGND VGND VPWR VPWR reg_file_inst.registry\[9\]\[21\]
+ sky130_fd_sc_hd__dfrtp_1
XFILLER_86_645 VPWR VGND VPWR VGND sky130_ef_sc_hd__decap_12
XFILLER_85_122 VPWR VGND VPWR VGND sky130_ef_sc_hd__decap_12
XFILLER_85_111 VGND VGND VPWR VPWR sky130_fd_sc_hd__fill_1
XFILLER_100_477 VGND VGND VPWR VPWR sky130_fd_sc_hd__decap_4
X_3259_ reg_file_inst.registry\[8\]\[24\] _1090_ _1091_ reg_file_inst.registry\[3\]\[24\]
+ VGND VGND VPWR VPWR _1200_ sky130_fd_sc_hd__a22o_1
X_6047_ net146 VGND VGND VPWR VPWR _0455_ sky130_fd_sc_hd__inv_2
XFILLER_27_701 VGND VGND VPWR VPWR sky130_fd_sc_hd__decap_4
XFILLER_37_37 VGND VGND VPWR VPWR sky130_fd_sc_hd__decap_4
XFILLER_39_561 VPWR VGND VPWR VGND sky130_ef_sc_hd__decap_12
XTAP_TAPCELL_ROW_107_1602 VGND VPWR sky130_fd_sc_hd__tapvpwrvgnd_1
XFILLER_54_542 VGND VGND VPWR VPWR sky130_fd_sc_hd__decap_4
XFILLER_41_214 VGND VGND VPWR VPWR sky130_fd_sc_hd__decap_8
XFILLER_53_69 VGND VGND VPWR VPWR sky130_fd_sc_hd__decap_6
XFILLER_41_225 VPWR VGND VPWR VGND sky130_ef_sc_hd__decap_12
XFILLER_10_601 VPWR VGND VPWR VGND sky130_ef_sc_hd__decap_12
XFILLER_22_461 VGND VGND VPWR VPWR sky130_fd_sc_hd__decap_3
XFILLER_10_645 VPWR VGND VPWR VGND sky130_ef_sc_hd__decap_12
XTAP_TAPCELL_ROW_118_1742 VGND VPWR sky130_fd_sc_hd__tapvpwrvgnd_1
XFILLER_108_533 VPWR VGND VPWR VGND sky130_ef_sc_hd__decap_12
XFILLER_78_22 VGND VGND VPWR VPWR sky130_fd_sc_hd__decap_6
XFILLER_78_11 VGND VGND VPWR VPWR sky130_fd_sc_hd__fill_2
XFILLER_111_709 VPWR VGND VPWR VGND sky130_ef_sc_hd__decap_12
XFILLER_78_66 VGND VGND VPWR VPWR sky130_fd_sc_hd__decap_6
XFILLER_94_32 VGND VGND VPWR VPWR sky130_fd_sc_hd__decap_4
XFILLER_76_155 VGND VGND VPWR VPWR sky130_fd_sc_hd__decap_3
XFILLER_18_701 VPWR VGND VPWR VGND sky130_ef_sc_hd__decap_12
XFILLER_94_65 VGND VGND VPWR VPWR sky130_fd_sc_hd__fill_1
XFILLER_92_637 VGND VGND VPWR VPWR sky130_fd_sc_hd__decap_6
XFILLER_91_136 VGND VGND VPWR VPWR sky130_fd_sc_hd__decap_8
XTAP_TAPCELL_ROW_69_1129 VGND VPWR sky130_fd_sc_hd__tapvpwrvgnd_1
XFILLER_45_531 VGND VGND VPWR VPWR sky130_fd_sc_hd__decap_4
XFILLER_72_372 VGND VGND VPWR VPWR sky130_fd_sc_hd__decap_6
XFILLER_60_589 VPWR VGND VPWR VGND sky130_ef_sc_hd__decap_12
XTAP_TAPCELL_ROW_15_456 VGND VPWR sky130_fd_sc_hd__tapvpwrvgnd_1
XFILLER_32_269 VGND VGND VPWR VPWR sky130_fd_sc_hd__fill_1
XTAP_TAPCELL_ROW_43_798 VGND VPWR sky130_fd_sc_hd__tapvpwrvgnd_1
XFILLER_71_6 VGND VGND VPWR VPWR sky130_fd_sc_hd__decap_6
XFILLER_40_291 VPWR VGND VPWR VGND sky130_ef_sc_hd__decap_12
XTAP_TAPCELL_ROW_93_1425 VGND VPWR sky130_fd_sc_hd__tapvpwrvgnd_1
XFILLER_114_525 VGND VGND VPWR VPWR sky130_fd_sc_hd__decap_6
X_5280_ _2817_ reg_file_inst.registry\[2\]\[22\] _2993_ VGND VGND VPWR VPWR _0777_
+ sky130_fd_sc_hd__mux2_1
XFILLER_5_671 VGND VGND VPWR VPWR sky130_fd_sc_hd__fill_1
X_4300_ _1357_ _2187_ VGND VGND VPWR VPWR _2188_ sky130_fd_sc_hd__nor2_1
XFILLER_114_569 VPWR VGND VPWR VGND sky130_ef_sc_hd__decap_12
XFILLER_4_41 VPWR VGND VPWR VGND sky130_ef_sc_hd__decap_12
X_4231_ _0958_ net37 _2117_ VGND VGND VPWR VPWR _2119_ sky130_fd_sc_hd__a21oi_1
XFILLER_4_85 VGND VGND VPWR VPWR sky130_fd_sc_hd__decap_3
XFILLER_95_420 VPWR VGND VPWR VGND sky130_ef_sc_hd__decap_12
XFILLER_68_645 VGND VGND VPWR VPWR sky130_fd_sc_hd__decap_8
XFILLER_68_634 VGND VGND VPWR VPWR sky130_fd_sc_hd__decap_8
XFILLER_67_111 VGND VGND VPWR VPWR sky130_fd_sc_hd__fill_1
X_4162_ _2072_ net116 net130 VGND VGND VPWR VPWR _0944_ sky130_fd_sc_hd__mux2_1
X_4093_ net131 _2007_ _2008_ net114 VGND VGND VPWR VPWR _2009_ sky130_fd_sc_hd__a31oi_1
X_3113_ JMPOFF\[15\] JMPOFF\[14\] _0967_ VGND VGND VPWR VPWR _1057_ sky130_fd_sc_hd__o21ai_1
XFILLER_83_626 VPWR VGND VPWR VGND sky130_ef_sc_hd__decap_12
XFILLER_82_114 VGND VGND VPWR VPWR sky130_fd_sc_hd__decap_4
X_3044_ _0978_ _0987_ VGND VGND VPWR VPWR _0988_ sky130_fd_sc_hd__nand2_1
XFILLER_51_501 VGND VGND VPWR VPWR sky130_fd_sc_hd__decap_3
XFILLER_23_214 VGND VGND VPWR VPWR sky130_fd_sc_hd__fill_1
X_4995_ _2442_ _2802_ _2836_ _1765_ _2839_ VGND VGND VPWR VPWR _2840_ sky130_fd_sc_hd__o221a_1
XFILLER_23_225 VGND VGND VPWR VPWR sky130_fd_sc_hd__decap_8
XTAP_TAPCELL_ROW_102_1543 VGND VPWR sky130_fd_sc_hd__tapvpwrvgnd_1
XPHY_EDGE_ROW_83_Left_206 VGND VGND VPWR VPWR sky130_fd_sc_hd__decap_3
X_3946_ _1858_ _1861_ _1420_ _1641_ VGND VGND VPWR VPWR _1862_ sky130_fd_sc_hd__o211a_1
X_3877_ reg_file_inst.registry\[15\]\[2\] _1122_ _1136_ reg_file_inst.registry\[8\]\[2\]
+ _1117_ VGND VGND VPWR VPWR _1796_ sky130_fd_sc_hd__a221o_1
X_5616_ net149 VGND VGND VPWR VPWR _0024_ sky130_fd_sc_hd__inv_2
XFILLER_105_503 VGND VGND VPWR VPWR sky130_fd_sc_hd__fill_1
X_5547_ _2883_ reg_file_inst.registry\[9\]\[16\] _3002_ VGND VGND VPWR VPWR _0519_
+ sky130_fd_sc_hd__mux2_1
XFILLER_117_385 VGND VGND VPWR VPWR sky130_fd_sc_hd__decap_6
X_5478_ JMPOFF\[27\] _2715_ _3000_ VGND VGND VPWR VPWR _0586_ sky130_fd_sc_hd__mux2_1
X_4429_ net132 _2257_ VGND VGND VPWR VPWR _2314_ sky130_fd_sc_hd__or2_1
XTAP_TAPCELL_ROW_113_1672 VGND VPWR sky130_fd_sc_hd__tapvpwrvgnd_1
XPHY_EDGE_ROW_92_Left_215 VGND VGND VPWR VPWR sky130_fd_sc_hd__decap_3
XFILLER_104_20 VGND VGND VPWR VPWR sky130_fd_sc_hd__decap_8
XFILLER_104_53 VPWR VGND VPWR VGND sky130_ef_sc_hd__decap_12
XFILLER_100_285 VGND VGND VPWR VPWR sky130_fd_sc_hd__fill_2
XFILLER_46_339 VPWR VGND VPWR VGND sky130_ef_sc_hd__decap_12
XFILLER_104_97 VPWR VGND VPWR VGND sky130_ef_sc_hd__decap_12
XFILLER_39_391 VGND VGND VPWR VPWR sky130_fd_sc_hd__fill_1
XFILLER_82_681 VPWR VGND VPWR VGND sky130_ef_sc_hd__decap_12
XFILLER_54_350 VGND VGND VPWR VPWR sky130_fd_sc_hd__decap_3
XFILLER_120_41 VPWR VGND VPWR VGND sky130_ef_sc_hd__decap_12
XTAP_TAPCELL_ROW_64_1059 VGND VPWR sky130_fd_sc_hd__tapvpwrvgnd_1
XFILLER_120_85 VPWR VGND VPWR VGND sky130_ef_sc_hd__decap_12
XTAP_TAPCELL_ROW_12_415 VGND VPWR sky130_fd_sc_hd__tapvpwrvgnd_1
XFILLER_10_442 VGND VGND VPWR VPWR sky130_fd_sc_hd__decap_8
XFILLER_22_291 VPWR VGND VPWR VGND sky130_ef_sc_hd__decap_12
XTAP_TAPCELL_ROW_40_768 VGND VPWR sky130_fd_sc_hd__tapvpwrvgnd_1
XFILLER_108_363 VGND VGND VPWR VPWR sky130_fd_sc_hd__fill_1
XFILLER_111_517 VPWR VGND VPWR VGND sky130_ef_sc_hd__decap_12
XTAP_TAPCELL_ROW_75_1199 VGND VPWR sky130_fd_sc_hd__tapvpwrvgnd_1
XFILLER_77_464 VGND VGND VPWR VPWR sky130_fd_sc_hd__fill_1
XFILLER_65_615 VGND VGND VPWR VPWR sky130_fd_sc_hd__fill_1
XFILLER_65_604 VGND VGND VPWR VPWR sky130_fd_sc_hd__fill_2
XFILLER_65_648 VPWR VGND VPWR VGND sky130_ef_sc_hd__decap_12
XFILLER_64_147 VGND VGND VPWR VPWR sky130_fd_sc_hd__fill_2
XFILLER_38_91 VGND VGND VPWR VPWR sky130_fd_sc_hd__decap_3
XTAP_TAPCELL_ROW_48_868 VGND VPWR sky130_fd_sc_hd__tapvpwrvgnd_1
XFILLER_73_681 VGND VGND VPWR VPWR sky130_fd_sc_hd__fill_1
XFILLER_33_545 VPWR VGND VPWR VGND sky130_ef_sc_hd__decap_12
X_4780_ _1433_ _2186_ _2555_ _2126_ VGND VGND VPWR VPWR _2639_ sky130_fd_sc_hd__a31o_1
X_3800_ MEMOFF\[4\] net95 _1113_ VGND VGND VPWR VPWR _1721_ sky130_fd_sc_hd__mux2_4
XFILLER_60_386 VPWR VGND VPWR VGND sky130_ef_sc_hd__decap_12
XFILLER_20_206 VGND VGND VPWR VPWR sky130_fd_sc_hd__decap_4
XFILLER_20_228 VPWR VGND VPWR VGND sky130_ef_sc_hd__decap_12
X_3731_ reg_file_inst.registry\[8\]\[7\] _0959_ _1114_ _0956_ _0958_ VGND VGND VPWR
+ VPWR _1655_ sky130_fd_sc_hd__o2111a_1
XFILLER_119_617 VPWR VGND VPWR VGND sky130_ef_sc_hd__decap_12
X_3662_ reg_file_inst.registry\[15\]\[9\] _1122_ _1138_ reg_file_inst.registry\[14\]\[9\]
+ _1117_ VGND VGND VPWR VPWR _1588_ sky130_fd_sc_hd__a221o_1
Xclkload10 clknet_leaf_61_clk VGND VGND VPWR VPWR clkload10/Y sky130_fd_sc_hd__clkinvlp_4
X_6450_ clknet_leaf_63_clk _0858_ _0383_ VGND VGND VPWR VPWR reg_file_inst.registry\[0\]\[11\]
+ sky130_fd_sc_hd__dfrtp_1
Xclkload21 clknet_leaf_15_clk VGND VGND VPWR VPWR clkload21/Y sky130_fd_sc_hd__inv_6
Xclkload32 clknet_leaf_26_clk VGND VGND VPWR VPWR clkload32/X sky130_fd_sc_hd__clkbuf_4
X_5401_ reg_file_inst.registry\[4\]\[17\] _2873_ _2997_ VGND VGND VPWR VPWR _0660_
+ sky130_fd_sc_hd__mux2_1
Xclkload43 clknet_leaf_50_clk VGND VGND VPWR VPWR clkload43/X sky130_fd_sc_hd__clkbuf_4
X_3593_ reg_file_inst.registry\[7\]\[11\] _1086_ _1092_ reg_file_inst.registry\[4\]\[11\]
+ _1520_ VGND VGND VPWR VPWR _1521_ sky130_fd_sc_hd__a221o_1
X_6381_ clknet_leaf_60_clk _0789_ _0314_ VGND VGND VPWR VPWR reg_file_inst.registry\[14\]\[6\]
+ sky130_fd_sc_hd__dfrtp_1
Xclkload54 clknet_leaf_36_clk VGND VGND VPWR VPWR clkload54/Y sky130_fd_sc_hd__inv_6
X_5332_ _1119_ _2987_ VGND VGND VPWR VPWR _2995_ sky130_fd_sc_hd__nand2_8
XFILLER_114_333 VPWR VGND VPWR VGND sky130_ef_sc_hd__decap_12
XFILLER_5_490 VPWR VGND VPWR VGND sky130_ef_sc_hd__decap_12
XFILLER_114_377 VPWR VGND VPWR VGND sky130_ef_sc_hd__decap_12
XFILLER_87_206 VPWR VGND VPWR VGND sky130_ef_sc_hd__decap_12
X_5263_ reg_file_inst.registry\[14\]\[10\] _2960_ _2992_ VGND VGND VPWR VPWR _0793_
+ sky130_fd_sc_hd__mux2_1
X_4214_ _1965_ _2106_ VGND VGND VPWR VPWR _2107_ sky130_fd_sc_hd__xnor2_1
X_5194_ _2948_ reg_file_inst.registry\[0\]\[11\] _2988_ VGND VGND VPWR VPWR _0858_
+ sky130_fd_sc_hd__mux2_1
X_4145_ net121 _2060_ VGND VGND VPWR VPWR _2061_ sky130_fd_sc_hd__xor2_1
XFILLER_83_401 VGND VGND VPWR VPWR sky130_fd_sc_hd__fill_2
XFILLER_56_637 VGND VGND VPWR VPWR sky130_fd_sc_hd__decap_6
XFILLER_55_125 VPWR VGND VPWR VGND sky130_ef_sc_hd__decap_12
XFILLER_83_456 VPWR VGND VPWR VGND sky130_ef_sc_hd__decap_12
XFILLER_83_445 VGND VGND VPWR VPWR sky130_fd_sc_hd__decap_3
X_4076_ _1974_ _1975_ _1986_ _1921_ _1910_ VGND VGND VPWR VPWR _1992_ sky130_fd_sc_hd__a2111o_1
X_3027_ JMPOFF\[24\] _0967_ VGND VGND VPWR VPWR _0971_ sky130_fd_sc_hd__nand2_1
XFILLER_71_629 VGND VGND VPWR VPWR sky130_fd_sc_hd__decap_3
XFILLER_55_169 VPWR VGND VPWR VGND sky130_ef_sc_hd__decap_12
XFILLER_36_361 VGND VGND VPWR VPWR sky130_fd_sc_hd__decap_3
XFILLER_70_128 VGND VGND VPWR VPWR sky130_fd_sc_hd__decap_3
XFILLER_51_331 VGND VGND VPWR VPWR sky130_fd_sc_hd__decap_4
XFILLER_34_27 VGND VGND VPWR VPWR sky130_fd_sc_hd__fill_1
XFILLER_12_718 VGND VGND VPWR VPWR sky130_fd_sc_hd__fill_1
XFILLER_34_49 VGND VGND VPWR VPWR sky130_fd_sc_hd__decap_6
XFILLER_11_239 VGND VGND VPWR VPWR sky130_fd_sc_hd__fill_2
X_4978_ _2755_ _2763_ _1790_ VGND VGND VPWR VPWR _2825_ sky130_fd_sc_hd__mux2_1
XFILLER_24_589 VGND VGND VPWR VPWR sky130_fd_sc_hd__decap_4
XFILLER_109_105 VGND VGND VPWR VPWR sky130_fd_sc_hd__decap_6
Xclkload4 clknet_3_7__leaf_clk VGND VGND VPWR VPWR clkload4/X sky130_fd_sc_hd__clkbuf_2
X_3929_ reg_file_inst.registry\[15\]\[0\] _1122_ _1135_ reg_file_inst.registry\[6\]\[0\]
+ _1117_ VGND VGND VPWR VPWR _1846_ sky130_fd_sc_hd__a221o_1
XFILLER_50_48 VPWR VGND VPWR VGND sky130_ef_sc_hd__decap_12
XTAP_TAPCELL_ROW_115_1701 VGND VPWR sky130_fd_sc_hd__tapvpwrvgnd_1
XFILLER_109_149 VPWR VGND VPWR VGND sky130_ef_sc_hd__decap_12
XFILLER_117_193 VPWR VGND VPWR VGND sky130_ef_sc_hd__decap_12
XFILLER_59_24 VGND VGND VPWR VPWR sky130_fd_sc_hd__decap_4
XFILLER_3_449 VGND VGND VPWR VPWR sky130_fd_sc_hd__fill_1
XFILLER_105_377 VGND VGND VPWR VPWR sky130_fd_sc_hd__decap_4
XFILLER_78_217 VGND VGND VPWR VPWR sky130_fd_sc_hd__decap_3
XFILLER_59_35 VPWR VGND VPWR VGND sky130_ef_sc_hd__decap_12
XFILLER_101_561 VPWR VGND VPWR VGND sky130_ef_sc_hd__decap_12
XFILLER_55_670 VGND VGND VPWR VPWR sky130_fd_sc_hd__fill_2
XFILLER_34_309 VPWR VGND VPWR VGND sky130_ef_sc_hd__decap_12
XTAP_TAPCELL_ROW_45_827 VGND VPWR sky130_fd_sc_hd__tapvpwrvgnd_1
XFILLER_91_55 VGND VGND VPWR VPWR sky130_fd_sc_hd__fill_1
XFILLER_15_589 VPWR VGND VPWR VGND sky130_ef_sc_hd__decap_12
XTAP_TAPCELL_ROW_25_573 VGND VPWR sky130_fd_sc_hd__tapvpwrvgnd_1
XFILLER_30_548 VGND VGND VPWR VPWR sky130_fd_sc_hd__fill_1
XTAP_TAPCELL_ROW_77_1228 VGND VPWR sky130_fd_sc_hd__tapvpwrvgnd_1
XFILLER_69_206 VPWR VGND VPWR VGND sky130_ef_sc_hd__decap_12
XFILLER_97_559 VGND VGND VPWR VPWR sky130_fd_sc_hd__fill_1
XFILLER_97_548 VGND VGND VPWR VPWR sky130_fd_sc_hd__fill_2
XFILLER_2_493 VPWR VGND VPWR VGND sky130_ef_sc_hd__decap_12
XFILLER_84_209 VGND VGND VPWR VPWR sky130_fd_sc_hd__decap_3
XFILLER_77_250 VPWR VGND VPWR VGND sky130_ef_sc_hd__decap_12
XFILLER_37_103 VGND VGND VPWR VPWR sky130_fd_sc_hd__fill_1
XFILLER_37_125 VPWR VGND VPWR VGND sky130_ef_sc_hd__decap_12
XTAP_TAPCELL_ROW_88_1368 VGND VPWR sky130_fd_sc_hd__tapvpwrvgnd_1
X_5950_ net146 VGND VGND VPWR VPWR _0358_ sky130_fd_sc_hd__inv_2
XFILLER_53_629 VPWR VGND VPWR VGND sky130_ef_sc_hd__decap_12
XFILLER_52_106 VPWR VGND VPWR VGND sky130_ef_sc_hd__decap_12
XFILLER_37_169 VGND VGND VPWR VPWR sky130_fd_sc_hd__decap_8
XFILLER_52_128 VPWR VGND VPWR VGND sky130_ef_sc_hd__decap_12
X_4901_ _2704_ _2708_ _1816_ VGND VGND VPWR VPWR _2756_ sky130_fd_sc_hd__mux2_1
XFILLER_46_692 VGND VGND VPWR VPWR sky130_fd_sc_hd__decap_8
X_5881_ net148 VGND VGND VPWR VPWR _0289_ sky130_fd_sc_hd__inv_2
XFILLER_61_673 VPWR VGND VPWR VGND sky130_ef_sc_hd__decap_12
X_4832_ _1816_ _2240_ _2298_ VGND VGND VPWR VPWR _2691_ sky130_fd_sc_hd__or3_1
X_4763_ _2135_ _2178_ _2621_ VGND VGND VPWR VPWR _2622_ sky130_fd_sc_hd__o21ai_1
X_4694_ _1120_ _2552_ VGND VGND VPWR VPWR _2553_ sky130_fd_sc_hd__nor2_8
X_3714_ _1323_ _1633_ _1637_ VGND VGND VPWR VPWR _1638_ sky130_fd_sc_hd__o21ai_1
X_6502_ clknet_leaf_3_clk _0910_ _0435_ VGND VGND VPWR VPWR reg_file_inst.registry\[11\]\[11\]
+ sky130_fd_sc_hd__dfrtp_1
XFILLER_119_447 VGND VGND VPWR VPWR sky130_fd_sc_hd__fill_1
XFILLER_107_609 VGND VGND VPWR VPWR sky130_fd_sc_hd__decap_6
X_6433_ clknet_leaf_25_clk _0841_ _0366_ VGND VGND VPWR VPWR reg_file_inst.registry\[11\]\[18\]
+ sky130_fd_sc_hd__dfrtp_1
XTAP_TAPCELL_ROW_99_1497 VGND VPWR sky130_fd_sc_hd__tapvpwrvgnd_1
X_3645_ reg_file_inst.registry\[15\]\[9\] _1093_ VGND VGND VPWR VPWR _1571_ sky130_fd_sc_hd__and2_1
XFILLER_20_29 VGND VGND VPWR VPWR sky130_fd_sc_hd__fill_2
XFILLER_115_653 VPWR VGND VPWR VGND sky130_ef_sc_hd__decap_12
X_6364_ clknet_leaf_24_clk _0772_ _0297_ VGND VGND VPWR VPWR reg_file_inst.registry\[2\]\[17\]
+ sky130_fd_sc_hd__dfrtp_1
X_3576_ reg_file_inst.registry\[7\]\[14\] _1119_ net142 VGND VGND VPWR VPWR _1505_
+ sky130_fd_sc_hd__and3_1
XFILLER_114_141 VPWR VGND VPWR VGND sky130_ef_sc_hd__decap_12
XFILLER_102_303 VGND VGND VPWR VPWR sky130_fd_sc_hd__decap_4
X_5315_ _2883_ reg_file_inst.registry\[8\]\[16\] _2994_ VGND VGND VPWR VPWR _0743_
+ sky130_fd_sc_hd__mux2_1
X_6295_ clknet_leaf_54_clk _0703_ _0228_ VGND VGND VPWR VPWR reg_file_inst.registry\[3\]\[4\]
+ sky130_fd_sc_hd__dfrtp_1
XFILLER_115_697 VPWR VGND VPWR VGND sky130_ef_sc_hd__decap_12
XFILLER_102_325 VPWR VGND VPWR VGND sky130_ef_sc_hd__decap_12
X_5246_ reg_file_inst.registry\[14\]\[27\] _2715_ _2992_ VGND VGND VPWR VPWR _0810_
+ sky130_fd_sc_hd__mux2_1
XFILLER_88_559 VGND VGND VPWR VPWR sky130_fd_sc_hd__fill_2
XTAP_TAPCELL_ROW_110_1642 VGND VPWR sky130_fd_sc_hd__tapvpwrvgnd_1
XPHY_EDGE_ROW_89_Right_89 VGND VGND VPWR VPWR sky130_fd_sc_hd__decap_3
X_5177_ _1114_ _2987_ VGND VGND VPWR VPWR _2988_ sky130_fd_sc_hd__nand2_8
X_4128_ net117 _2043_ VGND VGND VPWR VPWR _2044_ sky130_fd_sc_hd__and2_1
XFILLER_28_125 VPWR VGND VPWR VGND sky130_ef_sc_hd__decap_12
XFILLER_83_275 VGND VGND VPWR VPWR sky130_fd_sc_hd__fill_2
XFILLER_56_467 VGND VGND VPWR VPWR sky130_fd_sc_hd__decap_8
X_4059_ _1938_ _1972_ _1929_ _1934_ VGND VGND VPWR VPWR _1975_ sky130_fd_sc_hd__o211a_1
XTAP_TAPCELL_ROW_121_1771 VGND VPWR sky130_fd_sc_hd__tapvpwrvgnd_1
XPHY_EDGE_ROW_98_Right_98 VGND VGND VPWR VPWR sky130_fd_sc_hd__decap_3
XTAP_TAPCELL_ROW_61_1029 VGND VPWR sky130_fd_sc_hd__tapvpwrvgnd_1
XFILLER_24_397 VGND VGND VPWR VPWR sky130_fd_sc_hd__decap_8
XTAP_TAPCELL_ROW_121_1782 VGND VPWR sky130_fd_sc_hd__tapvpwrvgnd_1
XTAP_TAPCELL_ROW_22_543 VGND VPWR sky130_fd_sc_hd__tapvpwrvgnd_1
XTAP_TAPCELL_ROW_50_885 VGND VPWR sky130_fd_sc_hd__tapvpwrvgnd_1
XFILLER_117_3 VPWR VGND VPWR VGND sky130_ef_sc_hd__decap_12
XFILLER_4_725 VGND VGND VPWR VPWR sky130_fd_sc_hd__fill_1
XFILLER_3_213 VGND VGND VPWR VPWR sky130_fd_sc_hd__fill_1
XFILLER_79_559 VGND VGND VPWR VPWR sky130_fd_sc_hd__fill_1
XTAP_TAPCELL_ROW_72_1158 VGND VPWR sky130_fd_sc_hd__tapvpwrvgnd_1
XFILLER_3_279 VGND VGND VPWR VPWR sky130_fd_sc_hd__fill_1
XFILLER_120_133 VGND VGND VPWR VPWR sky130_fd_sc_hd__decap_6
XTAP_TAPCELL_ROW_72_1169 VGND VPWR sky130_fd_sc_hd__tapvpwrvgnd_1
XFILLER_120_177 VPWR VGND VPWR VGND sky130_ef_sc_hd__decap_12
XFILLER_75_721 VGND VGND VPWR VPWR sky130_fd_sc_hd__fill_2
XFILLER_101_380 VPWR VGND VPWR VGND sky130_ef_sc_hd__decap_12
XFILLER_90_713 VGND VGND VPWR VPWR sky130_fd_sc_hd__decap_6
XFILLER_74_253 VGND VGND VPWR VPWR sky130_fd_sc_hd__decap_8
XTAP_TAPCELL_ROW_58_985 VGND VPWR sky130_fd_sc_hd__tapvpwrvgnd_1
XFILLER_19_93 VGND VGND VPWR VPWR sky130_fd_sc_hd__decap_6
XFILLER_19_158 VGND VGND VPWR VPWR sky130_fd_sc_hd__decap_6
XTAP_TAPCELL_ROW_2_290 VGND VPWR sky130_fd_sc_hd__tapvpwrvgnd_1
XFILLER_34_128 VGND VGND VPWR VPWR sky130_fd_sc_hd__fill_1
XFILLER_34_139 VGND VGND VPWR VPWR sky130_fd_sc_hd__fill_1
XFILLER_15_353 VGND VGND VPWR VPWR sky130_fd_sc_hd__fill_1
XFILLER_43_662 VGND VGND VPWR VPWR sky130_fd_sc_hd__decap_8
XFILLER_96_8 VPWR VGND VPWR VGND sky130_ef_sc_hd__decap_12
XFILLER_30_301 VGND VGND VPWR VPWR sky130_fd_sc_hd__decap_3
XFILLER_43_673 VGND VGND VPWR VPWR sky130_fd_sc_hd__decap_6
XTAP_TAPCELL_ROW_83_1298 VGND VPWR sky130_fd_sc_hd__tapvpwrvgnd_1
XFILLER_7_541 VPWR VGND VPWR VGND sky130_ef_sc_hd__decap_12
XFILLER_7_585 VPWR VGND VPWR VGND sky130_ef_sc_hd__decap_12
X_3430_ reg_file_inst.registry\[7\]\[18\] _1133_ _1141_ reg_file_inst.registry\[11\]\[18\]
+ VGND VGND VPWR VPWR _1365_ sky130_fd_sc_hd__a22o_1
XFILLER_112_601 VPWR VGND VPWR VGND sky130_ef_sc_hd__decap_12
X_3361_ reg_file_inst.registry\[8\]\[20\] _1090_ _1096_ reg_file_inst.registry\[11\]\[20\]
+ VGND VGND VPWR VPWR _1298_ sky130_fd_sc_hd__a22o_1
XFILLER_111_111 VGND VGND VPWR VPWR sky130_fd_sc_hd__fill_1
XFILLER_97_323 VPWR VGND VPWR VGND sky130_ef_sc_hd__decap_12
X_5100_ _2297_ _2433_ _2451_ _2721_ VGND VGND VPWR VPWR _2929_ sky130_fd_sc_hd__a2bb2o_1
X_6080_ clknet_leaf_1_clk _0488_ _0013_ VGND VGND VPWR VPWR reg_file_inst.registry\[15\]\[13\]
+ sky130_fd_sc_hd__dfrtp_1
XFILLER_112_645 VPWR VGND VPWR VGND sky130_ef_sc_hd__decap_12
X_3292_ reg_file_inst.registry\[1\]\[23\] _1116_ _1127_ VGND VGND VPWR VPWR _1232_
+ sky130_fd_sc_hd__and3_1
X_5031_ _2296_ _2520_ _2869_ _2277_ VGND VGND VPWR VPWR _2870_ sky130_fd_sc_hd__a22o_1
XFILLER_38_401 VGND VGND VPWR VPWR sky130_fd_sc_hd__fill_1
XFILLER_38_434 VPWR VGND VPWR VGND sky130_ef_sc_hd__decap_12
XTAP_TAPCELL_ROW_0_249 VGND VPWR sky130_fd_sc_hd__tapvpwrvgnd_1
X_5933_ net146 VGND VGND VPWR VPWR _0341_ sky130_fd_sc_hd__inv_2
X_5864_ net149 VGND VGND VPWR VPWR _0272_ sky130_fd_sc_hd__inv_2
XFILLER_61_481 VGND VGND VPWR VPWR sky130_fd_sc_hd__fill_1
XFILLER_21_312 VPWR VGND VPWR VGND sky130_ef_sc_hd__decap_12
X_4815_ _2598_ _2600_ _2595_ VGND VGND VPWR VPWR _2674_ sky130_fd_sc_hd__a21bo_1
X_5795_ net149 VGND VGND VPWR VPWR _0203_ sky130_fd_sc_hd__inv_2
X_4746_ _2604_ VGND VGND VPWR VPWR _2605_ sky130_fd_sc_hd__inv_2
XFILLER_107_417 VPWR VGND VPWR VGND sky130_ef_sc_hd__decap_12
X_4677_ net29 _2117_ _2308_ net45 net101 VGND VGND VPWR VPWR _2549_ sky130_fd_sc_hd__a221o_1
X_3628_ reg_file_inst.registry\[8\]\[10\] _1114_ net144 VGND VGND VPWR VPWR _1555_
+ sky130_fd_sc_hd__and3_1
X_6416_ clknet_leaf_11_clk _0824_ _0349_ VGND VGND VPWR VPWR reg_file_inst.registry\[1\]\[13\]
+ sky130_fd_sc_hd__dfrtp_1
XFILLER_115_461 VPWR VGND VPWR VGND sky130_ef_sc_hd__decap_12
X_6347_ clknet_leaf_45_clk _0755_ _0280_ VGND VGND VPWR VPWR reg_file_inst.registry\[2\]\[0\]
+ sky130_fd_sc_hd__dfrtp_1
X_3559_ reg_file_inst.registry\[8\]\[15\] _1136_ _1140_ reg_file_inst.registry\[3\]\[15\]
+ VGND VGND VPWR VPWR _1489_ sky130_fd_sc_hd__a22o_1
XFILLER_102_133 VGND VGND VPWR VPWR sky130_fd_sc_hd__decap_6
X_6278_ clknet_leaf_12_clk _0686_ _0211_ VGND VGND VPWR VPWR MEMOFF\[15\] sky130_fd_sc_hd__dfrtp_1
XFILLER_88_389 VGND VGND VPWR VPWR sky130_fd_sc_hd__decap_8
X_5229_ _2909_ reg_file_inst.registry\[1\]\[14\] _2990_ VGND VGND VPWR VPWR _0825_
+ sky130_fd_sc_hd__mux2_1
XFILLER_72_713 VPWR VGND VPWR VGND sky130_ef_sc_hd__decap_12
XTAP_TAPCELL_ROW_27_602 VGND VPWR sky130_fd_sc_hd__tapvpwrvgnd_1
XFILLER_16_106 VGND VGND VPWR VPWR sky130_fd_sc_hd__decap_8
XFILLER_112_53 VPWR VGND VPWR VGND sky130_ef_sc_hd__decap_12
XFILLER_71_234 VPWR VGND VPWR VGND sky130_ef_sc_hd__decap_12
XTAP_TAPCELL_ROW_55_955 VGND VPWR sky130_fd_sc_hd__tapvpwrvgnd_1
XFILLER_112_97 VPWR VGND VPWR VGND sky130_ef_sc_hd__decap_12
XFILLER_12_323 VGND VGND VPWR VPWR sky130_fd_sc_hd__decap_8
XFILLER_24_194 VGND VGND VPWR VPWR sky130_fd_sc_hd__fill_2
XPHY_EDGE_ROW_117_Right_117 VGND VGND VPWR VPWR sky130_fd_sc_hd__decap_3
XFILLER_4_533 VPWR VGND VPWR VGND sky130_ef_sc_hd__decap_12
XFILLER_98_109 VPWR VGND VPWR VGND sky130_ef_sc_hd__decap_12
XFILLER_97_98 VPWR VGND VPWR VGND sky130_ef_sc_hd__decap_12
XFILLER_48_721 VGND VGND VPWR VPWR sky130_fd_sc_hd__fill_2
XFILLER_121_497 VGND VGND VPWR VPWR sky130_fd_sc_hd__decap_6
XTAP_TAPCELL_ROW_85_1327 VGND VPWR sky130_fd_sc_hd__tapvpwrvgnd_1
XFILLER_35_426 VGND VGND VPWR VPWR sky130_fd_sc_hd__fill_2
XFILLER_35_437 VGND VGND VPWR VPWR sky130_fd_sc_hd__decap_8
XFILLER_47_297 VGND VGND VPWR VPWR sky130_fd_sc_hd__fill_1
XFILLER_15_150 VPWR VGND VPWR VGND sky130_ef_sc_hd__decap_12
XFILLER_16_673 VGND VGND VPWR VPWR sky130_fd_sc_hd__fill_1
XFILLER_15_172 VPWR VGND VPWR VGND sky130_ef_sc_hd__decap_12
XFILLER_31_621 VPWR VGND VPWR VGND sky130_ef_sc_hd__decap_12
X_4600_ _2308_ net66 _2477_ VGND VGND VPWR VPWR _2478_ sky130_fd_sc_hd__a21o_4
XFILLER_30_131 VGND VGND VPWR VPWR sky130_fd_sc_hd__decap_8
XFILLER_31_687 VPWR VGND VPWR VGND sky130_ef_sc_hd__decap_12
X_5580_ reg_file_inst.registry\[15\]\[12\] _2934_ _3003_ VGND VGND VPWR VPWR _0487_
+ sky130_fd_sc_hd__mux2_1
X_4531_ _2145_ _2146_ VGND VGND VPWR VPWR _2414_ sky130_fd_sc_hd__and2_1
XTAP_TAPCELL_ROW_96_1467 VGND VPWR sky130_fd_sc_hd__tapvpwrvgnd_1
XFILLER_7_371 VGND VGND VPWR VPWR sky130_fd_sc_hd__fill_1
X_4462_ _2339_ _2346_ _1791_ VGND VGND VPWR VPWR _2347_ sky130_fd_sc_hd__mux2_1
X_6201_ clknet_leaf_34_clk _0609_ _0134_ VGND VGND VPWR VPWR reg_file_inst.registry\[5\]\[22\]
+ sky130_fd_sc_hd__dfrtp_1
X_3413_ reg_file_inst.registry\[8\]\[18\] _1090_ _1091_ reg_file_inst.registry\[3\]\[18\]
+ VGND VGND VPWR VPWR _1348_ sky130_fd_sc_hd__a22o_1
X_4393_ net30 _2125_ VGND VGND VPWR VPWR _2281_ sky130_fd_sc_hd__nor2_2
XFILLER_98_643 VGND VGND VPWR VPWR sky130_fd_sc_hd__fill_1
X_3344_ reg_file_inst.registry\[9\]\[21\] _1125_ _1127_ VGND VGND VPWR VPWR _1282_
+ sky130_fd_sc_hd__and3_1
X_6132_ clknet_leaf_27_clk _0540_ _0065_ VGND VGND VPWR VPWR reg_file_inst.registry\[6\]\[9\]
+ sky130_fd_sc_hd__dfrtp_1
XFILLER_112_475 VGND VGND VPWR VPWR sky130_fd_sc_hd__fill_1
X_3275_ reg_file_inst.registry\[1\]\[24\] _1142_ _1213_ _1215_ VGND VGND VPWR VPWR
+ _1216_ sky130_fd_sc_hd__a211o_1
X_6063_ net146 VGND VGND VPWR VPWR _0471_ sky130_fd_sc_hd__inv_2
XFILLER_100_637 VGND VGND VPWR VPWR sky130_fd_sc_hd__decap_6
X_5014_ _2662_ _2843_ VGND VGND VPWR VPWR _2855_ sky130_fd_sc_hd__nand2_1
XFILLER_66_551 VPWR VGND VPWR VGND sky130_ef_sc_hd__decap_12
XFILLER_54_713 VPWR VGND VPWR VGND sky130_ef_sc_hd__decap_12
XFILLER_38_242 VGND VGND VPWR VPWR sky130_fd_sc_hd__decap_4
XFILLER_38_253 VGND VGND VPWR VPWR sky130_fd_sc_hd__fill_2
XFILLER_53_223 VGND VGND VPWR VPWR sky130_fd_sc_hd__fill_1
XFILLER_26_39 VPWR VGND VPWR VGND sky130_ef_sc_hd__decap_12
XTAP_TAPCELL_ROW_105_1574 VGND VPWR sky130_fd_sc_hd__tapvpwrvgnd_1
X_5916_ net44 VGND VGND VPWR VPWR _0324_ sky130_fd_sc_hd__inv_2
XFILLER_81_587 VGND VGND VPWR VPWR sky130_fd_sc_hd__fill_2
XTAP_TAPCELL_ROW_52_914 VGND VPWR sky130_fd_sc_hd__tapvpwrvgnd_1
XFILLER_53_278 VGND VGND VPWR VPWR sky130_fd_sc_hd__fill_2
X_5847_ net148 VGND VGND VPWR VPWR _0255_ sky130_fd_sc_hd__inv_2
XTAP_TAPCELL_ROW_32_660 VGND VPWR sky130_fd_sc_hd__tapvpwrvgnd_1
XFILLER_42_27 VGND VGND VPWR VPWR sky130_fd_sc_hd__fill_1
X_5778_ net147 VGND VGND VPWR VPWR _0186_ sky130_fd_sc_hd__inv_2
X_4729_ _1280_ _2587_ VGND VGND VPWR VPWR _2588_ sky130_fd_sc_hd__xnor2_1
XFILLER_107_225 VPWR VGND VPWR VGND sky130_ef_sc_hd__decap_12
XFILLER_89_665 VGND VGND VPWR VPWR sky130_fd_sc_hd__decap_6
XFILLER_88_153 VGND VGND VPWR VPWR sky130_fd_sc_hd__decap_3
XFILLER_67_57 VPWR VGND VPWR VGND sky130_ef_sc_hd__decap_12
XFILLER_67_35 VPWR VGND VPWR VGND sky130_ef_sc_hd__decap_12
XFILLER_88_197 VGND VGND VPWR VPWR sky130_fd_sc_hd__fill_2
XFILLER_57_584 VPWR VGND VPWR VGND sky130_ef_sc_hd__decap_12
XPHY_EDGE_ROW_103_Left_226 VGND VGND VPWR VPWR sky130_fd_sc_hd__decap_3
XFILLER_72_598 VGND VGND VPWR VPWR sky130_fd_sc_hd__fill_2
XFILLER_72_587 VGND VGND VPWR VPWR sky130_fd_sc_hd__fill_1
XFILLER_13_610 VGND VGND VPWR VPWR sky130_fd_sc_hd__decap_6
XTAP_TAPCELL_ROW_80_1268 VGND VPWR sky130_fd_sc_hd__tapvpwrvgnd_1
XFILLER_40_495 VGND VGND VPWR VPWR sky130_fd_sc_hd__decap_8
XFILLER_12_197 VGND VGND VPWR VPWR sky130_fd_sc_hd__decap_4
XFILLER_32_82 VGND VGND VPWR VPWR sky130_fd_sc_hd__fill_2
XPHY_EDGE_ROW_112_Left_235 VGND VGND VPWR VPWR sky130_fd_sc_hd__decap_3
XTAP_TAPCELL_ROW_10_387 VGND VPWR sky130_fd_sc_hd__tapvpwrvgnd_1
XFILLER_113_217 VGND VGND VPWR VPWR sky130_fd_sc_hd__decap_6
XFILLER_4_374 VPWR VGND VPWR VGND sky130_ef_sc_hd__decap_12
XFILLER_121_261 VPWR VGND VPWR VGND sky130_ef_sc_hd__decap_12
XTAP_TAPCELL_ROW_91_1397 VGND VPWR sky130_fd_sc_hd__tapvpwrvgnd_1
XFILLER_79_175 VGND VGND VPWR VPWR sky130_fd_sc_hd__fill_1
XFILLER_94_112 VGND VGND VPWR VPWR sky130_fd_sc_hd__decap_4
XFILLER_79_197 VGND VGND VPWR VPWR sky130_fd_sc_hd__decap_4
XFILLER_67_337 VPWR VGND VPWR VGND sky130_ef_sc_hd__decap_12
X_3060_ _1002_ _1003_ VGND VGND VPWR VPWR _1004_ sky130_fd_sc_hd__and2b_1
XPHY_EDGE_ROW_121_Left_244 VGND VGND VPWR VPWR sky130_fd_sc_hd__decap_3
XFILLER_35_201 VPWR VGND VPWR VGND sky130_ef_sc_hd__decap_12
XFILLER_90_395 VGND VGND VPWR VPWR sky130_fd_sc_hd__decap_6
X_5701_ net149 VGND VGND VPWR VPWR _0109_ sky130_fd_sc_hd__inv_2
XTAP_TAPCELL_ROW_18_487 VGND VPWR sky130_fd_sc_hd__tapvpwrvgnd_1
X_3962_ _1876_ _1877_ _0956_ VGND VGND VPWR VPWR _1878_ sky130_fd_sc_hd__a21oi_4
XFILLER_31_462 VGND VGND VPWR VPWR sky130_fd_sc_hd__decap_4
X_3893_ MEMOFF\[1\] _1079_ _1091_ reg_file_inst.registry\[3\]\[1\] VGND VGND VPWR
+ VPWR _1811_ sky130_fd_sc_hd__a22o_1
X_5632_ net147 VGND VGND VPWR VPWR _0040_ sky130_fd_sc_hd__inv_2
X_5563_ _2550_ reg_file_inst.registry\[9\]\[0\] _3002_ VGND VGND VPWR VPWR _0503_
+ sky130_fd_sc_hd__mux2_1
X_4514_ _1151_ _1816_ _2388_ VGND VGND VPWR VPWR _2397_ sky130_fd_sc_hd__a21bo_1
X_5494_ JMPOFF\[11\] _2948_ _3000_ VGND VGND VPWR VPWR _0570_ sky130_fd_sc_hd__mux2_1
X_4445_ _2328_ _2329_ VGND VGND VPWR VPWR _2330_ sky130_fd_sc_hd__nor2_1
XFILLER_104_239 VPWR VGND VPWR VGND sky130_ef_sc_hd__decap_12
X_4376_ _2262_ _2263_ VGND VGND VPWR VPWR _2264_ sky130_fd_sc_hd__or2_1
XFILLER_86_613 VPWR VGND VPWR VGND sky130_ef_sc_hd__decap_12
X_3327_ reg_file_inst.registry\[8\]\[22\] _1136_ _1259_ _1264_ _1265_ VGND VGND VPWR
+ VPWR _1266_ sky130_fd_sc_hd__a2111o_1
X_6115_ clknet_leaf_41_clk _0523_ _0048_ VGND VGND VPWR VPWR reg_file_inst.registry\[9\]\[20\]
+ sky130_fd_sc_hd__dfrtp_1
XFILLER_86_657 VPWR VGND VPWR VGND sky130_ef_sc_hd__decap_12
XFILLER_85_134 VPWR VGND VPWR VGND sky130_ef_sc_hd__decap_12
X_3258_ MEMOFF\[24\] _1079_ _1089_ reg_file_inst.registry\[9\]\[24\] VGND VGND VPWR
+ VPWR _1199_ sky130_fd_sc_hd__a22o_1
X_6046_ net146 VGND VGND VPWR VPWR _0454_ sky130_fd_sc_hd__inv_2
XTAP_TAPCELL_ROW_107_1603 VGND VPWR sky130_fd_sc_hd__tapvpwrvgnd_1
X_3189_ _1119_ net142 VGND VGND VPWR VPWR _1133_ sky130_fd_sc_hd__and2_4
XFILLER_39_573 VGND VGND VPWR VPWR sky130_fd_sc_hd__decap_4
XTAP_TAPCELL_ROW_37_730 VGND VPWR sky130_fd_sc_hd__tapvpwrvgnd_1
XFILLER_42_705 VGND VGND VPWR VPWR sky130_fd_sc_hd__fill_1
XFILLER_81_373 VGND VGND VPWR VPWR sky130_fd_sc_hd__fill_1
XFILLER_14_407 VPWR VGND VPWR VGND sky130_ef_sc_hd__decap_12
XTAP_TAPCELL_ROW_66_1090 VGND VPWR sky130_fd_sc_hd__tapvpwrvgnd_1
XFILLER_41_237 VGND VGND VPWR VPWR sky130_fd_sc_hd__fill_2
XFILLER_10_613 VPWR VGND VPWR VGND sky130_ef_sc_hd__decap_12
XFILLER_108_501 VPWR VGND VPWR VGND sky130_ef_sc_hd__decap_12
XFILLER_10_657 VPWR VGND VPWR VGND sky130_ef_sc_hd__decap_12
XTAP_TAPCELL_ROW_118_1743 VGND VPWR sky130_fd_sc_hd__tapvpwrvgnd_1
XFILLER_118_41 VPWR VGND VPWR VGND sky130_ef_sc_hd__decap_12
XFILLER_108_545 VPWR VGND VPWR VGND sky130_ef_sc_hd__decap_12
XFILLER_108_589 VPWR VGND VPWR VGND sky130_ef_sc_hd__decap_12
XFILLER_118_85 VPWR VGND VPWR VGND sky130_ef_sc_hd__decap_12
XFILLER_110_209 VPWR VGND VPWR VGND sky130_ef_sc_hd__decap_12
XFILLER_77_602 VGND VGND VPWR VPWR sky130_fd_sc_hd__fill_1
XFILLER_76_101 VGND VGND VPWR VPWR sky130_fd_sc_hd__decap_4
XFILLER_18_713 VGND VGND VPWR VPWR sky130_fd_sc_hd__decap_8
XFILLER_33_716 VGND VGND VPWR VPWR sky130_fd_sc_hd__fill_1
XFILLER_60_557 VGND VGND VPWR VPWR sky130_fd_sc_hd__decap_8
XFILLER_60_524 VGND VGND VPWR VPWR sky130_fd_sc_hd__decap_8
XFILLER_17_289 VGND VGND VPWR VPWR sky130_fd_sc_hd__decap_8
XFILLER_32_237 VGND VGND VPWR VPWR sky130_fd_sc_hd__decap_3
XTAP_TAPCELL_ROW_15_446 VGND VPWR sky130_fd_sc_hd__tapvpwrvgnd_1
XTAP_TAPCELL_ROW_15_457 VGND VPWR sky130_fd_sc_hd__tapvpwrvgnd_1
XFILLER_9_433 VGND VGND VPWR VPWR sky130_fd_sc_hd__fill_1
XFILLER_9_411 VGND VGND VPWR VPWR sky130_fd_sc_hd__fill_1
XTAP_TAPCELL_ROW_43_799 VGND VPWR sky130_fd_sc_hd__tapvpwrvgnd_1
XFILLER_118_309 VPWR VGND VPWR VGND sky130_ef_sc_hd__decap_12
XTAP_TAPCELL_ROW_93_1426 VGND VPWR sky130_fd_sc_hd__tapvpwrvgnd_1
XFILLER_99_259 VPWR VGND VPWR VGND sky130_ef_sc_hd__decap_12
XFILLER_99_248 VGND VGND VPWR VPWR sky130_fd_sc_hd__fill_2
XFILLER_4_171 VPWR VGND VPWR VGND sky130_ef_sc_hd__decap_12
X_4230_ _1873_ _2115_ VGND VGND VPWR VPWR _2118_ sky130_fd_sc_hd__nand2_8
X_4161_ _2029_ _2071_ VGND VGND VPWR VPWR _2072_ sky130_fd_sc_hd__xnor2_1
XFILLER_4_53 VPWR VGND VPWR VGND sky130_ef_sc_hd__decap_12
XFILLER_95_432 VGND VGND VPWR VPWR sky130_fd_sc_hd__decap_4
XFILLER_68_657 VPWR VGND VPWR VGND sky130_ef_sc_hd__decap_12
XFILLER_67_167 VGND VGND VPWR VPWR sky130_fd_sc_hd__fill_1
X_4092_ _0974_ _1064_ _2006_ VGND VGND VPWR VPWR _2008_ sky130_fd_sc_hd__nand3_1
X_3112_ JMPOFF\[13\] JMPOFF\[12\] _0967_ VGND VGND VPWR VPWR _1056_ sky130_fd_sc_hd__o21ai_1
XFILLER_83_638 VPWR VGND VPWR VGND sky130_ef_sc_hd__decap_12
X_3043_ JMPOFF\[22\] net141 net41 VGND VGND VPWR VPWR _0987_ sky130_fd_sc_hd__a21o_1
XFILLER_55_318 VGND VGND VPWR VPWR sky130_fd_sc_hd__decap_6
XFILLER_91_671 VGND VGND VPWR VPWR sky130_fd_sc_hd__fill_1
XFILLER_63_384 VGND VGND VPWR VPWR sky130_fd_sc_hd__decap_8
X_4994_ _1320_ _2282_ _2285_ _1321_ _2838_ VGND VGND VPWR VPWR _2839_ sky130_fd_sc_hd__o221a_1
XTAP_TAPCELL_ROW_102_1544 VGND VPWR sky130_fd_sc_hd__tapvpwrvgnd_1
XTAP_TAPCELL_ROW_102_1533 VGND VPWR sky130_fd_sc_hd__tapvpwrvgnd_1
X_3945_ _1695_ _1860_ _1859_ VGND VGND VPWR VPWR _1861_ sky130_fd_sc_hd__a21bo_1
X_5615_ net146 VGND VGND VPWR VPWR _0023_ sky130_fd_sc_hd__inv_2
XFILLER_31_281 VGND VGND VPWR VPWR sky130_fd_sc_hd__fill_2
X_3876_ reg_file_inst.registry\[2\]\[2\] _1137_ _1141_ reg_file_inst.registry\[11\]\[2\]
+ VGND VGND VPWR VPWR _1795_ sky130_fd_sc_hd__a22o_1
X_5546_ _2873_ reg_file_inst.registry\[9\]\[17\] _3002_ VGND VGND VPWR VPWR _0520_
+ sky130_fd_sc_hd__mux2_1
XFILLER_3_609 VGND VGND VPWR VPWR sky130_fd_sc_hd__decap_6
X_5477_ _1115_ _2991_ VGND VGND VPWR VPWR _3000_ sky130_fd_sc_hd__nor2_8
XFILLER_105_559 VGND VGND VPWR VPWR sky130_fd_sc_hd__fill_1
X_4428_ _2173_ _2176_ _2312_ VGND VGND VPWR VPWR _2313_ sky130_fd_sc_hd__and3_1
XTAP_TAPCELL_ROW_113_1673 VGND VPWR sky130_fd_sc_hd__tapvpwrvgnd_1
XFILLER_101_721 VGND VGND VPWR VPWR sky130_fd_sc_hd__decap_4
X_4359_ _2244_ _2245_ _2243_ VGND VGND VPWR VPWR _2247_ sky130_fd_sc_hd__o21a_1
XFILLER_48_26 VGND VGND VPWR VPWR sky130_fd_sc_hd__fill_2
XFILLER_58_145 VPWR VGND VPWR VGND sky130_ef_sc_hd__decap_12
X_6029_ net148 VGND VGND VPWR VPWR _0437_ sky130_fd_sc_hd__inv_2
XFILLER_46_318 VGND VGND VPWR VPWR sky130_fd_sc_hd__fill_1
XFILLER_104_65 VPWR VGND VPWR VGND sky130_ef_sc_hd__decap_12
XFILLER_54_362 VGND VGND VPWR VPWR sky130_fd_sc_hd__fill_2
XFILLER_42_502 VGND VGND VPWR VPWR sky130_fd_sc_hd__decap_3
XFILLER_120_20 VGND VGND VPWR VPWR sky130_fd_sc_hd__decap_8
XFILLER_82_693 VGND VGND VPWR VPWR sky130_fd_sc_hd__decap_6
XFILLER_81_181 VGND VGND VPWR VPWR sky130_fd_sc_hd__decap_8
XFILLER_120_53 VPWR VGND VPWR VGND sky130_ef_sc_hd__decap_12
XFILLER_120_97 VPWR VGND VPWR VGND sky130_ef_sc_hd__decap_12
XTAP_TAPCELL_ROW_12_416 VGND VPWR sky130_fd_sc_hd__tapvpwrvgnd_1
XFILLER_13_51 VGND VGND VPWR VPWR sky130_fd_sc_hd__decap_4
XTAP_TAPCELL_ROW_40_758 VGND VPWR sky130_fd_sc_hd__tapvpwrvgnd_1
XTAP_TAPCELL_ROW_40_769 VGND VPWR sky130_fd_sc_hd__tapvpwrvgnd_1
XFILLER_10_487 VPWR VGND VPWR VGND sky130_ef_sc_hd__decap_12
XFILLER_89_22 VGND VGND VPWR VPWR sky130_fd_sc_hd__fill_1
XFILLER_89_44 VPWR VGND VPWR VGND sky130_ef_sc_hd__decap_12
XFILLER_111_529 VPWR VGND VPWR VGND sky130_ef_sc_hd__decap_12
XFILLER_104_581 VGND VGND VPWR VPWR sky130_fd_sc_hd__decap_6
XFILLER_89_281 VPWR VGND VPWR VGND sky130_ef_sc_hd__decap_12
XFILLER_89_270 VGND VGND VPWR VPWR sky130_fd_sc_hd__decap_8
XFILLER_77_498 VGND VGND VPWR VPWR sky130_fd_sc_hd__decap_6
XFILLER_64_104 VGND VGND VPWR VPWR sky130_fd_sc_hd__decap_4
XTAP_TAPCELL_ROW_48_858 VGND VPWR sky130_fd_sc_hd__tapvpwrvgnd_1
XTAP_TAPCELL_ROW_48_869 VGND VPWR sky130_fd_sc_hd__tapvpwrvgnd_1
XFILLER_33_513 VGND VGND VPWR VPWR sky130_fd_sc_hd__decap_4
XFILLER_60_365 VGND VGND VPWR VPWR sky130_fd_sc_hd__fill_2
XFILLER_33_557 VGND VGND VPWR VPWR sky130_fd_sc_hd__decap_3
XFILLER_60_398 VPWR VGND VPWR VGND sky130_ef_sc_hd__decap_12
X_3730_ MEMOFF\[7\] _1121_ _1127_ VGND VGND VPWR VPWR _1654_ sky130_fd_sc_hd__and3_1
XFILLER_13_270 VGND VGND VPWR VPWR sky130_fd_sc_hd__fill_1
XFILLER_119_629 VPWR VGND VPWR VGND sky130_ef_sc_hd__decap_12
XFILLER_13_281 VGND VGND VPWR VPWR sky130_fd_sc_hd__fill_2
XFILLER_118_139 VGND VGND VPWR VPWR sky130_fd_sc_hd__fill_1
X_3661_ reg_file_inst.registry\[4\]\[9\] _1134_ _1140_ reg_file_inst.registry\[3\]\[9\]
+ VGND VGND VPWR VPWR _1587_ sky130_fd_sc_hd__a22o_1
Xclkload22 clknet_leaf_16_clk VGND VGND VPWR VPWR clkload22/Y sky130_fd_sc_hd__clkinv_4
X_5400_ reg_file_inst.registry\[4\]\[18\] _2863_ _2997_ VGND VGND VPWR VPWR _0661_
+ sky130_fd_sc_hd__mux2_1
Xclkload33 clknet_leaf_27_clk VGND VGND VPWR VPWR clkload33/Y sky130_fd_sc_hd__bufinv_16
XFILLER_62_3 VGND VGND VPWR VPWR sky130_fd_sc_hd__fill_2
X_6380_ clknet_leaf_41_clk _0788_ _0313_ VGND VGND VPWR VPWR reg_file_inst.registry\[14\]\[5\]
+ sky130_fd_sc_hd__dfrtp_1
Xclkload44 clknet_leaf_52_clk VGND VGND VPWR VPWR clkload44/Y sky130_fd_sc_hd__clkinvlp_4
Xclkload11 clknet_leaf_62_clk VGND VGND VPWR VPWR clkload11/Y sky130_fd_sc_hd__clkinvlp_4
X_3592_ reg_file_inst.registry\[14\]\[11\] _1081_ _1091_ reg_file_inst.registry\[3\]\[11\]
+ VGND VGND VPWR VPWR _1520_ sky130_fd_sc_hd__a22o_1
XFILLER_114_301 VGND VGND VPWR VPWR sky130_fd_sc_hd__decap_6
Xclkload55 clknet_leaf_37_clk VGND VGND VPWR VPWR clkload55/Y sky130_fd_sc_hd__clkinvlp_4
X_5331_ _2550_ reg_file_inst.registry\[8\]\[0\] _2994_ VGND VGND VPWR VPWR _0727_
+ sky130_fd_sc_hd__mux2_1
XFILLER_114_345 VPWR VGND VPWR VGND sky130_ef_sc_hd__decap_12
XFILLER_88_719 VGND VGND VPWR VPWR sky130_fd_sc_hd__fill_1
XFILLER_87_218 VGND VGND VPWR VPWR sky130_fd_sc_hd__decap_6
X_5262_ reg_file_inst.registry\[14\]\[11\] _2948_ _2992_ VGND VGND VPWR VPWR _0794_
+ sky130_fd_sc_hd__mux2_1
XFILLER_114_389 VPWR VGND VPWR VGND sky130_ef_sc_hd__decap_12
XFILLER_68_421 VPWR VGND VPWR VGND sky130_ef_sc_hd__decap_12
X_4213_ _1947_ _1948_ VGND VGND VPWR VPWR _2106_ sky130_fd_sc_hd__nand2_1
X_5193_ _2934_ reg_file_inst.registry\[0\]\[12\] _2988_ VGND VGND VPWR VPWR _0859_
+ sky130_fd_sc_hd__mux2_1
X_4144_ net131 _2059_ VGND VGND VPWR VPWR _2060_ sky130_fd_sc_hd__nand2_1
XFILLER_28_307 VGND VGND VPWR VPWR sky130_fd_sc_hd__fill_1
XFILLER_55_137 VPWR VGND VPWR VGND sky130_ef_sc_hd__decap_12
X_4075_ _1910_ _1990_ _1925_ _1924_ VGND VGND VPWR VPWR _1991_ sky130_fd_sc_hd__o211a_1
XFILLER_83_468 VPWR VGND VPWR VGND sky130_ef_sc_hd__decap_12
X_3026_ JMPOFF\[25\] _0967_ _0969_ VGND VGND VPWR VPWR _0970_ sky130_fd_sc_hd__a21o_1
XFILLER_64_660 VPWR VGND VPWR VGND sky130_ef_sc_hd__decap_12
X_4977_ _2820_ _2823_ _2821_ VGND VGND VPWR VPWR _2824_ sky130_fd_sc_hd__or3b_1
Xclkload5 clknet_leaf_0_clk VGND VGND VPWR VPWR clkload5/Y sky130_fd_sc_hd__bufinv_16
X_3928_ reg_file_inst.registry\[4\]\[0\] _1114_ _1132_ VGND VGND VPWR VPWR _1845_
+ sky130_fd_sc_hd__and3_1
X_3859_ MEMOFF\[3\] net94 _1113_ VGND VGND VPWR VPWR _1778_ sky130_fd_sc_hd__mux2_2
XTAP_TAPCELL_ROW_115_1702 VGND VPWR sky130_fd_sc_hd__tapvpwrvgnd_1
XFILLER_117_161 VGND VGND VPWR VPWR sky130_fd_sc_hd__decap_6
X_5529_ reg_file_inst.registry\[6\]\[5\] _2419_ _3001_ VGND VGND VPWR VPWR _0536_
+ sky130_fd_sc_hd__mux2_1
XFILLER_59_14 VGND VGND VPWR VPWR sky130_fd_sc_hd__fill_1
XFILLER_59_47 VGND VGND VPWR VPWR sky130_fd_sc_hd__decap_6
XFILLER_59_410 VGND VGND VPWR VPWR sky130_fd_sc_hd__decap_3
XFILLER_59_465 VGND VGND VPWR VPWR sky130_fd_sc_hd__decap_8
XFILLER_101_573 VPWR VGND VPWR VGND sky130_ef_sc_hd__decap_12
XFILLER_86_251 VGND VGND VPWR VPWR sky130_fd_sc_hd__fill_1
XFILLER_75_57 VGND VGND VPWR VPWR sky130_fd_sc_hd__decap_6
XFILLER_46_137 VGND VGND VPWR VPWR sky130_fd_sc_hd__decap_3
XFILLER_55_660 VGND VGND VPWR VPWR sky130_fd_sc_hd__decap_3
XFILLER_15_502 VGND VGND VPWR VPWR sky130_fd_sc_hd__fill_2
XTAP_TAPCELL_ROW_45_828 VGND VPWR sky130_fd_sc_hd__tapvpwrvgnd_1
XFILLER_91_45 VGND VGND VPWR VPWR sky130_fd_sc_hd__fill_1
XFILLER_70_641 VGND VGND VPWR VPWR sky130_fd_sc_hd__decap_3
XTAP_TAPCELL_ROW_25_574 VGND VPWR sky130_fd_sc_hd__tapvpwrvgnd_1
XTAP_TAPCELL_ROW_77_1229 VGND VPWR sky130_fd_sc_hd__tapvpwrvgnd_1
XFILLER_109_673 VPWR VGND VPWR VGND sky130_ef_sc_hd__decap_12
XFILLER_6_299 VGND VGND VPWR VPWR sky130_fd_sc_hd__fill_2
XFILLER_40_93 VGND VGND VPWR VPWR sky130_fd_sc_hd__decap_3
XFILLER_111_337 VPWR VGND VPWR VGND sky130_ef_sc_hd__decap_12
XFILLER_69_218 VGND VGND VPWR VPWR sky130_fd_sc_hd__decap_6
XFILLER_77_262 VPWR VGND VPWR VGND sky130_ef_sc_hd__decap_12
XFILLER_38_627 VGND VGND VPWR VPWR sky130_fd_sc_hd__decap_3
XTAP_TAPCELL_ROW_88_1358 VGND VPWR sky130_fd_sc_hd__tapvpwrvgnd_1
XFILLER_65_457 VGND VGND VPWR VPWR sky130_fd_sc_hd__fill_1
XFILLER_65_446 VGND VGND VPWR VPWR sky130_fd_sc_hd__fill_2
XFILLER_37_137 VPWR VGND VPWR VGND sky130_ef_sc_hd__decap_12
XTAP_TAPCELL_ROW_88_1369 VGND VPWR sky130_fd_sc_hd__tapvpwrvgnd_1
XFILLER_1_87 VGND VGND VPWR VPWR sky130_fd_sc_hd__fill_1
XFILLER_18_351 VGND VGND VPWR VPWR sky130_fd_sc_hd__decap_3
XFILLER_18_362 VGND VGND VPWR VPWR sky130_fd_sc_hd__fill_2
XFILLER_52_118 VGND VGND VPWR VPWR sky130_fd_sc_hd__fill_1
X_4900_ _2687_ _2707_ net133 VGND VGND VPWR VPWR _2755_ sky130_fd_sc_hd__mux2_1
XFILLER_45_181 VGND VGND VPWR VPWR sky130_fd_sc_hd__decap_6
X_5880_ net146 VGND VGND VPWR VPWR _0288_ sky130_fd_sc_hd__inv_2
XFILLER_46_682 VGND VGND VPWR VPWR sky130_fd_sc_hd__fill_2
X_4831_ _2472_ _2689_ net137 VGND VGND VPWR VPWR _2690_ sky130_fd_sc_hd__mux2_1
XFILLER_61_685 VGND VGND VPWR VPWR sky130_fd_sc_hd__fill_1
XFILLER_60_195 VGND VGND VPWR VPWR sky130_fd_sc_hd__fill_1
X_4762_ _2618_ _2620_ VGND VGND VPWR VPWR _2621_ sky130_fd_sc_hd__nor2_1
X_6501_ clknet_leaf_27_clk _0909_ _0434_ VGND VGND VPWR VPWR reg_file_inst.registry\[11\]\[10\]
+ sky130_fd_sc_hd__dfrtp_1
X_4693_ _0958_ net37 _2114_ _2117_ VGND VGND VPWR VPWR _2552_ sky130_fd_sc_hd__or4_4
X_3713_ _1244_ _1269_ _1636_ _1635_ VGND VGND VPWR VPWR _1637_ sky130_fd_sc_hd__o31a_1
X_6432_ clknet_leaf_26_clk _0840_ _0365_ VGND VGND VPWR VPWR reg_file_inst.registry\[11\]\[17\]
+ sky130_fd_sc_hd__dfrtp_1
X_3644_ JMPOFF\[9\] _1095_ _1098_ reg_file_inst.registry\[10\]\[9\] VGND VGND VPWR
+ VPWR _1570_ sky130_fd_sc_hd__a22o_1
XFILLER_106_109 VPWR VGND VPWR VGND sky130_ef_sc_hd__decap_12
XTAP_TAPCELL_ROW_99_1498 VGND VPWR sky130_fd_sc_hd__tapvpwrvgnd_1
X_6363_ clknet_leaf_16_clk _0771_ _0296_ VGND VGND VPWR VPWR reg_file_inst.registry\[2\]\[16\]
+ sky130_fd_sc_hd__dfrtp_1
X_3575_ reg_file_inst.registry\[0\]\[14\] net138 _1496_ _1503_ VGND VGND VPWR VPWR
+ _1504_ sky130_fd_sc_hd__o22ai_4
XFILLER_115_665 VGND VGND VPWR VPWR sky130_fd_sc_hd__decap_6
XFILLER_114_153 VPWR VGND VPWR VGND sky130_ef_sc_hd__decap_12
X_5314_ _2873_ reg_file_inst.registry\[8\]\[17\] _2994_ VGND VGND VPWR VPWR _0744_
+ sky130_fd_sc_hd__mux2_1
X_6294_ clknet_leaf_5_clk _0702_ _0227_ VGND VGND VPWR VPWR reg_file_inst.registry\[3\]\[3\]
+ sky130_fd_sc_hd__dfrtp_1
XFILLER_0_409 VGND VGND VPWR VPWR sky130_fd_sc_hd__fill_2
XFILLER_102_337 VPWR VGND VPWR VGND sky130_ef_sc_hd__decap_12
X_5245_ _1124_ _2991_ VGND VGND VPWR VPWR _2992_ sky130_fd_sc_hd__nor2_8
XFILLER_114_197 VPWR VGND VPWR VGND sky130_ef_sc_hd__decap_12
XTAP_TAPCELL_ROW_110_1643 VGND VPWR sky130_fd_sc_hd__tapvpwrvgnd_1
XFILLER_68_251 VGND VGND VPWR VPWR sky130_fd_sc_hd__fill_1
X_5176_ _2114_ _2117_ _0958_ _0959_ VGND VGND VPWR VPWR _2987_ sky130_fd_sc_hd__and4bb_4
XFILLER_83_221 VGND VGND VPWR VPWR sky130_fd_sc_hd__decap_3
X_4127_ net131 _2038_ _2042_ VGND VGND VPWR VPWR _2043_ sky130_fd_sc_hd__and3_1
XFILLER_28_137 VGND VGND VPWR VPWR sky130_fd_sc_hd__decap_3
XFILLER_83_243 VPWR VGND VPWR VGND sky130_ef_sc_hd__decap_12
X_4058_ _1952_ _1966_ _1971_ _1949_ _1938_ VGND VGND VPWR VPWR _1974_ sky130_fd_sc_hd__a2111o_1
XFILLER_71_449 VGND VGND VPWR VPWR sky130_fd_sc_hd__decap_4
X_3009_ net29 VGND VGND VPWR VPWR _0955_ sky130_fd_sc_hd__inv_2
XFILLER_37_671 VGND VGND VPWR VPWR sky130_fd_sc_hd__fill_1
XFILLER_52_630 VGND VGND VPWR VPWR sky130_fd_sc_hd__decap_3
XFILLER_36_181 VGND VGND VPWR VPWR sky130_fd_sc_hd__fill_1
Xclkbuf_leaf_63_clk clknet_3_0__leaf_clk VGND VGND VPWR VPWR clknet_leaf_63_clk sky130_fd_sc_hd__clkbuf_8
XFILLER_101_55 VGND VGND VPWR VPWR sky130_fd_sc_hd__fill_1
XFILLER_61_15 VGND VGND VPWR VPWR sky130_fd_sc_hd__fill_2
XFILLER_51_151 VGND VGND VPWR VPWR sky130_fd_sc_hd__fill_2
XFILLER_12_527 VGND VGND VPWR VPWR sky130_fd_sc_hd__decap_4
XTAP_TAPCELL_ROW_121_1772 VGND VPWR sky130_fd_sc_hd__tapvpwrvgnd_1
XFILLER_61_26 VPWR VGND VPWR VGND sky130_ef_sc_hd__decap_12
XTAP_TAPCELL_ROW_22_533 VGND VPWR sky130_fd_sc_hd__tapvpwrvgnd_1
XTAP_TAPCELL_ROW_22_544 VGND VPWR sky130_fd_sc_hd__tapvpwrvgnd_1
XTAP_TAPCELL_ROW_50_886 VGND VPWR sky130_fd_sc_hd__tapvpwrvgnd_1
XFILLER_106_643 VGND VGND VPWR VPWR sky130_fd_sc_hd__fill_1
XFILLER_10_41 VPWR VGND VPWR VGND sky130_ef_sc_hd__decap_12
XTAP_TAPCELL_ROW_72_1159 VGND VPWR sky130_fd_sc_hd__tapvpwrvgnd_1
XFILLER_10_85 VPWR VGND VPWR VGND sky130_ef_sc_hd__decap_12
XFILLER_120_189 VGND VGND VPWR VPWR sky130_fd_sc_hd__decap_6
XFILLER_47_446 VGND VGND VPWR VPWR sky130_fd_sc_hd__fill_2
XTAP_TAPCELL_ROW_58_986 VGND VPWR sky130_fd_sc_hd__tapvpwrvgnd_1
XFILLER_62_416 VGND VGND VPWR VPWR sky130_fd_sc_hd__decap_4
XTAP_TAPCELL_ROW_2_291 VGND VPWR sky130_fd_sc_hd__tapvpwrvgnd_1
Xclkbuf_leaf_54_clk clknet_3_5__leaf_clk VGND VGND VPWR VPWR clknet_leaf_54_clk sky130_fd_sc_hd__clkbuf_8
XFILLER_15_387 VGND VGND VPWR VPWR sky130_fd_sc_hd__fill_2
XTAP_TAPCELL_ROW_83_1299 VGND VPWR sky130_fd_sc_hd__tapvpwrvgnd_1
XFILLER_42_195 VGND VGND VPWR VPWR sky130_fd_sc_hd__fill_1
XFILLER_7_553 VGND VGND VPWR VPWR sky130_fd_sc_hd__decap_6
XFILLER_7_597 VPWR VGND VPWR VGND sky130_ef_sc_hd__decap_12
X_3360_ JMPOFF\[20\] _1095_ _1097_ reg_file_inst.registry\[5\]\[20\] VGND VGND VPWR
+ VPWR _1297_ sky130_fd_sc_hd__a22o_1
XFILLER_112_613 VPWR VGND VPWR VGND sky130_ef_sc_hd__decap_12
XFILLER_112_657 VPWR VGND VPWR VGND sky130_ef_sc_hd__decap_12
XFILLER_97_335 VGND VGND VPWR VPWR sky130_fd_sc_hd__fill_1
X_3291_ reg_file_inst.registry\[0\]\[23\] _1076_ _1223_ _1230_ VGND VGND VPWR VPWR
+ _1231_ sky130_fd_sc_hd__o22a_4
XFILLER_2_291 VGND VGND VPWR VPWR sky130_fd_sc_hd__fill_2
X_5030_ _2757_ _2764_ _1764_ VGND VGND VPWR VPWR _2869_ sky130_fd_sc_hd__mux2_1
XFILLER_111_167 VGND VGND VPWR VPWR sky130_fd_sc_hd__fill_1
XFILLER_78_560 VPWR VGND VPWR VGND sky130_ef_sc_hd__decap_12
XFILLER_25_3 VGND VGND VPWR VPWR sky130_fd_sc_hd__decap_8
XFILLER_38_446 VGND VGND VPWR VPWR sky130_fd_sc_hd__decap_3
XFILLER_53_405 VGND VGND VPWR VPWR sky130_fd_sc_hd__fill_2
XFILLER_19_660 VGND VGND VPWR VPWR sky130_fd_sc_hd__fill_2
XFILLER_53_427 VGND VGND VPWR VPWR sky130_fd_sc_hd__decap_8
XFILLER_19_671 VGND VGND VPWR VPWR sky130_fd_sc_hd__fill_1
X_5932_ net146 VGND VGND VPWR VPWR _0340_ sky130_fd_sc_hd__inv_2
Xclkbuf_leaf_45_clk clknet_3_4__leaf_clk VGND VGND VPWR VPWR clknet_leaf_45_clk sky130_fd_sc_hd__clkbuf_8
XFILLER_53_449 VPWR VGND VPWR VGND sky130_ef_sc_hd__decap_12
XFILLER_18_192 VGND VGND VPWR VPWR sky130_fd_sc_hd__decap_4
X_5863_ net44 VGND VGND VPWR VPWR _0271_ sky130_fd_sc_hd__inv_2
X_4814_ _2653_ _2668_ _2672_ VGND VGND VPWR VPWR _2673_ sky130_fd_sc_hd__o21bai_4
XFILLER_21_324 VPWR VGND VPWR VGND sky130_ef_sc_hd__decap_12
X_5794_ net148 VGND VGND VPWR VPWR _0202_ sky130_fd_sc_hd__inv_2
X_4745_ _1540_ _2602_ VGND VGND VPWR VPWR _2604_ sky130_fd_sc_hd__or2_1
XFILLER_21_379 VGND VGND VPWR VPWR sky130_fd_sc_hd__decap_4
XFILLER_119_223 VGND VGND VPWR VPWR sky130_fd_sc_hd__fill_1
XFILLER_107_429 VPWR VGND VPWR VGND sky130_ef_sc_hd__decap_12
X_4676_ _2295_ _2544_ _2548_ _2538_ VGND VGND VPWR VPWR net45 sky130_fd_sc_hd__a211o_2
X_3627_ reg_file_inst.registry\[5\]\[10\] _1127_ net142 VGND VGND VPWR VPWR _1554_
+ sky130_fd_sc_hd__and3_1
X_6415_ clknet_leaf_2_clk _0823_ _0348_ VGND VGND VPWR VPWR reg_file_inst.registry\[1\]\[12\]
+ sky130_fd_sc_hd__dfrtp_1
X_6346_ clknet_leaf_18_clk _0754_ _0279_ VGND VGND VPWR VPWR reg_file_inst.registry\[8\]\[27\]
+ sky130_fd_sc_hd__dfrtp_1
X_3558_ reg_file_inst.registry\[14\]\[15\] _1138_ _1141_ reg_file_inst.registry\[11\]\[15\]
+ _1481_ VGND VGND VPWR VPWR _1488_ sky130_fd_sc_hd__a221o_1
XFILLER_115_473 VPWR VGND VPWR VGND sky130_ef_sc_hd__decap_12
XFILLER_0_206 VGND VGND VPWR VPWR sky130_fd_sc_hd__decap_8
X_6277_ clknet_leaf_10_clk _0685_ _0210_ VGND VGND VPWR VPWR MEMOFF\[14\] sky130_fd_sc_hd__dfrtp_1
XFILLER_0_239 VGND VGND VPWR VPWR sky130_fd_sc_hd__decap_3
X_3489_ _1323_ _1419_ _1372_ _1393_ VGND VGND VPWR VPWR _1421_ sky130_fd_sc_hd__or4b_2
X_5228_ _2897_ reg_file_inst.registry\[1\]\[15\] _2990_ VGND VGND VPWR VPWR _0826_
+ sky130_fd_sc_hd__mux2_1
X_5159_ _2977_ _2979_ VGND VGND VPWR VPWR _2980_ sky130_fd_sc_hd__nor2_1
XFILLER_72_725 VGND VGND VPWR VPWR sky130_fd_sc_hd__fill_1
XTAP_TAPCELL_ROW_27_603 VGND VPWR sky130_fd_sc_hd__tapvpwrvgnd_1
XFILLER_112_65 VPWR VGND VPWR VGND sky130_ef_sc_hd__decap_12
Xclkbuf_leaf_36_clk clknet_3_7__leaf_clk VGND VGND VPWR VPWR clknet_leaf_36_clk sky130_fd_sc_hd__clkbuf_8
XFILLER_71_246 VGND VGND VPWR VPWR sky130_fd_sc_hd__decap_8
XTAP_TAPCELL_ROW_55_956 VGND VPWR sky130_fd_sc_hd__tapvpwrvgnd_1
XFILLER_25_630 VPWR VGND VPWR VGND sky130_ef_sc_hd__decap_12
XFILLER_71_279 VGND VGND VPWR VPWR sky130_fd_sc_hd__fill_1
XFILLER_72_69 VGND VGND VPWR VPWR sky130_fd_sc_hd__fill_1
XFILLER_8_317 VGND VGND VPWR VPWR sky130_fd_sc_hd__fill_2
XFILLER_20_390 VGND VGND VPWR VPWR sky130_fd_sc_hd__fill_1
XFILLER_21_51 VGND VGND VPWR VPWR sky130_fd_sc_hd__decap_4
XFILLER_4_545 VPWR VGND VPWR VGND sky130_ef_sc_hd__decap_12
XFILLER_4_589 VPWR VGND VPWR VGND sky130_ef_sc_hd__decap_12
XFILLER_79_335 VGND VGND VPWR VPWR sky130_fd_sc_hd__fill_1
XTAP_TAPCELL_ROW_7_350 VGND VPWR sky130_fd_sc_hd__tapvpwrvgnd_1
XFILLER_90_533 VGND VGND VPWR VPWR sky130_fd_sc_hd__decap_4
XFILLER_90_511 VGND VGND VPWR VPWR sky130_fd_sc_hd__decap_6
XTAP_TAPCELL_ROW_85_1328 VGND VPWR sky130_fd_sc_hd__tapvpwrvgnd_1
XFILLER_90_544 VGND VGND VPWR VPWR sky130_fd_sc_hd__fill_2
Xclkbuf_leaf_27_clk clknet_3_3__leaf_clk VGND VGND VPWR VPWR clknet_leaf_27_clk sky130_fd_sc_hd__clkbuf_8
XFILLER_15_162 VGND VGND VPWR VPWR sky130_fd_sc_hd__decap_6
XFILLER_15_184 VGND VGND VPWR VPWR sky130_fd_sc_hd__decap_8
XFILLER_30_121 VGND VGND VPWR VPWR sky130_fd_sc_hd__fill_1
XFILLER_31_633 VGND VGND VPWR VPWR sky130_fd_sc_hd__decap_6
XFILLER_43_493 VGND VGND VPWR VPWR sky130_fd_sc_hd__decap_8
XFILLER_31_699 VGND VGND VPWR VPWR sky130_fd_sc_hd__decap_6
X_4530_ _2280_ _2406_ _2412_ VGND VGND VPWR VPWR _2413_ sky130_fd_sc_hd__o21ai_1
XTAP_TAPCELL_ROW_96_1468 VGND VPWR sky130_fd_sc_hd__tapvpwrvgnd_1
X_4461_ _2342_ _2345_ net134 VGND VGND VPWR VPWR _2346_ sky130_fd_sc_hd__mux2_1
XFILLER_7_86 VPWR VGND VPWR VGND sky130_ef_sc_hd__decap_12
X_6200_ clknet_leaf_37_clk _0608_ _0133_ VGND VGND VPWR VPWR reg_file_inst.registry\[5\]\[21\]
+ sky130_fd_sc_hd__dfrtp_1
X_3412_ _1334_ _1345_ VGND VGND VPWR VPWR _1347_ sky130_fd_sc_hd__xnor2_1
X_4392_ net137 _2277_ VGND VGND VPWR VPWR _2280_ sky130_fd_sc_hd__nand2_1
X_6131_ clknet_leaf_46_clk _0539_ _0064_ VGND VGND VPWR VPWR reg_file_inst.registry\[6\]\[8\]
+ sky130_fd_sc_hd__dfrtp_1
XFILLER_112_421 VPWR VGND VPWR VGND sky130_ef_sc_hd__decap_12
XFILLER_97_110 VGND VGND VPWR VPWR sky130_fd_sc_hd__fill_2
X_3343_ reg_file_inst.registry\[0\]\[21\] _1076_ _1273_ _1279_ VGND VGND VPWR VPWR
+ _1281_ sky130_fd_sc_hd__a2bb2o_2
XFILLER_98_699 VGND VGND VPWR VPWR sky130_fd_sc_hd__fill_1
X_3274_ reg_file_inst.registry\[6\]\[24\] _1135_ _1140_ reg_file_inst.registry\[3\]\[24\]
+ _1214_ VGND VGND VPWR VPWR _1215_ sky130_fd_sc_hd__a221o_1
XFILLER_85_305 VGND VGND VPWR VPWR sky130_fd_sc_hd__decap_6
X_6062_ net146 VGND VGND VPWR VPWR _0470_ sky130_fd_sc_hd__inv_2
X_5013_ reg_file_inst.registry\[7\]\[19\] _2854_ _2553_ VGND VGND VPWR VPWR _0894_
+ sky130_fd_sc_hd__mux2_1
XFILLER_85_349 VGND VGND VPWR VPWR sky130_fd_sc_hd__fill_2
XFILLER_38_221 VGND VGND VPWR VPWR sky130_fd_sc_hd__decap_6
XFILLER_66_563 VGND VGND VPWR VPWR sky130_fd_sc_hd__decap_8
XFILLER_66_541 VGND VGND VPWR VPWR sky130_fd_sc_hd__fill_1
XFILLER_66_574 VPWR VGND VPWR VGND sky130_ef_sc_hd__decap_12
XFILLER_54_725 VGND VGND VPWR VPWR sky130_fd_sc_hd__fill_1
XFILLER_26_29 VGND VGND VPWR VPWR sky130_fd_sc_hd__fill_1
Xclkbuf_leaf_18_clk clknet_3_2__leaf_clk VGND VGND VPWR VPWR clknet_leaf_18_clk sky130_fd_sc_hd__clkbuf_8
XPHY_EDGE_ROW_5_Right_5 VGND VGND VPWR VPWR sky130_fd_sc_hd__decap_3
X_5915_ net147 VGND VGND VPWR VPWR _0323_ sky130_fd_sc_hd__inv_2
XTAP_TAPCELL_ROW_52_915 VGND VPWR sky130_fd_sc_hd__tapvpwrvgnd_1
XTAP_TAPCELL_ROW_105_1575 VGND VPWR sky130_fd_sc_hd__tapvpwrvgnd_1
X_5846_ net147 VGND VGND VPWR VPWR _0254_ sky130_fd_sc_hd__inv_2
X_5777_ net147 VGND VGND VPWR VPWR _0185_ sky130_fd_sc_hd__inv_2
XFILLER_22_688 VPWR VGND VPWR VGND sky130_ef_sc_hd__decap_12
XTAP_TAPCELL_ROW_32_661 VGND VPWR sky130_fd_sc_hd__tapvpwrvgnd_1
X_4728_ _1307_ _2126_ _2586_ VGND VGND VPWR VPWR _2587_ sky130_fd_sc_hd__o21ai_1
XFILLER_107_237 VPWR VGND VPWR VGND sky130_ef_sc_hd__decap_12
X_4659_ _2531_ VGND VGND VPWR VPWR _2532_ sky130_fd_sc_hd__inv_2
XFILLER_115_281 VPWR VGND VPWR VGND sky130_ef_sc_hd__decap_12
XFILLER_103_432 VPWR VGND VPWR VGND sky130_ef_sc_hd__decap_12
X_6329_ clknet_leaf_26_clk _0737_ _0262_ VGND VGND VPWR VPWR reg_file_inst.registry\[8\]\[10\]
+ sky130_fd_sc_hd__dfrtp_1
XFILLER_1_559 VGND VGND VPWR VPWR sky130_fd_sc_hd__fill_1
XFILLER_88_165 VGND VGND VPWR VPWR sky130_fd_sc_hd__decap_3
XFILLER_76_305 VGND VGND VPWR VPWR sky130_fd_sc_hd__decap_3
XFILLER_67_47 VGND VGND VPWR VPWR sky130_fd_sc_hd__decap_8
XFILLER_67_69 VPWR VGND VPWR VGND sky130_ef_sc_hd__decap_12
XTAP_TAPCELL_ROW_4_320 VGND VPWR sky130_fd_sc_hd__tapvpwrvgnd_1
XFILLER_29_243 VGND VGND VPWR VPWR sky130_fd_sc_hd__fill_2
XFILLER_45_703 VGND VGND VPWR VPWR sky130_fd_sc_hd__fill_1
XFILLER_57_596 VGND VGND VPWR VPWR sky130_fd_sc_hd__decap_8
XFILLER_17_405 VPWR VGND VPWR VGND sky130_ef_sc_hd__decap_12
XFILLER_83_57 VGND VGND VPWR VPWR sky130_fd_sc_hd__decap_8
XFILLER_13_600 VGND VGND VPWR VPWR sky130_fd_sc_hd__decap_4
XFILLER_44_268 VGND VGND VPWR VPWR sky130_fd_sc_hd__fill_2
XFILLER_12_110 VPWR VGND VPWR VGND sky130_ef_sc_hd__decap_12
XFILLER_16_95 VGND VGND VPWR VPWR sky130_fd_sc_hd__decap_3
XFILLER_25_471 VPWR VGND VPWR VGND sky130_ef_sc_hd__decap_12
XTAP_TAPCELL_ROW_80_1269 VGND VPWR sky130_fd_sc_hd__tapvpwrvgnd_1
XTAP_TAPCELL_ROW_80_1258 VGND VPWR sky130_fd_sc_hd__tapvpwrvgnd_1
XFILLER_9_615 VGND VGND VPWR VPWR sky130_fd_sc_hd__fill_1
XTAP_TAPCELL_ROW_10_388 VGND VPWR sky130_fd_sc_hd__tapvpwrvgnd_1
XFILLER_4_386 VPWR VGND VPWR VGND sky130_ef_sc_hd__decap_12
XTAP_TAPCELL_ROW_91_1398 VGND VPWR sky130_fd_sc_hd__tapvpwrvgnd_1
XFILLER_121_273 VGND VGND VPWR VPWR sky130_fd_sc_hd__decap_6
XFILLER_94_102 VGND VGND VPWR VPWR sky130_fd_sc_hd__fill_1
XFILLER_67_349 VGND VGND VPWR VPWR sky130_fd_sc_hd__fill_1
XFILLER_35_213 VGND VGND VPWR VPWR sky130_fd_sc_hd__decap_8
XFILLER_90_330 VGND VGND VPWR VPWR sky130_fd_sc_hd__decap_6
XFILLER_75_393 VPWR VGND VPWR VGND sky130_ef_sc_hd__decap_12
X_3961_ net42 _1872_ _0965_ net43 VGND VGND VPWR VPWR _1877_ sky130_fd_sc_hd__o211a_1
XFILLER_35_279 VGND VGND VPWR VPWR sky130_fd_sc_hd__fill_1
X_5700_ net149 VGND VGND VPWR VPWR _0108_ sky130_fd_sc_hd__inv_2
XTAP_TAPCELL_ROW_18_488 VGND VPWR sky130_fd_sc_hd__tapvpwrvgnd_1
X_3892_ reg_file_inst.registry\[8\]\[1\] _1090_ _1092_ reg_file_inst.registry\[4\]\[1\]
+ VGND VGND VPWR VPWR _1810_ sky130_fd_sc_hd__a22o_1
X_5631_ net147 VGND VGND VPWR VPWR _0039_ sky130_fd_sc_hd__inv_2
X_5562_ _2528_ reg_file_inst.registry\[9\]\[1\] _3002_ VGND VGND VPWR VPWR _0504_
+ sky130_fd_sc_hd__mux2_1
XFILLER_8_681 VPWR VGND VPWR VGND sky130_ef_sc_hd__decap_12
X_4513_ _1708_ _2393_ _2387_ _2294_ VGND VGND VPWR VPWR _2396_ sky130_fd_sc_hd__a211oi_1
X_5493_ JMPOFF\[12\] _2934_ _3000_ VGND VGND VPWR VPWR _0571_ sky130_fd_sc_hd__mux2_1
Xclkbuf_leaf_7_clk clknet_3_1__leaf_clk VGND VGND VPWR VPWR clknet_leaf_7_clk sky130_fd_sc_hd__clkbuf_8
X_4444_ _1840_ _2213_ VGND VGND VPWR VPWR _2329_ sky130_fd_sc_hd__nor2_1
X_4375_ _1802_ _2190_ net132 VGND VGND VPWR VPWR _2263_ sky130_fd_sc_hd__a21oi_1
XFILLER_112_251 VGND VGND VPWR VPWR sky130_fd_sc_hd__fill_1
XFILLER_98_463 VGND VGND VPWR VPWR sky130_fd_sc_hd__decap_3
X_6114_ clknet_leaf_20_clk _0522_ _0047_ VGND VGND VPWR VPWR reg_file_inst.registry\[9\]\[19\]
+ sky130_fd_sc_hd__dfrtp_1
X_3326_ reg_file_inst.registry\[14\]\[22\] _1138_ _1257_ _1258_ _1260_ VGND VGND VPWR
+ VPWR _1265_ sky130_fd_sc_hd__a2111o_1
XFILLER_100_413 VGND VGND VPWR VPWR sky130_fd_sc_hd__decap_6
XFILLER_98_496 VPWR VGND VPWR VGND sky130_ef_sc_hd__decap_12
XFILLER_86_625 VPWR VGND VPWR VGND sky130_ef_sc_hd__decap_12
XFILLER_85_113 VGND VGND VPWR VPWR sky130_fd_sc_hd__decap_6
X_6045_ net146 VGND VGND VPWR VPWR _0453_ sky130_fd_sc_hd__inv_2
X_3257_ reg_file_inst.registry\[11\]\[24\] _1096_ _1098_ reg_file_inst.registry\[10\]\[24\]
+ VGND VGND VPWR VPWR _1198_ sky130_fd_sc_hd__a22o_1
XFILLER_86_669 VPWR VGND VPWR VGND sky130_ef_sc_hd__decap_12
XFILLER_85_146 VPWR VGND VPWR VGND sky130_ef_sc_hd__decap_12
XFILLER_39_530 VGND VGND VPWR VPWR sky130_fd_sc_hd__decap_8
XTAP_TAPCELL_ROW_107_1604 VGND VPWR sky130_fd_sc_hd__tapvpwrvgnd_1
X_3188_ net34 net37 net36 VGND VGND VPWR VPWR _1132_ sky130_fd_sc_hd__nor3b_4
XFILLER_54_522 VGND VGND VPWR VPWR sky130_fd_sc_hd__fill_1
XFILLER_81_330 VGND VGND VPWR VPWR sky130_fd_sc_hd__decap_6
XFILLER_54_533 VGND VGND VPWR VPWR sky130_fd_sc_hd__decap_3
XTAP_TAPCELL_ROW_37_731 VGND VPWR sky130_fd_sc_hd__tapvpwrvgnd_1
XFILLER_54_577 VGND VGND VPWR VPWR sky130_fd_sc_hd__decap_8
XFILLER_54_566 VGND VGND VPWR VPWR sky130_fd_sc_hd__fill_2
XFILLER_14_419 VGND VGND VPWR VPWR sky130_fd_sc_hd__fill_1
XTAP_TAPCELL_ROW_66_1091 VGND VPWR sky130_fd_sc_hd__tapvpwrvgnd_1
XFILLER_22_441 VPWR VGND VPWR VGND sky130_ef_sc_hd__decap_12
XFILLER_10_625 VPWR VGND VPWR VGND sky130_ef_sc_hd__decap_12
X_5829_ net147 VGND VGND VPWR VPWR _0237_ sky130_fd_sc_hd__inv_2
XFILLER_10_669 VPWR VGND VPWR VGND sky130_ef_sc_hd__decap_12
XTAP_TAPCELL_ROW_118_1744 VGND VPWR sky130_fd_sc_hd__tapvpwrvgnd_1
XTAP_TAPCELL_ROW_118_1733 VGND VPWR sky130_fd_sc_hd__tapvpwrvgnd_1
XFILLER_108_513 VPWR VGND VPWR VGND sky130_ef_sc_hd__decap_12
XFILLER_108_557 VPWR VGND VPWR VGND sky130_ef_sc_hd__decap_12
XFILLER_118_53 VPWR VGND VPWR VGND sky130_ef_sc_hd__decap_12
XFILLER_118_97 VPWR VGND VPWR VGND sky130_ef_sc_hd__decap_12
XFILLER_103_240 VGND VGND VPWR VPWR sky130_fd_sc_hd__fill_1
XFILLER_77_647 VGND VGND VPWR VPWR sky130_fd_sc_hd__fill_2
XFILLER_94_45 VPWR VGND VPWR VGND sky130_ef_sc_hd__decap_12
XFILLER_77_669 VGND VGND VPWR VPWR sky130_fd_sc_hd__decap_3
XFILLER_57_393 VGND VGND VPWR VPWR sky130_fd_sc_hd__decap_8
XFILLER_60_514 VGND VGND VPWR VPWR sky130_fd_sc_hd__decap_3
XFILLER_17_279 VGND VGND VPWR VPWR sky130_fd_sc_hd__fill_1
XTAP_TAPCELL_ROW_15_447 VGND VPWR sky130_fd_sc_hd__tapvpwrvgnd_1
XFILLER_25_290 VGND VGND VPWR VPWR sky130_fd_sc_hd__decap_8
XFILLER_40_271 VGND VGND VPWR VPWR sky130_fd_sc_hd__decap_8
XTAP_TAPCELL_ROW_93_1427 VGND VPWR sky130_fd_sc_hd__tapvpwrvgnd_1
XFILLER_5_673 VPWR VGND VPWR VGND sky130_ef_sc_hd__decap_12
XFILLER_4_183 VGND VGND VPWR VPWR sky130_fd_sc_hd__fill_1
X_4160_ _2021_ _2034_ _2032_ VGND VGND VPWR VPWR _2071_ sky130_fd_sc_hd__o21ba_1
XFILLER_4_65 VPWR VGND VPWR VGND sky130_ef_sc_hd__decap_12
XFILLER_67_113 VPWR VGND VPWR VGND sky130_ef_sc_hd__decap_12
X_3111_ _1034_ _1037_ _1054_ VGND VGND VPWR VPWR _1055_ sky130_fd_sc_hd__and3_1
XFILLER_68_669 VGND VGND VPWR VPWR sky130_fd_sc_hd__decap_4
X_4091_ _0974_ _2006_ _1064_ VGND VGND VPWR VPWR _2007_ sky130_fd_sc_hd__a21o_1
X_3042_ JMPOFF\[21\] _0967_ _0985_ VGND VGND VPWR VPWR _0986_ sky130_fd_sc_hd__a21oi_1
XFILLER_36_500 VPWR VGND VPWR VGND sky130_ef_sc_hd__decap_12
XFILLER_82_138 VGND VGND VPWR VPWR sky130_fd_sc_hd__fill_2
XFILLER_63_396 VGND VGND VPWR VPWR sky130_fd_sc_hd__decap_8
XFILLER_51_547 VPWR VGND VPWR VGND sky130_ef_sc_hd__decap_12
X_4993_ _1306_ _1320_ _2289_ _2837_ VGND VGND VPWR VPWR _2838_ sky130_fd_sc_hd__a2bb2o_1
XTAP_TAPCELL_ROW_102_1545 VGND VPWR sky130_fd_sc_hd__tapvpwrvgnd_1
XTAP_TAPCELL_ROW_102_1534 VGND VPWR sky130_fd_sc_hd__tapvpwrvgnd_1
XFILLER_16_290 VGND VGND VPWR VPWR sky130_fd_sc_hd__fill_1
X_3944_ _1708_ _1722_ _1753_ _1752_ _1735_ VGND VGND VPWR VPWR _1860_ sky130_fd_sc_hd__a32o_1
X_3875_ reg_file_inst.registry\[5\]\[2\] _1127_ net142 VGND VGND VPWR VPWR _1794_
+ sky130_fd_sc_hd__and3_1
X_5614_ net146 VGND VGND VPWR VPWR _0022_ sky130_fd_sc_hd__inv_2
X_5545_ _2863_ reg_file_inst.registry\[9\]\[18\] _3002_ VGND VGND VPWR VPWR _0521_
+ sky130_fd_sc_hd__mux2_1
XFILLER_105_505 VPWR VGND VPWR VGND sky130_ef_sc_hd__decap_12
X_5476_ reg_file_inst.registry\[5\]\[0\] _2550_ _2999_ VGND VGND VPWR VPWR _0587_
+ sky130_fd_sc_hd__mux2_1
X_4427_ _2145_ _2172_ _2142_ VGND VGND VPWR VPWR _2312_ sky130_fd_sc_hd__a21o_1
XTAP_TAPCELL_ROW_113_1674 VGND VPWR sky130_fd_sc_hd__tapvpwrvgnd_1
XFILLER_59_614 VGND VGND VPWR VPWR sky130_fd_sc_hd__fill_2
X_4358_ _1194_ _1841_ _2190_ _2240_ VGND VGND VPWR VPWR _2246_ sky130_fd_sc_hd__a31oi_1
X_3309_ reg_file_inst.registry\[3\]\[22\] _1091_ _1098_ reg_file_inst.registry\[10\]\[22\]
+ _1245_ VGND VGND VPWR VPWR _1248_ sky130_fd_sc_hd__a221o_1
XFILLER_58_157 VGND VGND VPWR VPWR sky130_fd_sc_hd__decap_6
X_4289_ _2112_ _2125_ _2127_ _1113_ VGND VGND VPWR VPWR _2177_ sky130_fd_sc_hd__o211a_4
XFILLER_58_179 VGND VGND VPWR VPWR sky130_fd_sc_hd__decap_4
X_6028_ net148 VGND VGND VPWR VPWR _0436_ sky130_fd_sc_hd__inv_2
XFILLER_104_77 VGND VGND VPWR VPWR sky130_fd_sc_hd__decap_6
XTAP_TAPCELL_ROW_68_1120 VGND VPWR sky130_fd_sc_hd__tapvpwrvgnd_1
XFILLER_27_533 VPWR VGND VPWR VGND sky130_ef_sc_hd__decap_12
XFILLER_14_205 VGND VGND VPWR VPWR sky130_fd_sc_hd__fill_2
XFILLER_14_216 VGND VGND VPWR VPWR sky130_fd_sc_hd__decap_4
XFILLER_42_514 VGND VGND VPWR VPWR sky130_fd_sc_hd__decap_4
XFILLER_120_65 VPWR VGND VPWR VGND sky130_ef_sc_hd__decap_12
XFILLER_80_25 VGND VGND VPWR VPWR sky130_fd_sc_hd__decap_3
XTAP_TAPCELL_ROW_12_417 VGND VPWR sky130_fd_sc_hd__tapvpwrvgnd_1
XTAP_TAPCELL_ROW_40_759 VGND VPWR sky130_fd_sc_hd__tapvpwrvgnd_1
XFILLER_10_477 VGND VGND VPWR VPWR sky130_fd_sc_hd__decap_3
XFILLER_108_321 VPWR VGND VPWR VGND sky130_ef_sc_hd__decap_12
XFILLER_10_499 VGND VGND VPWR VPWR sky130_fd_sc_hd__fill_1
XFILLER_108_365 VPWR VGND VPWR VGND sky130_ef_sc_hd__decap_12
XFILLER_97_709 VPWR VGND VPWR VGND sky130_ef_sc_hd__decap_12
XPHY_EDGE_ROW_8_Left_131 VGND VGND VPWR VPWR sky130_fd_sc_hd__decap_3
XFILLER_2_643 VGND VGND VPWR VPWR sky130_fd_sc_hd__fill_1
XFILLER_1_153 VGND VGND VPWR VPWR sky130_fd_sc_hd__fill_1
XFILLER_49_113 VGND VGND VPWR VPWR sky130_fd_sc_hd__decap_3
XFILLER_89_293 VPWR VGND VPWR VGND sky130_ef_sc_hd__decap_12
XFILLER_77_477 VGND VGND VPWR VPWR sky130_fd_sc_hd__decap_4
XFILLER_65_639 VGND VGND VPWR VPWR sky130_fd_sc_hd__decap_4
XFILLER_65_617 VGND VGND VPWR VPWR sky130_fd_sc_hd__decap_3
XFILLER_58_680 VGND VGND VPWR VPWR sky130_fd_sc_hd__fill_1
XFILLER_38_82 VGND VGND VPWR VPWR sky130_fd_sc_hd__fill_2
XTAP_TAPCELL_ROW_48_859 VGND VPWR sky130_fd_sc_hd__tapvpwrvgnd_1
XFILLER_33_503 VGND VGND VPWR VPWR sky130_fd_sc_hd__fill_1
XFILLER_73_694 VGND VGND VPWR VPWR sky130_fd_sc_hd__decap_4
XFILLER_21_709 VPWR VGND VPWR VGND sky130_ef_sc_hd__decap_12
X_3660_ reg_file_inst.registry\[2\]\[9\] net145 _1123_ VGND VGND VPWR VPWR _1586_
+ sky130_fd_sc_hd__and3_1
Xclkload23 clknet_leaf_17_clk VGND VGND VPWR VPWR clkload23/Y sky130_fd_sc_hd__clkinvlp_4
Xclkload34 clknet_leaf_45_clk VGND VGND VPWR VPWR clkload34/Y sky130_fd_sc_hd__bufinv_16
X_3591_ _1447_ _1470_ _1494_ _1518_ VGND VGND VPWR VPWR _1519_ sky130_fd_sc_hd__or4_1
Xclkload12 clknet_leaf_63_clk VGND VGND VPWR VPWR clkload12/Y sky130_fd_sc_hd__clkinv_8
Xclkload56 clknet_leaf_39_clk VGND VGND VPWR VPWR clkload56/Y sky130_fd_sc_hd__inv_6
XFILLER_55_3 VPWR VGND VPWR VGND sky130_ef_sc_hd__decap_12
Xclkload45 clknet_leaf_53_clk VGND VGND VPWR VPWR clkload45/Y sky130_fd_sc_hd__inv_6
X_5330_ _2528_ reg_file_inst.registry\[8\]\[1\] _2994_ VGND VGND VPWR VPWR _0728_
+ sky130_fd_sc_hd__mux2_1
X_5261_ reg_file_inst.registry\[14\]\[12\] _2934_ _2992_ VGND VGND VPWR VPWR _0795_
+ sky130_fd_sc_hd__mux2_1
XFILLER_114_357 VGND VGND VPWR VPWR sky130_fd_sc_hd__decap_6
X_4212_ _2105_ net125 net130 VGND VGND VPWR VPWR _0927_ sky130_fd_sc_hd__mux2_1
X_5192_ _2922_ reg_file_inst.registry\[0\]\[13\] _2988_ VGND VGND VPWR VPWR _0860_
+ sky130_fd_sc_hd__mux2_1
X_4143_ _2057_ _2058_ VGND VGND VPWR VPWR _2059_ sky130_fd_sc_hd__xnor2_1
XFILLER_68_433 VPWR VGND VPWR VGND sky130_ef_sc_hd__decap_12
XFILLER_68_477 VGND VGND VPWR VPWR sky130_fd_sc_hd__fill_1
X_4074_ _1921_ _1989_ _1926_ VGND VGND VPWR VPWR _1990_ sky130_fd_sc_hd__o21a_1
X_3025_ JMPOFF\[25\] net141 net41 VGND VGND VPWR VPWR _0969_ sky130_fd_sc_hd__a21oi_1
XFILLER_55_149 VGND VGND VPWR VPWR sky130_fd_sc_hd__decap_4
XFILLER_64_672 VGND VGND VPWR VPWR sky130_fd_sc_hd__decap_8
XFILLER_91_480 VGND VGND VPWR VPWR sky130_fd_sc_hd__fill_1
XTAP_TAPCELL_ROW_63_1050 VGND VPWR sky130_fd_sc_hd__tapvpwrvgnd_1
XFILLER_51_377 VPWR VGND VPWR VGND sky130_ef_sc_hd__decap_12
X_4976_ net136 _2756_ _2822_ _2279_ VGND VGND VPWR VPWR _2823_ sky130_fd_sc_hd__o211a_1
X_3927_ reg_file_inst.registry\[9\]\[0\] _1125_ _1127_ VGND VGND VPWR VPWR _1844_
+ sky130_fd_sc_hd__and3_1
Xclkload6 clknet_leaf_1_clk VGND VGND VPWR VPWR clkload6/Y sky130_fd_sc_hd__clkinv_2
X_3858_ reg_file_inst.registry\[0\]\[3\] _1118_ _1774_ _1777_ VGND VGND VPWR VPWR
+ net94 sky130_fd_sc_hd__o22a_2
X_3789_ reg_file_inst.registry\[2\]\[4\] _1116_ _1123_ VGND VGND VPWR VPWR _1711_
+ sky130_fd_sc_hd__and3_1
XTAP_TAPCELL_ROW_115_1703 VGND VPWR sky130_fd_sc_hd__tapvpwrvgnd_1
X_5528_ reg_file_inst.registry\[6\]\[6\] _2375_ _3001_ VGND VGND VPWR VPWR _0537_
+ sky130_fd_sc_hd__mux2_1
XFILLER_105_335 VGND VGND VPWR VPWR sky130_fd_sc_hd__fill_1
XFILLER_79_709 VPWR VGND VPWR VGND sky130_ef_sc_hd__decap_12
X_5459_ reg_file_inst.registry\[5\]\[17\] _2873_ _2999_ VGND VGND VPWR VPWR _0604_
+ sky130_fd_sc_hd__mux2_1
XTAP_TAPCELL_ROW_74_1190 VGND VPWR sky130_fd_sc_hd__tapvpwrvgnd_1
XFILLER_101_541 VPWR VGND VPWR VGND sky130_ef_sc_hd__decap_12
XFILLER_59_455 VGND VGND VPWR VPWR sky130_fd_sc_hd__fill_1
XFILLER_59_433 VGND VGND VPWR VPWR sky130_fd_sc_hd__fill_2
XFILLER_101_585 VPWR VGND VPWR VGND sky130_ef_sc_hd__decap_12
XFILLER_47_617 VPWR VGND VPWR VGND sky130_ef_sc_hd__decap_12
XFILLER_46_149 VGND VGND VPWR VPWR sky130_fd_sc_hd__fill_2
XFILLER_62_609 VPWR VGND VPWR VGND sky130_ef_sc_hd__decap_12
XFILLER_27_352 VGND VGND VPWR VPWR sky130_fd_sc_hd__fill_1
XTAP_TAPCELL_ROW_45_829 VGND VPWR sky130_fd_sc_hd__tapvpwrvgnd_1
XFILLER_91_57 VGND VGND VPWR VPWR sky130_fd_sc_hd__fill_1
XFILLER_70_675 VPWR VGND VPWR VGND sky130_ef_sc_hd__decap_12
XTAP_TAPCELL_ROW_25_575 VGND VPWR sky130_fd_sc_hd__tapvpwrvgnd_1
XFILLER_23_580 VGND VGND VPWR VPWR sky130_fd_sc_hd__fill_2
XFILLER_109_641 VPWR VGND VPWR VGND sky130_ef_sc_hd__decap_12
XFILLER_109_685 VPWR VGND VPWR VGND sky130_ef_sc_hd__decap_12
XFILLER_40_50 VGND VGND VPWR VPWR sky130_fd_sc_hd__decap_8
XFILLER_108_195 VGND VGND VPWR VPWR sky130_fd_sc_hd__fill_1
XFILLER_41_9 VGND VGND VPWR VPWR sky130_fd_sc_hd__fill_1
XFILLER_111_305 VPWR VGND VPWR VGND sky130_ef_sc_hd__decap_12
XFILLER_2_473 VGND VGND VPWR VPWR sky130_fd_sc_hd__decap_3
XFILLER_111_349 VPWR VGND VPWR VGND sky130_ef_sc_hd__decap_12
XFILLER_49_70 VGND VGND VPWR VPWR sky130_fd_sc_hd__fill_1
XFILLER_77_274 VGND VGND VPWR VPWR sky130_fd_sc_hd__decap_6
XFILLER_65_414 VPWR VGND VPWR VGND sky130_ef_sc_hd__decap_12
XFILLER_1_55 VGND VGND VPWR VPWR sky130_fd_sc_hd__fill_1
XFILLER_92_244 VGND VGND VPWR VPWR sky130_fd_sc_hd__fill_1
XTAP_TAPCELL_ROW_88_1359 VGND VPWR sky130_fd_sc_hd__tapvpwrvgnd_1
XFILLER_18_341 VGND VGND VPWR VPWR sky130_fd_sc_hd__fill_2
XFILLER_37_149 VGND VGND VPWR VPWR sky130_fd_sc_hd__decap_4
XFILLER_61_653 VGND VGND VPWR VPWR sky130_fd_sc_hd__decap_3
X_4830_ _1791_ _2688_ _2685_ VGND VGND VPWR VPWR _2689_ sky130_fd_sc_hd__a21o_1
XFILLER_60_152 VPWR VGND VPWR VGND sky130_ef_sc_hd__decap_12
XFILLER_60_141 VGND VGND VPWR VPWR sky130_fd_sc_hd__fill_2
XFILLER_21_539 VGND VGND VPWR VPWR sky130_fd_sc_hd__fill_1
X_4761_ _2612_ _2613_ VGND VGND VPWR VPWR _2620_ sky130_fd_sc_hd__nand2b_1
XFILLER_119_405 VPWR VGND VPWR VGND sky130_ef_sc_hd__decap_12
X_4692_ reg_file_inst.registry\[11\]\[24\] _2550_ _2551_ VGND VGND VPWR VPWR _0903_
+ sky130_fd_sc_hd__mux2_1
X_6500_ clknet_leaf_6_clk _0908_ _0433_ VGND VGND VPWR VPWR reg_file_inst.registry\[11\]\[9\]
+ sky130_fd_sc_hd__dfrtp_1
X_3712_ _1296_ _1307_ _1320_ _1294_ _1281_ VGND VGND VPWR VPWR _1636_ sky130_fd_sc_hd__o32a_1
XFILLER_119_449 VPWR VGND VPWR VGND sky130_ef_sc_hd__decap_12
X_6431_ clknet_leaf_23_clk _0839_ _0364_ VGND VGND VPWR VPWR reg_file_inst.registry\[11\]\[16\]
+ sky130_fd_sc_hd__dfrtp_2
X_3643_ _1542_ _1568_ VGND VGND VPWR VPWR _1569_ sky130_fd_sc_hd__or2_1
XTAP_TAPCELL_ROW_99_1499 VGND VPWR sky130_fd_sc_hd__tapvpwrvgnd_1
X_6362_ clknet_leaf_13_clk _0770_ _0295_ VGND VGND VPWR VPWR reg_file_inst.registry\[2\]\[15\]
+ sky130_fd_sc_hd__dfrtp_1
X_5313_ _2863_ reg_file_inst.registry\[8\]\[18\] _2994_ VGND VGND VPWR VPWR _0745_
+ sky130_fd_sc_hd__mux2_1
X_3574_ net140 _1498_ _1499_ _1502_ VGND VGND VPWR VPWR _1503_ sky130_fd_sc_hd__or4_1
XFILLER_114_121 VPWR VGND VPWR VGND sky130_ef_sc_hd__decap_12
X_6293_ clknet_leaf_61_clk _0701_ _0226_ VGND VGND VPWR VPWR reg_file_inst.registry\[3\]\[2\]
+ sky130_fd_sc_hd__dfrtp_1
XFILLER_114_165 VPWR VGND VPWR VGND sky130_ef_sc_hd__decap_12
X_5244_ _0958_ _0959_ _2114_ _2117_ VGND VGND VPWR VPWR _2991_ sky130_fd_sc_hd__or4_4
XTAP_TAPCELL_ROW_110_1644 VGND VPWR sky130_fd_sc_hd__tapvpwrvgnd_1
XTAP_TAPCELL_ROW_110_1633 VGND VPWR sky130_fd_sc_hd__tapvpwrvgnd_1
XFILLER_102_349 VPWR VGND VPWR VGND sky130_ef_sc_hd__decap_12
X_5175_ reg_file_inst.registry\[7\]\[0\] _2550_ _2553_ VGND VGND VPWR VPWR _0875_
+ sky130_fd_sc_hd__mux2_1
XFILLER_84_701 VPWR VGND VPWR VGND sky130_ef_sc_hd__decap_12
X_4126_ _0977_ _0988_ _2037_ VGND VGND VPWR VPWR _2042_ sky130_fd_sc_hd__nand3_1
XFILLER_29_617 VPWR VGND VPWR VGND sky130_ef_sc_hd__decap_12
XFILLER_83_233 VGND VGND VPWR VPWR sky130_fd_sc_hd__fill_1
XFILLER_83_255 VPWR VGND VPWR VGND sky130_ef_sc_hd__decap_12
X_4057_ _1967_ _1971_ _1972_ VGND VGND VPWR VPWR _1973_ sky130_fd_sc_hd__o21a_1
X_3008_ JMPOFF\[1\] VGND VGND VPWR VPWR _0954_ sky130_fd_sc_hd__inv_2
XFILLER_12_517 VGND VGND VPWR VPWR sky130_fd_sc_hd__fill_1
XTAP_TAPCELL_ROW_121_1773 VGND VPWR sky130_fd_sc_hd__tapvpwrvgnd_1
XFILLER_61_38 VGND VGND VPWR VPWR sky130_fd_sc_hd__decap_4
X_4959_ _1268_ _2286_ _2124_ _1256_ VGND VGND VPWR VPWR _2808_ sky130_fd_sc_hd__o2bb2a_1
XTAP_TAPCELL_ROW_22_534 VGND VPWR sky130_fd_sc_hd__tapvpwrvgnd_1
XTAP_TAPCELL_ROW_22_545 VGND VPWR sky130_fd_sc_hd__tapvpwrvgnd_1
XTAP_TAPCELL_ROW_50_887 VGND VPWR sky130_fd_sc_hd__tapvpwrvgnd_1
XPHY_EDGE_ROW_89_Left_212 VGND VGND VPWR VPWR sky130_fd_sc_hd__decap_3
XFILLER_10_53 VPWR VGND VPWR VGND sky130_ef_sc_hd__decap_12
XFILLER_106_699 VGND VGND VPWR VPWR sky130_fd_sc_hd__fill_1
XFILLER_79_539 VPWR VGND VPWR VGND sky130_ef_sc_hd__decap_12
XFILLER_79_528 VGND VGND VPWR VPWR sky130_fd_sc_hd__decap_6
XFILLER_10_97 VPWR VGND VPWR VGND sky130_ef_sc_hd__decap_12
XFILLER_10_75 VGND VGND VPWR VPWR sky130_fd_sc_hd__decap_8
XFILLER_87_561 VGND VGND VPWR VPWR sky130_fd_sc_hd__decap_8
XFILLER_86_79 VGND VGND VPWR VPWR sky130_fd_sc_hd__decap_4
XPHY_EDGE_ROW_98_Left_221 VGND VGND VPWR VPWR sky130_fd_sc_hd__decap_3
XFILLER_59_285 VGND VGND VPWR VPWR sky130_fd_sc_hd__fill_1
XTAP_TAPCELL_ROW_58_987 VGND VPWR sky130_fd_sc_hd__tapvpwrvgnd_1
XTAP_TAPCELL_ROW_2_292 VGND VPWR sky130_fd_sc_hd__tapvpwrvgnd_1
XFILLER_15_300 VPWR VGND VPWR VGND sky130_ef_sc_hd__decap_12
XFILLER_34_108 VGND VGND VPWR VPWR sky130_fd_sc_hd__decap_3
XFILLER_70_472 VGND VGND VPWR VPWR sky130_fd_sc_hd__decap_4
XFILLER_15_366 VGND VGND VPWR VPWR sky130_fd_sc_hd__fill_1
XFILLER_35_94 VPWR VGND VPWR VGND sky130_ef_sc_hd__decap_12
XFILLER_42_141 VPWR VGND VPWR VGND sky130_ef_sc_hd__decap_12
XFILLER_30_314 VPWR VGND VPWR VGND sky130_ef_sc_hd__decap_12
XFILLER_89_9 VGND VGND VPWR VPWR sky130_fd_sc_hd__fill_1
XFILLER_30_347 VGND VGND VPWR VPWR sky130_fd_sc_hd__fill_1
XFILLER_30_358 VGND VGND VPWR VPWR sky130_fd_sc_hd__decap_6
XFILLER_30_369 VGND VGND VPWR VPWR sky130_fd_sc_hd__fill_1
XFILLER_11_561 VPWR VGND VPWR VGND sky130_ef_sc_hd__decap_12
XFILLER_116_419 VGND VGND VPWR VPWR sky130_fd_sc_hd__fill_1
XFILLER_112_625 VPWR VGND VPWR VGND sky130_ef_sc_hd__decap_12
X_3290_ _1075_ _1225_ _1226_ _1229_ VGND VGND VPWR VPWR _1230_ sky130_fd_sc_hd__or4_1
XFILLER_112_669 VPWR VGND VPWR VGND sky130_ef_sc_hd__decap_12
XFILLER_111_113 VPWR VGND VPWR VGND sky130_ef_sc_hd__decap_12
XFILLER_78_572 VPWR VGND VPWR VGND sky130_ef_sc_hd__decap_12
XFILLER_66_701 VPWR VGND VPWR VGND sky130_ef_sc_hd__decap_12
XFILLER_93_520 VGND VGND VPWR VPWR sky130_fd_sc_hd__decap_6
XFILLER_18_3 VPWR VGND VPWR VGND sky130_ef_sc_hd__decap_12
XFILLER_38_425 VGND VGND VPWR VPWR sky130_fd_sc_hd__fill_1
XFILLER_65_266 VPWR VGND VPWR VGND sky130_ef_sc_hd__decap_12
X_5931_ net148 VGND VGND VPWR VPWR _0339_ sky130_fd_sc_hd__inv_2
X_5862_ net147 VGND VGND VPWR VPWR _0270_ sky130_fd_sc_hd__inv_2
XFILLER_61_461 VGND VGND VPWR VPWR sky130_fd_sc_hd__decap_6
X_4813_ _2663_ _2665_ _2669_ _2671_ VGND VGND VPWR VPWR _2672_ sky130_fd_sc_hd__a31o_1
XFILLER_34_697 VGND VGND VPWR VPWR sky130_fd_sc_hd__decap_3
X_5793_ net149 VGND VGND VPWR VPWR _0201_ sky130_fd_sc_hd__inv_2
XTAP_TAPCELL_ROW_60_1020 VGND VPWR sky130_fd_sc_hd__tapvpwrvgnd_1
X_4744_ _1540_ _2602_ VGND VGND VPWR VPWR _2603_ sky130_fd_sc_hd__and2_1
XFILLER_119_279 VGND VGND VPWR VPWR sky130_fd_sc_hd__fill_1
X_4675_ _2192_ _2543_ _2547_ _2249_ _2255_ VGND VGND VPWR VPWR _2548_ sky130_fd_sc_hd__o221a_1
X_3626_ reg_file_inst.registry\[4\]\[10\] _1114_ net142 VGND VGND VPWR VPWR _1553_
+ sky130_fd_sc_hd__and3_1
X_6414_ clknet_leaf_63_clk _0822_ _0347_ VGND VGND VPWR VPWR reg_file_inst.registry\[1\]\[11\]
+ sky130_fd_sc_hd__dfrtp_1
XFILLER_115_441 VGND VGND VPWR VPWR sky130_fd_sc_hd__decap_6
X_6345_ clknet_leaf_21_clk _0753_ _0278_ VGND VGND VPWR VPWR reg_file_inst.registry\[8\]\[26\]
+ sky130_fd_sc_hd__dfrtp_1
X_3557_ MEMOFF\[15\] _1129_ _1131_ reg_file_inst.registry\[9\]\[15\] _1117_ VGND VGND
+ VPWR VPWR _1487_ sky130_fd_sc_hd__a221o_1
XFILLER_115_485 VPWR VGND VPWR VGND sky130_ef_sc_hd__decap_12
X_6276_ clknet_leaf_1_clk _0684_ _0209_ VGND VGND VPWR VPWR MEMOFF\[13\] sky130_fd_sc_hd__dfrtp_1
X_5227_ _2883_ reg_file_inst.registry\[1\]\[16\] _2990_ VGND VGND VPWR VPWR _0827_
+ sky130_fd_sc_hd__mux2_1
X_3488_ _1323_ _1419_ _1372_ _1393_ VGND VGND VPWR VPWR _1420_ sky130_fd_sc_hd__nor4b_1
XFILLER_69_561 VGND VGND VPWR VPWR sky130_fd_sc_hd__decap_3
XFILLER_84_531 VGND VGND VPWR VPWR sky130_fd_sc_hd__fill_1
XFILLER_57_723 VGND VGND VPWR VPWR sky130_fd_sc_hd__decap_3
X_5158_ _2301_ _2531_ _2297_ VGND VGND VPWR VPWR _2979_ sky130_fd_sc_hd__o21a_1
X_4109_ _0986_ _2023_ VGND VGND VPWR VPWR _2025_ sky130_fd_sc_hd__nand2_1
X_5089_ _1764_ _2384_ _2399_ _2448_ VGND VGND VPWR VPWR _2920_ sky130_fd_sc_hd__o22a_1
XFILLER_29_458 VPWR VGND VPWR VGND sky130_ef_sc_hd__decap_12
XFILLER_56_288 VPWR VGND VPWR VGND sky130_ef_sc_hd__decap_12
XTAP_TAPCELL_ROW_27_604 VGND VPWR sky130_fd_sc_hd__tapvpwrvgnd_1
XFILLER_112_77 VGND VGND VPWR VPWR sky130_fd_sc_hd__decap_6
XFILLER_71_225 VGND VGND VPWR VPWR sky130_fd_sc_hd__fill_1
XTAP_TAPCELL_ROW_55_957 VGND VPWR sky130_fd_sc_hd__tapvpwrvgnd_1
XTAP_TAPCELL_ROW_55_946 VGND VPWR sky130_fd_sc_hd__tapvpwrvgnd_1
XFILLER_25_642 VPWR VGND VPWR VGND sky130_ef_sc_hd__decap_12
XFILLER_12_303 VGND VGND VPWR VPWR sky130_fd_sc_hd__fill_1
XFILLER_24_141 VGND VGND VPWR VPWR sky130_fd_sc_hd__decap_6
XFILLER_40_601 VGND VGND VPWR VPWR sky130_fd_sc_hd__fill_1
XFILLER_52_483 VGND VGND VPWR VPWR sky130_fd_sc_hd__fill_1
XFILLER_24_174 VGND VGND VPWR VPWR sky130_fd_sc_hd__decap_4
XFILLER_40_634 VGND VGND VPWR VPWR sky130_fd_sc_hd__decap_8
XFILLER_40_645 VPWR VGND VPWR VGND sky130_ef_sc_hd__decap_12
XFILLER_8_307 VGND VGND VPWR VPWR sky130_fd_sc_hd__fill_1
XFILLER_122_3 VPWR VGND VPWR VGND sky130_ef_sc_hd__decap_12
XFILLER_4_557 VPWR VGND VPWR VGND sky130_ef_sc_hd__decap_12
XFILLER_79_314 VGND VGND VPWR VPWR sky130_fd_sc_hd__decap_6
XTAP_TAPCELL_ROW_7_351 VGND VPWR sky130_fd_sc_hd__tapvpwrvgnd_1
XFILLER_47_255 VPWR VGND VPWR VGND sky130_ef_sc_hd__decap_12
XTAP_TAPCELL_ROW_85_1329 VGND VPWR sky130_fd_sc_hd__tapvpwrvgnd_1
XFILLER_16_620 VGND VGND VPWR VPWR sky130_fd_sc_hd__decap_6
XFILLER_28_491 VPWR VGND VPWR VGND sky130_ef_sc_hd__decap_12
XFILLER_90_589 VPWR VGND VPWR VGND sky130_ef_sc_hd__decap_12
XFILLER_62_258 VPWR VGND VPWR VGND sky130_ef_sc_hd__decap_12
XFILLER_16_686 VPWR VGND VPWR VGND sky130_ef_sc_hd__decap_12
XFILLER_43_461 VPWR VGND VPWR VGND sky130_ef_sc_hd__decap_12
XFILLER_94_7 VGND VGND VPWR VPWR sky130_fd_sc_hd__fill_1
XFILLER_30_155 VGND VGND VPWR VPWR sky130_fd_sc_hd__decap_8
XFILLER_7_351 VPWR VGND VPWR VGND sky130_ef_sc_hd__decap_12
XTAP_TAPCELL_ROW_96_1458 VGND VPWR sky130_fd_sc_hd__tapvpwrvgnd_1
X_4460_ _2343_ _2344_ VGND VGND VPWR VPWR _2345_ sky130_fd_sc_hd__nor2_1
XTAP_TAPCELL_ROW_96_1469 VGND VPWR sky130_fd_sc_hd__tapvpwrvgnd_1
XFILLER_7_98 VGND VGND VPWR VPWR sky130_fd_sc_hd__fill_2
X_4391_ _1764_ _2278_ VGND VGND VPWR VPWR _2279_ sky130_fd_sc_hd__nor2_4
X_3411_ _1333_ _1345_ VGND VGND VPWR VPWR _1346_ sky130_fd_sc_hd__nand2_1
XFILLER_98_601 VPWR VGND VPWR VGND sky130_ef_sc_hd__decap_12
X_3342_ _1273_ _1279_ reg_file_inst.registry\[0\]\[21\] _1076_ VGND VGND VPWR VPWR
+ _1280_ sky130_fd_sc_hd__o2bb2a_2
X_6130_ clknet_leaf_41_clk _0538_ _0063_ VGND VGND VPWR VPWR reg_file_inst.registry\[6\]\[7\]
+ sky130_fd_sc_hd__dfrtp_1
XFILLER_112_433 VPWR VGND VPWR VGND sky130_ef_sc_hd__decap_12
XFILLER_98_645 VPWR VGND VPWR VGND sky130_ef_sc_hd__decap_12
XFILLER_112_477 VPWR VGND VPWR VGND sky130_ef_sc_hd__decap_12
X_3273_ reg_file_inst.registry\[4\]\[24\] _1134_ _1138_ reg_file_inst.registry\[14\]\[24\]
+ VGND VGND VPWR VPWR _1214_ sky130_fd_sc_hd__a22o_1
X_6061_ net146 VGND VGND VPWR VPWR _0469_ sky130_fd_sc_hd__inv_2
X_5012_ net11 net101 net55 _2308_ VGND VGND VPWR VPWR _2854_ sky130_fd_sc_hd__a22o_4
XFILLER_66_531 VGND VGND VPWR VPWR sky130_fd_sc_hd__fill_1
XFILLER_66_586 VGND VGND VPWR VPWR sky130_fd_sc_hd__fill_2
XFILLER_53_203 VGND VGND VPWR VPWR sky130_fd_sc_hd__decap_4
XFILLER_26_417 VGND VGND VPWR VPWR sky130_fd_sc_hd__decap_3
XFILLER_53_225 VGND VGND VPWR VPWR sky130_fd_sc_hd__decap_3
X_5914_ net147 VGND VGND VPWR VPWR _0322_ sky130_fd_sc_hd__inv_2
XTAP_TAPCELL_ROW_52_916 VGND VPWR sky130_fd_sc_hd__tapvpwrvgnd_1
XFILLER_22_601 VGND VGND VPWR VPWR sky130_fd_sc_hd__fill_2
XTAP_TAPCELL_ROW_105_1576 VGND VPWR sky130_fd_sc_hd__tapvpwrvgnd_1
XFILLER_21_111 VGND VGND VPWR VPWR sky130_fd_sc_hd__fill_1
X_5845_ net149 VGND VGND VPWR VPWR _0253_ sky130_fd_sc_hd__inv_2
XFILLER_22_645 VPWR VGND VPWR VGND sky130_ef_sc_hd__decap_12
XFILLER_42_29 VGND VGND VPWR VPWR sky130_fd_sc_hd__decap_4
X_5776_ net44 VGND VGND VPWR VPWR _0184_ sky130_fd_sc_hd__inv_2
XTAP_TAPCELL_ROW_32_662 VGND VPWR sky130_fd_sc_hd__tapvpwrvgnd_1
X_4727_ _1334_ _2126_ _2562_ VGND VGND VPWR VPWR _2586_ sky130_fd_sc_hd__o21a_1
XFILLER_107_205 VPWR VGND VPWR VGND sky130_ef_sc_hd__decap_12
X_4658_ _1790_ _2430_ VGND VGND VPWR VPWR _2531_ sky130_fd_sc_hd__or2_1
XFILLER_107_249 VPWR VGND VPWR VGND sky130_ef_sc_hd__decap_12
X_3609_ reg_file_inst.registry\[11\]\[11\] _1141_ _1530_ _1531_ _1532_ VGND VGND VPWR
+ VPWR _1537_ sky130_fd_sc_hd__a2111o_1
XFILLER_1_505 VPWR VGND VPWR VGND sky130_ef_sc_hd__decap_12
X_4589_ _2282_ _2289_ _1778_ VGND VGND VPWR VPWR _2468_ sky130_fd_sc_hd__mux2_1
XFILLER_115_293 VPWR VGND VPWR VGND sky130_ef_sc_hd__decap_12
XFILLER_107_55 VGND VGND VPWR VPWR sky130_fd_sc_hd__fill_1
X_6328_ clknet_leaf_26_clk _0736_ _0261_ VGND VGND VPWR VPWR reg_file_inst.registry\[8\]\[9\]
+ sky130_fd_sc_hd__dfrtp_1
XFILLER_103_444 VGND VGND VPWR VPWR sky130_fd_sc_hd__decap_4
X_6259_ clknet_leaf_32_clk _0667_ _0192_ VGND VGND VPWR VPWR reg_file_inst.registry\[4\]\[24\]
+ sky130_fd_sc_hd__dfrtp_1
XFILLER_67_15 VPWR VGND VPWR VGND sky130_ef_sc_hd__decap_12
XFILLER_69_380 VPWR VGND VPWR VGND sky130_ef_sc_hd__decap_12
XTAP_TAPCELL_ROW_4_310 VGND VPWR sky130_fd_sc_hd__tapvpwrvgnd_1
XFILLER_17_417 VPWR VGND VPWR VGND sky130_ef_sc_hd__decap_12
XFILLER_29_288 VGND VGND VPWR VPWR sky130_fd_sc_hd__decap_6
XPHY_EDGE_ROW_11_Right_11 VGND VGND VPWR VPWR sky130_fd_sc_hd__decap_3
XFILLER_13_623 VGND VGND VPWR VPWR sky130_fd_sc_hd__decap_6
XFILLER_16_63 VGND VGND VPWR VPWR sky130_fd_sc_hd__decap_8
XFILLER_16_85 VGND VGND VPWR VPWR sky130_fd_sc_hd__decap_3
XFILLER_25_483 VPWR VGND VPWR VGND sky130_ef_sc_hd__decap_12
XTAP_TAPCELL_ROW_80_1259 VGND VPWR sky130_fd_sc_hd__tapvpwrvgnd_1
XFILLER_52_291 VPWR VGND VPWR VGND sky130_ef_sc_hd__decap_12
XFILLER_12_122 VPWR VGND VPWR VGND sky130_ef_sc_hd__decap_12
XFILLER_40_475 VGND VGND VPWR VPWR sky130_fd_sc_hd__fill_1
XTAP_TAPCELL_ROW_10_389 VGND VPWR sky130_fd_sc_hd__tapvpwrvgnd_1
XFILLER_4_321 VPWR VGND VPWR VGND sky130_ef_sc_hd__decap_12
XFILLER_79_122 VGND VGND VPWR VPWR sky130_fd_sc_hd__decap_3
XFILLER_79_100 VPWR VGND VPWR VGND sky130_ef_sc_hd__decap_12
XFILLER_4_398 VGND VGND VPWR VPWR sky130_fd_sc_hd__fill_1
XPHY_EDGE_ROW_20_Right_20 VGND VGND VPWR VPWR sky130_fd_sc_hd__decap_3
XPHY_EDGE_ROW_26_Left_149 VGND VGND VPWR VPWR sky130_fd_sc_hd__decap_3
XFILLER_95_615 VGND VGND VPWR VPWR sky130_fd_sc_hd__fill_1
XFILLER_79_144 VPWR VGND VPWR VGND sky130_ef_sc_hd__decap_12
XTAP_TAPCELL_ROW_91_1399 VGND VPWR sky130_fd_sc_hd__tapvpwrvgnd_1
XFILLER_0_571 VGND VGND VPWR VPWR sky130_fd_sc_hd__decap_8
XFILLER_48_531 VGND VGND VPWR VPWR sky130_fd_sc_hd__fill_1
XFILLER_57_81 VGND VGND VPWR VPWR sky130_fd_sc_hd__decap_8
XFILLER_35_225 VPWR VGND VPWR VGND sky130_ef_sc_hd__decap_12
XFILLER_63_567 VGND VGND VPWR VPWR sky130_fd_sc_hd__fill_1
X_3960_ _1863_ _1866_ _1872_ _1875_ VGND VGND VPWR VPWR _1876_ sky130_fd_sc_hd__o211ai_2
XPHY_EDGE_ROW_35_Left_158 VGND VGND VPWR VPWR sky130_fd_sc_hd__decap_3
XFILLER_50_206 VGND VGND VPWR VPWR sky130_fd_sc_hd__decap_4
XFILLER_73_91 VGND VGND VPWR VPWR sky130_fd_sc_hd__fill_1
XFILLER_16_461 VGND VGND VPWR VPWR sky130_fd_sc_hd__decap_4
XTAP_TAPCELL_ROW_18_489 VGND VPWR sky130_fd_sc_hd__tapvpwrvgnd_1
XFILLER_31_442 VGND VGND VPWR VPWR sky130_fd_sc_hd__decap_6
X_3891_ reg_file_inst.registry\[10\]\[1\] _1080_ _1088_ VGND VGND VPWR VPWR _1809_
+ sky130_fd_sc_hd__and3_1
XFILLER_85_3 VPWR VGND VPWR VGND sky130_ef_sc_hd__decap_12
X_5630_ net148 VGND VGND VPWR VPWR _0038_ sky130_fd_sc_hd__inv_2
X_5561_ _2501_ reg_file_inst.registry\[9\]\[2\] _3002_ VGND VGND VPWR VPWR _0505_
+ sky130_fd_sc_hd__mux2_1
XFILLER_117_503 VGND VGND VPWR VPWR sky130_fd_sc_hd__fill_1
X_4512_ _2246_ _2306_ _1816_ VGND VGND VPWR VPWR _2395_ sky130_fd_sc_hd__mux2_1
X_5492_ JMPOFF\[13\] _2922_ _3000_ VGND VGND VPWR VPWR _0572_ sky130_fd_sc_hd__mux2_1
XFILLER_105_709 VGND VGND VPWR VPWR sky130_fd_sc_hd__decap_8
XFILLER_8_693 VGND VGND VPWR VPWR sky130_fd_sc_hd__decap_6
X_4443_ net132 _2210_ VGND VGND VPWR VPWR _2328_ sky130_fd_sc_hd__nor2_1
XPHY_EDGE_ROW_44_Left_167 VGND VGND VPWR VPWR sky130_fd_sc_hd__decap_3
XFILLER_98_431 VPWR VGND VPWR VGND sky130_ef_sc_hd__decap_12
X_4374_ _1778_ _2190_ _1840_ VGND VGND VPWR VPWR _2262_ sky130_fd_sc_hd__a21oi_1
XFILLER_98_475 VGND VGND VPWR VPWR sky130_fd_sc_hd__fill_1
X_3325_ reg_file_inst.registry\[2\]\[22\] _1137_ _1139_ reg_file_inst.registry\[5\]\[22\]
+ VGND VGND VPWR VPWR _1264_ sky130_fd_sc_hd__a22o_1
X_6113_ clknet_leaf_19_clk _0521_ _0046_ VGND VGND VPWR VPWR reg_file_inst.registry\[9\]\[18\]
+ sky130_fd_sc_hd__dfrtp_1
XFILLER_86_637 VGND VGND VPWR VPWR sky130_fd_sc_hd__decap_6
X_6044_ net146 VGND VGND VPWR VPWR _0452_ sky130_fd_sc_hd__inv_2
X_3256_ _1185_ _1194_ VGND VGND VPWR VPWR _1197_ sky130_fd_sc_hd__xnor2_1
XFILLER_85_158 VGND VGND VPWR VPWR sky130_fd_sc_hd__decap_3
XTAP_TAPCELL_ROW_107_1605 VGND VPWR sky130_fd_sc_hd__tapvpwrvgnd_1
XFILLER_94_681 VPWR VGND VPWR VGND sky130_ef_sc_hd__decap_12
X_3187_ net144 _1127_ VGND VGND VPWR VPWR _1131_ sky130_fd_sc_hd__and2_4
XFILLER_85_169 VPWR VGND VPWR VGND sky130_ef_sc_hd__decap_12
XPHY_EDGE_ROW_53_Left_176 VGND VGND VPWR VPWR sky130_fd_sc_hd__decap_3
XFILLER_26_236 VGND VGND VPWR VPWR sky130_fd_sc_hd__decap_6
XTAP_TAPCELL_ROW_37_721 VGND VPWR sky130_fd_sc_hd__tapvpwrvgnd_1
XTAP_TAPCELL_ROW_37_732 VGND VPWR sky130_fd_sc_hd__tapvpwrvgnd_1
XTAP_TAPCELL_ROW_66_1092 VGND VPWR sky130_fd_sc_hd__tapvpwrvgnd_1
XFILLER_22_453 VGND VGND VPWR VPWR sky130_fd_sc_hd__decap_8
XFILLER_34_291 VPWR VGND VPWR VGND sky130_ef_sc_hd__decap_12
X_5828_ net147 VGND VGND VPWR VPWR _0236_ sky130_fd_sc_hd__inv_2
XFILLER_22_475 VGND VGND VPWR VPWR sky130_fd_sc_hd__fill_1
X_5759_ net44 VGND VGND VPWR VPWR _0167_ sky130_fd_sc_hd__inv_2
XFILLER_10_637 VGND VGND VPWR VPWR sky130_fd_sc_hd__decap_6
XTAP_TAPCELL_ROW_118_1745 VGND VPWR sky130_fd_sc_hd__tapvpwrvgnd_1
XTAP_TAPCELL_ROW_118_1734 VGND VPWR sky130_fd_sc_hd__tapvpwrvgnd_1
XFILLER_108_525 VGND VGND VPWR VPWR sky130_fd_sc_hd__decap_6
XFILLER_108_569 VPWR VGND VPWR VGND sky130_ef_sc_hd__decap_12
XPHY_EDGE_ROW_62_Left_185 VGND VGND VPWR VPWR sky130_fd_sc_hd__decap_3
XFILLER_118_65 VPWR VGND VPWR VGND sky130_ef_sc_hd__decap_12
XFILLER_77_615 VGND VGND VPWR VPWR sky130_fd_sc_hd__fill_1
XFILLER_1_335 VGND VGND VPWR VPWR sky130_fd_sc_hd__fill_1
XFILLER_1_368 VGND VGND VPWR VPWR sky130_fd_sc_hd__decap_8
XFILLER_49_306 VPWR VGND VPWR VGND sky130_ef_sc_hd__decap_12
XFILLER_89_486 VPWR VGND VPWR VGND sky130_ef_sc_hd__decap_12
XFILLER_76_125 VGND VGND VPWR VPWR sky130_fd_sc_hd__decap_4
XFILLER_94_57 VGND VGND VPWR VPWR sky130_fd_sc_hd__decap_8
XPHY_EDGE_ROW_71_Left_194 VGND VGND VPWR VPWR sky130_fd_sc_hd__decap_3
XFILLER_17_225 VGND VGND VPWR VPWR sky130_fd_sc_hd__decap_8
XFILLER_17_269 VGND VGND VPWR VPWR sky130_fd_sc_hd__fill_1
XFILLER_27_95 VPWR VGND VPWR VGND sky130_ef_sc_hd__decap_12
XFILLER_45_556 VGND VGND VPWR VPWR sky130_fd_sc_hd__decap_4
XTAP_TAPCELL_ROW_15_448 VGND VPWR sky130_fd_sc_hd__tapvpwrvgnd_1
XFILLER_13_453 VGND VGND VPWR VPWR sky130_fd_sc_hd__fill_1
XFILLER_40_250 VGND VGND VPWR VPWR sky130_fd_sc_hd__fill_2
XFILLER_43_72 VGND VGND VPWR VPWR sky130_fd_sc_hd__decap_4
XFILLER_43_83 VGND VGND VPWR VPWR sky130_fd_sc_hd__decap_3
XFILLER_5_641 VPWR VGND VPWR VGND sky130_ef_sc_hd__decap_12
XTAP_TAPCELL_ROW_93_1428 VGND VPWR sky130_fd_sc_hd__tapvpwrvgnd_1
XFILLER_5_685 VPWR VGND VPWR VGND sky130_ef_sc_hd__decap_12
XFILLER_4_162 VGND VGND VPWR VPWR sky130_fd_sc_hd__fill_2
XFILLER_110_701 VPWR VGND VPWR VGND sky130_ef_sc_hd__decap_12
XFILLER_4_195 VGND VGND VPWR VPWR sky130_fd_sc_hd__fill_1
XFILLER_4_77 VGND VGND VPWR VPWR sky130_fd_sc_hd__decap_6
XFILLER_122_561 VPWR VGND VPWR VGND sky130_ef_sc_hd__decap_12
XFILLER_67_103 VGND VGND VPWR VPWR sky130_fd_sc_hd__decap_8
X_3110_ JMPOFF\[9\] JMPOFF\[8\] _0967_ VGND VGND VPWR VPWR _1054_ sky130_fd_sc_hd__o21ai_1
XFILLER_67_125 VPWR VGND VPWR VGND sky130_ef_sc_hd__decap_12
X_4090_ _0973_ _1062_ _1066_ VGND VGND VPWR VPWR _2006_ sky130_fd_sc_hd__a21o_1
X_3041_ JMPOFF\[21\] net141 net41 VGND VGND VPWR VPWR _0985_ sky130_fd_sc_hd__a21oi_1
XFILLER_67_169 VPWR VGND VPWR VGND sky130_ef_sc_hd__decap_12
XFILLER_36_512 VGND VGND VPWR VPWR sky130_fd_sc_hd__decap_6
XFILLER_76_692 VGND VGND VPWR VPWR sky130_fd_sc_hd__decap_8
XFILLER_91_673 VPWR VGND VPWR VGND sky130_ef_sc_hd__decap_12
XFILLER_90_161 VPWR VGND VPWR VGND sky130_ef_sc_hd__decap_12
X_4992_ _1321_ _2286_ _2124_ _1307_ VGND VGND VPWR VPWR _2837_ sky130_fd_sc_hd__o2bb2a_1
XFILLER_36_589 VGND VGND VPWR VPWR sky130_fd_sc_hd__fill_1
XTAP_TAPCELL_ROW_102_1535 VGND VPWR sky130_fd_sc_hd__tapvpwrvgnd_1
XFILLER_51_559 VGND VGND VPWR VPWR sky130_fd_sc_hd__fill_1
X_3943_ _1669_ _1680_ _1692_ _1667_ _1653_ VGND VGND VPWR VPWR _1859_ sky130_fd_sc_hd__o32a_1
XFILLER_31_261 VGND VGND VPWR VPWR sky130_fd_sc_hd__decap_6
X_3874_ reg_file_inst.registry\[10\]\[2\] _1123_ net143 VGND VGND VPWR VPWR _1793_
+ sky130_fd_sc_hd__and3_1
Xclkbuf_3_2__f_clk clknet_0_clk VGND VGND VPWR VPWR clknet_3_2__leaf_clk sky130_fd_sc_hd__clkbuf_16
X_5613_ net146 VGND VGND VPWR VPWR _0021_ sky130_fd_sc_hd__inv_2
XFILLER_31_272 VGND VGND VPWR VPWR sky130_fd_sc_hd__decap_8
XTAP_TAPCELL_ROW_42_790 VGND VPWR sky130_fd_sc_hd__tapvpwrvgnd_1
X_5544_ _2854_ reg_file_inst.registry\[9\]\[19\] _3002_ VGND VGND VPWR VPWR _0522_
+ sky130_fd_sc_hd__mux2_1
XFILLER_105_517 VPWR VGND VPWR VGND sky130_ef_sc_hd__decap_12
X_5475_ reg_file_inst.registry\[5\]\[1\] _2528_ _2999_ VGND VGND VPWR VPWR _0588_
+ sky130_fd_sc_hd__mux2_1
X_4426_ reg_file_inst.registry\[11\]\[7\] _2311_ _2122_ VGND VGND VPWR VPWR _0922_
+ sky130_fd_sc_hd__mux2_1
XTAP_TAPCELL_ROW_113_1675 VGND VPWR sky130_fd_sc_hd__tapvpwrvgnd_1
XFILLER_113_561 VPWR VGND VPWR VGND sky130_ef_sc_hd__decap_12
X_4357_ _1790_ _2191_ VGND VGND VPWR VPWR _2245_ sky130_fd_sc_hd__or2_1
XFILLER_48_39 VGND VGND VPWR VPWR sky130_fd_sc_hd__decap_4
X_3308_ reg_file_inst.registry\[1\]\[22\] _1087_ _1090_ reg_file_inst.registry\[8\]\[22\]
+ VGND VGND VPWR VPWR _1247_ sky130_fd_sc_hd__a22o_1
X_4288_ _2112_ _2125_ _2127_ _1113_ VGND VGND VPWR VPWR _2176_ sky130_fd_sc_hd__o211ai_4
X_3239_ reg_file_inst.registry\[2\]\[25\] _1083_ _1096_ reg_file_inst.registry\[11\]\[25\]
+ VGND VGND VPWR VPWR _1181_ sky130_fd_sc_hd__a22o_1
X_6027_ net148 VGND VGND VPWR VPWR _0435_ sky130_fd_sc_hd__inv_2
XTAP_TAPCELL_ROW_68_1110 VGND VPWR sky130_fd_sc_hd__tapvpwrvgnd_1
XFILLER_64_27 VGND VGND VPWR VPWR sky130_fd_sc_hd__fill_1
XFILLER_27_545 VGND VGND VPWR VPWR sky130_fd_sc_hd__decap_6
XFILLER_14_228 VGND VGND VPWR VPWR sky130_fd_sc_hd__decap_4
XFILLER_120_77 VGND VGND VPWR VPWR sky130_fd_sc_hd__decap_6
XTAP_TAPCELL_ROW_12_418 VGND VPWR sky130_fd_sc_hd__tapvpwrvgnd_1
XFILLER_22_272 VGND VGND VPWR VPWR sky130_fd_sc_hd__decap_3
XFILLER_6_427 VPWR VGND VPWR VGND sky130_ef_sc_hd__decap_12
XFILLER_108_333 VPWR VGND VPWR VGND sky130_ef_sc_hd__decap_12
XTAP_TAPCELL_ROW_79_1250 VGND VPWR sky130_fd_sc_hd__tapvpwrvgnd_1
XFILLER_108_377 VPWR VGND VPWR VGND sky130_ef_sc_hd__decap_12
XFILLER_89_57 VPWR VGND VPWR VGND sky130_ef_sc_hd__decap_12
XFILLER_2_699 VGND VGND VPWR VPWR sky130_fd_sc_hd__fill_1
XFILLER_49_125 VGND VGND VPWR VPWR sky130_fd_sc_hd__decap_3
XFILLER_92_404 VGND VGND VPWR VPWR sky130_fd_sc_hd__fill_1
XFILLER_18_501 VGND VGND VPWR VPWR sky130_fd_sc_hd__decap_4
XFILLER_49_169 VPWR VGND VPWR VGND sky130_ef_sc_hd__decap_12
XFILLER_64_139 VGND VGND VPWR VPWR sky130_fd_sc_hd__fill_1
XFILLER_45_320 VGND VGND VPWR VPWR sky130_fd_sc_hd__decap_4
XFILLER_18_556 VPWR VGND VPWR VGND sky130_ef_sc_hd__decap_12
XFILLER_73_673 VGND VGND VPWR VPWR sky130_fd_sc_hd__decap_8
XFILLER_18_589 VPWR VGND VPWR VGND sky130_ef_sc_hd__decap_12
XFILLER_72_183 VPWR VGND VPWR VGND sky130_ef_sc_hd__decap_12
XFILLER_54_93 VGND VGND VPWR VPWR sky130_fd_sc_hd__decap_8
XFILLER_54_71 VPWR VGND VPWR VGND sky130_ef_sc_hd__decap_12
XPHY_EDGE_ROW_109_Left_232 VGND VGND VPWR VPWR sky130_fd_sc_hd__decap_3
XFILLER_41_570 VGND VGND VPWR VPWR sky130_fd_sc_hd__decap_6
XFILLER_119_609 VGND VGND VPWR VPWR sky130_fd_sc_hd__decap_6
XFILLER_9_210 VGND VGND VPWR VPWR sky130_fd_sc_hd__fill_1
Xclkload24 clknet_leaf_18_clk VGND VGND VPWR VPWR clkload24/Y sky130_fd_sc_hd__clkinv_2
Xclkload13 clknet_leaf_5_clk VGND VGND VPWR VPWR clkload13/Y sky130_fd_sc_hd__clkinv_2
X_3590_ _1504_ _1515_ VGND VGND VPWR VPWR _1518_ sky130_fd_sc_hd__xnor2_1
Xclkload35 clknet_leaf_55_clk VGND VGND VPWR VPWR clkload35/X sky130_fd_sc_hd__clkbuf_4
Xclkload46 clknet_leaf_28_clk VGND VGND VPWR VPWR clkload46/Y sky130_fd_sc_hd__inv_6
Xclkload57 clknet_leaf_40_clk VGND VGND VPWR VPWR clkload57/Y sky130_fd_sc_hd__inv_8
X_5260_ reg_file_inst.registry\[14\]\[13\] _2922_ _2992_ VGND VGND VPWR VPWR _0796_
+ sky130_fd_sc_hd__mux2_1
XPHY_EDGE_ROW_118_Left_241 VGND VGND VPWR VPWR sky130_fd_sc_hd__decap_3
X_4211_ _1969_ _2104_ VGND VGND VPWR VPWR _2105_ sky130_fd_sc_hd__nor2_1
X_5191_ _2909_ reg_file_inst.registry\[0\]\[14\] _2988_ VGND VGND VPWR VPWR _0861_
+ sky130_fd_sc_hd__mux2_1
XFILLER_110_531 VGND VGND VPWR VPWR sky130_fd_sc_hd__fill_1
X_4142_ _0970_ _1072_ _0971_ _0968_ VGND VGND VPWR VPWR _2058_ sky130_fd_sc_hd__o211a_1
XFILLER_68_445 VPWR VGND VPWR VGND sky130_ef_sc_hd__decap_12
XFILLER_28_309 VPWR VGND VPWR VGND sky130_ef_sc_hd__decap_12
X_4073_ net103 _1984_ _1988_ VGND VGND VPWR VPWR _1989_ sky130_fd_sc_hd__o21ai_1
X_3024_ JMPOFF\[25\] _0967_ VGND VGND VPWR VPWR _0968_ sky130_fd_sc_hd__nand2_1
XFILLER_36_353 VGND VGND VPWR VPWR sky130_fd_sc_hd__decap_8
XFILLER_70_109 VGND VGND VPWR VPWR sky130_fd_sc_hd__decap_8
XFILLER_63_161 VGND VGND VPWR VPWR sky130_fd_sc_hd__decap_6
X_4975_ _1790_ _2759_ VGND VGND VPWR VPWR _2822_ sky130_fd_sc_hd__or2_1
XTAP_TAPCELL_ROW_63_1051 VGND VPWR sky130_fd_sc_hd__tapvpwrvgnd_1
XFILLER_51_389 VGND VGND VPWR VPWR sky130_fd_sc_hd__decap_3
XFILLER_51_367 VGND VGND VPWR VPWR sky130_fd_sc_hd__fill_1
X_3926_ reg_file_inst.registry\[2\]\[0\] _1116_ _1123_ VGND VGND VPWR VPWR _1843_
+ sky130_fd_sc_hd__and3_1
Xclkload7 clknet_leaf_3_clk VGND VGND VPWR VPWR clkload7/Y sky130_fd_sc_hd__clkinvlp_4
XFILLER_50_29 VGND VGND VPWR VPWR sky130_fd_sc_hd__fill_1
X_3857_ reg_file_inst.registry\[2\]\[3\] _1137_ _1772_ _1775_ _1776_ VGND VGND VPWR
+ VPWR _1777_ sky130_fd_sc_hd__a2111o_1
X_3788_ reg_file_inst.registry\[15\]\[4\] _1122_ _1129_ MEMOFF\[4\] VGND VGND VPWR
+ VPWR _1710_ sky130_fd_sc_hd__a22o_1
XTAP_TAPCELL_ROW_115_1704 VGND VPWR sky130_fd_sc_hd__tapvpwrvgnd_1
X_5527_ reg_file_inst.registry\[6\]\[7\] _2311_ _3001_ VGND VGND VPWR VPWR _0538_
+ sky130_fd_sc_hd__mux2_1
X_5458_ reg_file_inst.registry\[5\]\[18\] _2863_ _2999_ VGND VGND VPWR VPWR _0605_
+ sky130_fd_sc_hd__mux2_1
XFILLER_87_721 VGND VGND VPWR VPWR sky130_fd_sc_hd__decap_4
XTAP_TAPCELL_ROW_74_1191 VGND VPWR sky130_fd_sc_hd__tapvpwrvgnd_1
X_4409_ _1709_ _2295_ VGND VGND VPWR VPWR _2297_ sky130_fd_sc_hd__nand2_2
X_5389_ MEMOFF\[0\] _2550_ _2996_ VGND VGND VPWR VPWR _0671_ sky130_fd_sc_hd__mux2_1
XFILLER_115_55 VGND VGND VPWR VPWR sky130_fd_sc_hd__fill_1
XFILLER_113_391 VGND VGND VPWR VPWR sky130_fd_sc_hd__fill_1
XFILLER_101_553 VGND VGND VPWR VPWR sky130_fd_sc_hd__decap_6
XFILLER_86_253 VGND VGND VPWR VPWR sky130_fd_sc_hd__decap_3
XFILLER_47_629 VPWR VGND VPWR VGND sky130_ef_sc_hd__decap_12
XFILLER_101_597 VPWR VGND VPWR VGND sky130_ef_sc_hd__decap_12
XFILLER_86_286 VGND VGND VPWR VPWR sky130_fd_sc_hd__decap_6
XFILLER_74_448 VPWR VGND VPWR VGND sky130_ef_sc_hd__decap_12
XFILLER_55_640 VGND VGND VPWR VPWR sky130_fd_sc_hd__decap_3
XFILLER_27_331 VGND VGND VPWR VPWR sky130_fd_sc_hd__decap_4
XFILLER_39_191 VPWR VGND VPWR VGND sky130_ef_sc_hd__decap_12
XFILLER_27_375 VPWR VGND VPWR VGND sky130_ef_sc_hd__decap_12
XFILLER_54_194 VGND VGND VPWR VPWR sky130_fd_sc_hd__fill_2
XFILLER_15_559 VGND VGND VPWR VPWR sky130_fd_sc_hd__fill_1
XFILLER_70_687 VPWR VGND VPWR VGND sky130_ef_sc_hd__decap_12
XTAP_TAPCELL_ROW_25_576 VGND VPWR sky130_fd_sc_hd__tapvpwrvgnd_1
XFILLER_42_356 VGND VGND VPWR VPWR sky130_fd_sc_hd__decap_8
XFILLER_42_378 VPWR VGND VPWR VGND sky130_ef_sc_hd__decap_12
XFILLER_7_725 VGND VGND VPWR VPWR sky130_fd_sc_hd__fill_1
XFILLER_6_213 VGND VGND VPWR VPWR sky130_fd_sc_hd__decap_6
XFILLER_109_653 VPWR VGND VPWR VGND sky130_ef_sc_hd__decap_12
XFILLER_108_141 VPWR VGND VPWR VGND sky130_ef_sc_hd__decap_12
XFILLER_109_697 VPWR VGND VPWR VGND sky130_ef_sc_hd__decap_12
XFILLER_6_279 VPWR VGND VPWR VGND sky130_ef_sc_hd__decap_12
XFILLER_2_430 VGND VGND VPWR VPWR sky130_fd_sc_hd__decap_4
XFILLER_111_317 VPWR VGND VPWR VGND sky130_ef_sc_hd__decap_12
XFILLER_2_485 VGND VGND VPWR VPWR sky130_fd_sc_hd__fill_1
XFILLER_65_426 VPWR VGND VPWR VGND sky130_ef_sc_hd__decap_12
XFILLER_61_665 VGND VGND VPWR VPWR sky130_fd_sc_hd__decap_6
XFILLER_60_164 VPWR VGND VPWR VGND sky130_ef_sc_hd__decap_12
XFILLER_60_197 VPWR VGND VPWR VGND sky130_ef_sc_hd__decap_12
X_4760_ _2135_ _2178_ _2618_ VGND VGND VPWR VPWR _2619_ sky130_fd_sc_hd__o21bai_2
XFILLER_119_417 VPWR VGND VPWR VGND sky130_ef_sc_hd__decap_12
XPHY_EDGE_ROW_112_Right_112 VGND VGND VPWR VPWR sky130_fd_sc_hd__decap_3
X_4691_ reg_file_inst.registry\[11\]\[25\] _2528_ _2551_ VGND VGND VPWR VPWR _0904_
+ sky130_fd_sc_hd__mux2_1
X_3711_ _1244_ _1256_ _1267_ _1634_ VGND VGND VPWR VPWR _1635_ sky130_fd_sc_hd__o31a_1
X_6430_ clknet_leaf_18_clk _0838_ _0363_ VGND VGND VPWR VPWR reg_file_inst.registry\[1\]\[27\]
+ sky130_fd_sc_hd__dfrtp_1
X_3642_ _1552_ _1566_ VGND VGND VPWR VPWR _1568_ sky130_fd_sc_hd__xor2_1
X_6361_ clknet_leaf_12_clk _0769_ _0294_ VGND VGND VPWR VPWR reg_file_inst.registry\[2\]\[14\]
+ sky130_fd_sc_hd__dfrtp_1
X_5312_ _2854_ reg_file_inst.registry\[8\]\[19\] _2994_ VGND VGND VPWR VPWR _0746_
+ sky130_fd_sc_hd__mux2_1
X_3573_ reg_file_inst.registry\[6\]\[14\] _1094_ _1500_ _1501_ VGND VGND VPWR VPWR
+ _1502_ sky130_fd_sc_hd__a211o_1
XPHY_EDGE_ROW_49_Right_49 VGND VGND VPWR VPWR sky130_fd_sc_hd__decap_3
XFILLER_114_133 VGND VGND VPWR VPWR sky130_fd_sc_hd__decap_6
X_6292_ clknet_leaf_57_clk _0700_ _0225_ VGND VGND VPWR VPWR reg_file_inst.registry\[3\]\[1\]
+ sky130_fd_sc_hd__dfrtp_1
XFILLER_114_177 VPWR VGND VPWR VGND sky130_ef_sc_hd__decap_12
XFILLER_69_721 VGND VGND VPWR VPWR sky130_fd_sc_hd__fill_2
X_5243_ _2550_ reg_file_inst.registry\[1\]\[0\] _2990_ VGND VGND VPWR VPWR _0811_
+ sky130_fd_sc_hd__mux2_1
XTAP_TAPCELL_ROW_110_1645 VGND VPWR sky130_fd_sc_hd__tapvpwrvgnd_1
XTAP_TAPCELL_ROW_110_1634 VGND VPWR sky130_fd_sc_hd__tapvpwrvgnd_1
XFILLER_68_220 VPWR VGND VPWR VGND sky130_ef_sc_hd__decap_12
X_5174_ reg_file_inst.registry\[7\]\[1\] _2528_ _2553_ VGND VGND VPWR VPWR _0876_
+ sky130_fd_sc_hd__mux2_1
XFILLER_96_573 VPWR VGND VPWR VGND sky130_ef_sc_hd__decap_12
XFILLER_84_713 VPWR VGND VPWR VGND sky130_ef_sc_hd__decap_12
X_4125_ net131 _2039_ _2040_ VGND VGND VPWR VPWR _2041_ sky130_fd_sc_hd__and3_1
XFILLER_68_253 VPWR VGND VPWR VGND sky130_ef_sc_hd__decap_12
XFILLER_29_629 VPWR VGND VPWR VGND sky130_ef_sc_hd__decap_12
XFILLER_83_267 VGND VGND VPWR VPWR sky130_fd_sc_hd__decap_8
XPHY_EDGE_ROW_58_Right_58 VGND VGND VPWR VPWR sky130_fd_sc_hd__decap_3
X_4056_ _1940_ _1944_ VGND VGND VPWR VPWR _1972_ sky130_fd_sc_hd__nand2_1
X_3007_ net125 VGND VGND VPWR VPWR _0953_ sky130_fd_sc_hd__inv_2
XFILLER_36_150 VGND VGND VPWR VPWR sky130_fd_sc_hd__decap_3
XFILLER_36_161 VPWR VGND VPWR VGND sky130_ef_sc_hd__decap_12
XFILLER_52_643 VGND VGND VPWR VPWR sky130_fd_sc_hd__fill_1
XFILLER_51_120 VGND VGND VPWR VPWR sky130_fd_sc_hd__decap_8
XFILLER_101_57 VPWR VGND VPWR VGND sky130_ef_sc_hd__decap_12
XTAP_TAPCELL_ROW_121_1774 VGND VPWR sky130_fd_sc_hd__tapvpwrvgnd_1
X_4958_ _2583_ _2790_ VGND VGND VPWR VPWR _2807_ sky130_fd_sc_hd__xnor2_1
X_4889_ _2495_ _2745_ net137 VGND VGND VPWR VPWR _2746_ sky130_fd_sc_hd__mux2_1
XTAP_TAPCELL_ROW_22_535 VGND VPWR sky130_fd_sc_hd__tapvpwrvgnd_1
X_3909_ MEMOFF\[1\] net84 _1113_ VGND VGND VPWR VPWR _1826_ sky130_fd_sc_hd__mux2_2
XTAP_TAPCELL_ROW_50_888 VGND VPWR sky130_fd_sc_hd__tapvpwrvgnd_1
XFILLER_106_601 VPWR VGND VPWR VGND sky130_ef_sc_hd__decap_12
XPHY_EDGE_ROW_67_Right_67 VGND VGND VPWR VPWR sky130_fd_sc_hd__decap_3
XTAP_TAPCELL_ROW_76_1220 VGND VPWR sky130_fd_sc_hd__tapvpwrvgnd_1
XFILLER_106_645 VPWR VGND VPWR VGND sky130_ef_sc_hd__decap_12
XFILLER_105_111 VGND VGND VPWR VPWR sky130_fd_sc_hd__fill_1
XFILLER_121_615 VGND VGND VPWR VPWR sky130_fd_sc_hd__fill_1
XFILLER_79_518 VGND VGND VPWR VPWR sky130_fd_sc_hd__decap_3
XFILLER_10_65 VGND VGND VPWR VPWR sky130_fd_sc_hd__decap_4
XFILLER_101_350 VGND VGND VPWR VPWR sky130_fd_sc_hd__fill_1
XFILLER_86_58 VGND VGND VPWR VPWR sky130_fd_sc_hd__fill_1
XFILLER_47_404 VGND VGND VPWR VPWR sky130_fd_sc_hd__fill_1
XPHY_EDGE_ROW_76_Right_76 VGND VGND VPWR VPWR sky130_fd_sc_hd__decap_3
XFILLER_19_139 VGND VGND VPWR VPWR sky130_fd_sc_hd__decap_3
XFILLER_74_267 VPWR VGND VPWR VGND sky130_ef_sc_hd__decap_12
XTAP_TAPCELL_ROW_58_988 VGND VPWR sky130_fd_sc_hd__tapvpwrvgnd_1
XFILLER_55_470 VGND VGND VPWR VPWR sky130_fd_sc_hd__decap_4
XTAP_TAPCELL_ROW_2_293 VGND VPWR sky130_fd_sc_hd__tapvpwrvgnd_1
XFILLER_15_312 VPWR VGND VPWR VGND sky130_ef_sc_hd__decap_12
XFILLER_42_153 VPWR VGND VPWR VGND sky130_ef_sc_hd__decap_12
XFILLER_42_197 VGND VGND VPWR VPWR sky130_fd_sc_hd__decap_4
XPHY_EDGE_ROW_85_Right_85 VGND VGND VPWR VPWR sky130_fd_sc_hd__decap_3
XFILLER_11_573 VPWR VGND VPWR VGND sky130_ef_sc_hd__decap_12
XFILLER_109_461 VPWR VGND VPWR VGND sky130_ef_sc_hd__decap_12
XFILLER_112_637 VGND VGND VPWR VPWR sky130_fd_sc_hd__decap_6
XFILLER_111_125 VPWR VGND VPWR VGND sky130_ef_sc_hd__decap_12
XFILLER_97_348 VGND VGND VPWR VPWR sky130_fd_sc_hd__decap_6
XFILLER_32_6 VPWR VGND VPWR VGND sky130_ef_sc_hd__decap_12
XFILLER_111_169 VPWR VGND VPWR VGND sky130_ef_sc_hd__decap_12
XPHY_EDGE_ROW_94_Right_94 VGND VGND VPWR VPWR sky130_fd_sc_hd__decap_3
XFILLER_66_713 VPWR VGND VPWR VGND sky130_ef_sc_hd__decap_12
XFILLER_120_681 VPWR VGND VPWR VGND sky130_ef_sc_hd__decap_12
XFILLER_78_584 VGND VGND VPWR VPWR sky130_fd_sc_hd__decap_4
XFILLER_65_223 VGND VGND VPWR VPWR sky130_fd_sc_hd__fill_1
XFILLER_19_640 VPWR VGND VPWR VGND sky130_ef_sc_hd__decap_12
XFILLER_65_278 VGND VGND VPWR VPWR sky130_fd_sc_hd__fill_2
X_5930_ net147 VGND VGND VPWR VPWR _0338_ sky130_fd_sc_hd__inv_2
XFILLER_34_643 VGND VGND VPWR VPWR sky130_fd_sc_hd__fill_1
XFILLER_46_481 VGND VGND VPWR VPWR sky130_fd_sc_hd__fill_1
X_5861_ net147 VGND VGND VPWR VPWR _0269_ sky130_fd_sc_hd__inv_2
XFILLER_33_142 VPWR VGND VPWR VGND sky130_ef_sc_hd__decap_12
XFILLER_34_676 VGND VGND VPWR VPWR sky130_fd_sc_hd__fill_2
XFILLER_61_473 VGND VGND VPWR VPWR sky130_fd_sc_hd__decap_8
XTAP_TAPCELL_ROW_60_1010 VGND VPWR sky130_fd_sc_hd__tapvpwrvgnd_1
X_4812_ _1345_ _2657_ _2670_ VGND VGND VPWR VPWR _2671_ sky130_fd_sc_hd__o21a_1
X_5792_ net149 VGND VGND VPWR VPWR _0200_ sky130_fd_sc_hd__inv_2
X_4743_ _1529_ _2601_ VGND VGND VPWR VPWR _2602_ sky130_fd_sc_hd__xnor2_1
XFILLER_119_225 VPWR VGND VPWR VGND sky130_ef_sc_hd__decap_12
X_6413_ clknet_leaf_26_clk _0821_ _0346_ VGND VGND VPWR VPWR reg_file_inst.registry\[1\]\[10\]
+ sky130_fd_sc_hd__dfrtp_1
X_4674_ _2546_ VGND VGND VPWR VPWR _2547_ sky130_fd_sc_hd__inv_2
X_3625_ reg_file_inst.registry\[0\]\[10\] net138 _1545_ _1551_ VGND VGND VPWR VPWR
+ _1552_ sky130_fd_sc_hd__o22ai_4
X_6344_ clknet_leaf_22_clk _0752_ _0277_ VGND VGND VPWR VPWR reg_file_inst.registry\[8\]\[25\]
+ sky130_fd_sc_hd__dfrtp_1
X_3556_ reg_file_inst.registry\[15\]\[15\] _1122_ _1130_ JMPOFF\[15\] VGND VGND VPWR
+ VPWR _1486_ sky130_fd_sc_hd__a22o_1
XFILLER_1_709 VPWR VGND VPWR VGND sky130_ef_sc_hd__decap_12
XFILLER_103_615 VGND VGND VPWR VPWR sky130_fd_sc_hd__fill_1
XFILLER_0_219 VGND VGND VPWR VPWR sky130_fd_sc_hd__decap_4
X_6275_ clknet_leaf_2_clk _0683_ _0208_ VGND VGND VPWR VPWR MEMOFF\[12\] sky130_fd_sc_hd__dfrtp_1
XFILLER_115_497 VGND VGND VPWR VPWR sky130_fd_sc_hd__decap_6
X_5226_ _2873_ reg_file_inst.registry\[1\]\[17\] _2990_ VGND VGND VPWR VPWR _0828_
+ sky130_fd_sc_hd__mux2_1
X_3487_ _1404_ _1417_ VGND VGND VPWR VPWR _1419_ sky130_fd_sc_hd__xnor2_1
XFILLER_102_158 VGND VGND VPWR VPWR sky130_fd_sc_hd__decap_6
XTAP_TAPCELL_ROW_71_1150 VGND VPWR sky130_fd_sc_hd__tapvpwrvgnd_1
XFILLER_69_573 VGND VGND VPWR VPWR sky130_fd_sc_hd__decap_6
X_5157_ _2977_ VGND VGND VPWR VPWR _2978_ sky130_fd_sc_hd__inv_2
X_4108_ _0986_ _2023_ VGND VGND VPWR VPWR _2024_ sky130_fd_sc_hd__or2_1
XFILLER_56_223 VPWR VGND VPWR VGND sky130_ef_sc_hd__decap_12
X_5088_ _2296_ _2912_ _2918_ VGND VGND VPWR VPWR _2919_ sky130_fd_sc_hd__a21o_1
X_4039_ net122 _1878_ _1954_ VGND VGND VPWR VPWR _1955_ sky130_fd_sc_hd__and3_1
XTAP_TAPCELL_ROW_27_605 VGND VPWR sky130_fd_sc_hd__tapvpwrvgnd_1
XFILLER_44_407 VGND VGND VPWR VPWR sky130_fd_sc_hd__decap_4
XFILLER_44_418 VGND VGND VPWR VPWR sky130_fd_sc_hd__fill_2
XTAP_TAPCELL_ROW_55_947 VGND VPWR sky130_fd_sc_hd__tapvpwrvgnd_1
XFILLER_72_27 VGND VGND VPWR VPWR sky130_fd_sc_hd__fill_1
XFILLER_25_654 VPWR VGND VPWR VGND sky130_ef_sc_hd__decap_12
XFILLER_24_186 VGND VGND VPWR VPWR sky130_fd_sc_hd__decap_8
XTAP_TAPCELL_ROW_82_1290 VGND VPWR sky130_fd_sc_hd__tapvpwrvgnd_1
XFILLER_12_337 VPWR VGND VPWR VGND sky130_ef_sc_hd__decap_12
XFILLER_24_197 VPWR VGND VPWR VGND sky130_ef_sc_hd__decap_12
XFILLER_40_657 VGND VGND VPWR VPWR sky130_fd_sc_hd__decap_8
XFILLER_40_679 VGND VGND VPWR VPWR sky130_fd_sc_hd__decap_6
XFILLER_115_3 VPWR VGND VPWR VGND sky130_ef_sc_hd__decap_12
XFILLER_106_475 VGND VGND VPWR VPWR sky130_fd_sc_hd__fill_1
XFILLER_4_569 VPWR VGND VPWR VGND sky130_ef_sc_hd__decap_12
XFILLER_97_57 VGND VGND VPWR VPWR sky130_fd_sc_hd__decap_3
XFILLER_79_337 VPWR VGND VPWR VGND sky130_ef_sc_hd__decap_12
XTAP_TAPCELL_ROW_7_352 VGND VPWR sky130_fd_sc_hd__tapvpwrvgnd_1
XFILLER_102_681 VPWR VGND VPWR VGND sky130_ef_sc_hd__decap_12
XFILLER_63_705 VPWR VGND VPWR VGND sky130_ef_sc_hd__decap_12
XFILLER_47_223 VGND VGND VPWR VPWR sky130_fd_sc_hd__fill_1
XFILLER_47_245 VGND VGND VPWR VPWR sky130_fd_sc_hd__decap_3
XFILLER_75_598 VPWR VGND VPWR VGND sky130_ef_sc_hd__decap_12
XFILLER_75_587 VGND VGND VPWR VPWR sky130_fd_sc_hd__fill_2
XFILLER_47_267 VPWR VGND VPWR VGND sky130_ef_sc_hd__decap_12
XFILLER_16_665 VGND VGND VPWR VPWR sky130_fd_sc_hd__decap_8
XFILLER_16_698 VGND VGND VPWR VPWR sky130_fd_sc_hd__fill_2
XFILLER_43_473 VGND VGND VPWR VPWR sky130_fd_sc_hd__decap_4
XFILLER_31_679 VGND VGND VPWR VPWR sky130_fd_sc_hd__fill_1
XFILLER_11_381 VGND VGND VPWR VPWR sky130_fd_sc_hd__decap_8
XFILLER_7_341 VGND VGND VPWR VPWR sky130_fd_sc_hd__fill_1
XFILLER_7_55 VGND VGND VPWR VPWR sky130_fd_sc_hd__fill_1
XTAP_TAPCELL_ROW_96_1459 VGND VPWR sky130_fd_sc_hd__tapvpwrvgnd_1
XFILLER_7_363 VGND VGND VPWR VPWR sky130_fd_sc_hd__decap_8
X_3410_ MEMOFF\[19\] net83 _1113_ VGND VGND VPWR VPWR _1345_ sky130_fd_sc_hd__mux2_4
X_4390_ _2129_ _2276_ VGND VGND VPWR VPWR _2278_ sky130_fd_sc_hd__or2_4
XFILLER_112_401 VPWR VGND VPWR VGND sky130_ef_sc_hd__decap_12
XFILLER_98_613 VPWR VGND VPWR VGND sky130_ef_sc_hd__decap_12
X_3341_ _1274_ _1275_ _1277_ _1278_ VGND VGND VPWR VPWR _1279_ sky130_fd_sc_hd__nor4_1
XFILLER_98_657 VPWR VGND VPWR VGND sky130_ef_sc_hd__decap_12
XFILLER_112_445 VPWR VGND VPWR VGND sky130_ef_sc_hd__decap_12
XFILLER_97_167 VGND VGND VPWR VPWR sky130_fd_sc_hd__fill_1
X_3272_ reg_file_inst.registry\[8\]\[24\] _1136_ _1137_ reg_file_inst.registry\[2\]\[24\]
+ _1210_ VGND VGND VPWR VPWR _1213_ sky130_fd_sc_hd__a221o_1
X_6060_ net146 VGND VGND VPWR VPWR _0468_ sky130_fd_sc_hd__inv_2
XFILLER_112_489 VPWR VGND VPWR VGND sky130_ef_sc_hd__decap_12
X_5011_ _2176_ _2845_ _2846_ _2853_ VGND VGND VPWR VPWR net55 sky130_fd_sc_hd__a31o_1
XFILLER_39_724 VGND VGND VPWR VPWR sky130_fd_sc_hd__fill_2
XFILLER_93_340 VGND VGND VPWR VPWR sky130_fd_sc_hd__decap_4
XFILLER_66_598 VGND VGND VPWR VPWR sky130_fd_sc_hd__decap_8
XFILLER_26_429 VGND VGND VPWR VPWR sky130_fd_sc_hd__fill_2
XFILLER_81_535 VGND VGND VPWR VPWR sky130_fd_sc_hd__fill_1
XTAP_TAPCELL_ROW_52_917 VGND VPWR sky130_fd_sc_hd__tapvpwrvgnd_1
X_5913_ net147 VGND VGND VPWR VPWR _0321_ sky130_fd_sc_hd__inv_2
XTAP_TAPCELL_ROW_105_1577 VGND VPWR sky130_fd_sc_hd__tapvpwrvgnd_1
XFILLER_34_473 VGND VGND VPWR VPWR sky130_fd_sc_hd__decap_3
XFILLER_34_495 VGND VGND VPWR VPWR sky130_fd_sc_hd__fill_2
X_5844_ net146 VGND VGND VPWR VPWR _0252_ sky130_fd_sc_hd__inv_2
XFILLER_22_657 VPWR VGND VPWR VGND sky130_ef_sc_hd__decap_12
X_5775_ net44 VGND VGND VPWR VPWR _0183_ sky130_fd_sc_hd__inv_2
XTAP_TAPCELL_ROW_32_663 VGND VPWR sky130_fd_sc_hd__tapvpwrvgnd_1
X_4726_ _2580_ _2584_ VGND VGND VPWR VPWR _2585_ sky130_fd_sc_hd__nand2_1
XFILLER_21_189 VGND VGND VPWR VPWR sky130_fd_sc_hd__decap_3
XFILLER_107_217 VGND VGND VPWR VPWR sky130_fd_sc_hd__decap_6
X_4657_ net136 _2422_ _2529_ VGND VGND VPWR VPWR _2530_ sky130_fd_sc_hd__a21oi_1
X_3608_ reg_file_inst.registry\[7\]\[11\] _1133_ _1139_ reg_file_inst.registry\[5\]\[11\]
+ VGND VGND VPWR VPWR _1536_ sky130_fd_sc_hd__a22o_1
XFILLER_122_209 VPWR VGND VPWR VGND sky130_ef_sc_hd__decap_12
XFILLER_1_517 VPWR VGND VPWR VGND sky130_ef_sc_hd__decap_12
X_4588_ _1778_ _2284_ _2437_ VGND VGND VPWR VPWR _2467_ sky130_fd_sc_hd__a21o_1
X_6327_ clknet_leaf_46_clk _0735_ _0260_ VGND VGND VPWR VPWR reg_file_inst.registry\[8\]\[8\]
+ sky130_fd_sc_hd__dfrtp_1
XFILLER_115_261 VPWR VGND VPWR VGND sky130_ef_sc_hd__decap_12
X_3539_ MEMOFF\[13\] net77 _1113_ VGND VGND VPWR VPWR _1469_ sky130_fd_sc_hd__mux2_4
X_6258_ clknet_leaf_33_clk _0666_ _0191_ VGND VGND VPWR VPWR reg_file_inst.registry\[4\]\[23\]
+ sky130_fd_sc_hd__dfrtp_1
XFILLER_67_27 VGND VGND VPWR VPWR sky130_fd_sc_hd__decap_4
X_6189_ clknet_leaf_29_clk _0597_ _0122_ VGND VGND VPWR VPWR reg_file_inst.registry\[5\]\[10\]
+ sky130_fd_sc_hd__dfrtp_1
X_5209_ reg_file_inst.registry\[11\]\[21\] _2419_ _2989_ VGND VGND VPWR VPWR _0844_
+ sky130_fd_sc_hd__mux2_1
XTAP_TAPCELL_ROW_4_311 VGND VPWR sky130_fd_sc_hd__tapvpwrvgnd_1
XFILLER_29_223 VGND VGND VPWR VPWR sky130_fd_sc_hd__fill_1
XFILLER_17_429 VPWR VGND VPWR VGND sky130_ef_sc_hd__decap_12
XFILLER_25_495 VGND VGND VPWR VPWR sky130_fd_sc_hd__decap_8
XFILLER_12_134 VGND VGND VPWR VPWR sky130_fd_sc_hd__decap_6
XFILLER_9_617 VPWR VGND VPWR VGND sky130_ef_sc_hd__decap_12
XFILLER_40_421 VGND VGND VPWR VPWR sky130_fd_sc_hd__fill_1
XFILLER_12_178 VGND VGND VPWR VPWR sky130_fd_sc_hd__decap_3
XFILLER_32_41 VGND VGND VPWR VPWR sky130_fd_sc_hd__decap_6
XFILLER_32_74 VGND VGND VPWR VPWR sky130_fd_sc_hd__decap_8
XFILLER_32_85 VPWR VGND VPWR VGND sky130_ef_sc_hd__decap_12
XFILLER_4_333 VGND VGND VPWR VPWR sky130_fd_sc_hd__decap_8
XFILLER_4_344 VPWR VGND VPWR VGND sky130_ef_sc_hd__decap_12
XFILLER_79_156 VGND VGND VPWR VPWR sky130_fd_sc_hd__fill_2
XFILLER_79_134 VGND VGND VPWR VPWR sky130_fd_sc_hd__decap_3
XFILLER_79_167 VGND VGND VPWR VPWR sky130_fd_sc_hd__fill_1
XFILLER_0_561 VGND VGND VPWR VPWR sky130_fd_sc_hd__decap_6
XFILLER_94_137 VGND VGND VPWR VPWR sky130_fd_sc_hd__decap_3
XFILLER_36_705 VGND VGND VPWR VPWR sky130_fd_sc_hd__fill_1
XFILLER_35_237 VPWR VGND VPWR VGND sky130_ef_sc_hd__decap_12
XFILLER_63_579 VPWR VGND VPWR VGND sky130_ef_sc_hd__decap_12
XFILLER_73_70 VGND VGND VPWR VPWR sky130_fd_sc_hd__fill_1
X_3890_ reg_file_inst.registry\[1\]\[1\] _1078_ _1082_ VGND VGND VPWR VPWR _1808_
+ sky130_fd_sc_hd__and3_1
XFILLER_78_3 VGND VGND VPWR VPWR sky130_fd_sc_hd__decap_8
X_5560_ _2478_ reg_file_inst.registry\[9\]\[3\] _3002_ VGND VGND VPWR VPWR _0506_
+ sky130_fd_sc_hd__mux2_1
X_5491_ JMPOFF\[14\] _2909_ _3000_ VGND VGND VPWR VPWR _0573_ sky130_fd_sc_hd__mux2_1
X_4511_ _2232_ _2239_ _1816_ VGND VGND VPWR VPWR _2394_ sky130_fd_sc_hd__mux2_1
XFILLER_117_559 VGND VGND VPWR VPWR sky130_fd_sc_hd__fill_1
X_4442_ _2279_ _2323_ _2326_ VGND VGND VPWR VPWR _2327_ sky130_fd_sc_hd__a21bo_1
XFILLER_104_209 VGND VGND VPWR VPWR sky130_fd_sc_hd__decap_3
XFILLER_98_421 VGND VGND VPWR VPWR sky130_fd_sc_hd__fill_1
X_4373_ _2260_ VGND VGND VPWR VPWR _2261_ sky130_fd_sc_hd__inv_2
XFILLER_98_443 VPWR VGND VPWR VGND sky130_ef_sc_hd__decap_12
X_3324_ reg_file_inst.registry\[9\]\[22\] _1131_ _1140_ reg_file_inst.registry\[3\]\[22\]
+ VGND VGND VPWR VPWR _1263_ sky130_fd_sc_hd__a22o_1
X_6112_ clknet_leaf_8_clk _0520_ _0045_ VGND VGND VPWR VPWR reg_file_inst.registry\[9\]\[17\]
+ sky130_fd_sc_hd__dfrtp_1
XFILLER_112_253 VPWR VGND VPWR VGND sky130_ef_sc_hd__decap_12
X_6043_ net146 VGND VGND VPWR VPWR _0451_ sky130_fd_sc_hd__inv_2
X_3255_ _1185_ _1195_ VGND VGND VPWR VPWR _1196_ sky130_fd_sc_hd__nor2_1
XTAP_TAPCELL_ROW_107_1606 VGND VPWR sky130_fd_sc_hd__tapvpwrvgnd_1
XFILLER_54_502 VPWR VGND VPWR VGND sky130_ef_sc_hd__decap_12
X_3186_ _1114_ _1121_ VGND VGND VPWR VPWR _1130_ sky130_fd_sc_hd__and2_4
XFILLER_26_204 VGND VGND VPWR VPWR sky130_fd_sc_hd__decap_4
XFILLER_27_705 VGND VGND VPWR VPWR sky130_fd_sc_hd__fill_1
XFILLER_94_693 VGND VGND VPWR VPWR sky130_fd_sc_hd__decap_6
XTAP_TAPCELL_ROW_37_722 VGND VPWR sky130_fd_sc_hd__tapvpwrvgnd_1
XFILLER_22_410 VGND VGND VPWR VPWR sky130_fd_sc_hd__fill_1
XTAP_TAPCELL_ROW_66_1093 VGND VPWR sky130_fd_sc_hd__tapvpwrvgnd_1
XFILLER_22_421 VPWR VGND VPWR VGND sky130_ef_sc_hd__decap_12
X_5827_ net147 VGND VGND VPWR VPWR _0235_ sky130_fd_sc_hd__inv_2
X_5758_ net44 VGND VGND VPWR VPWR _0166_ sky130_fd_sc_hd__inv_2
XTAP_TAPCELL_ROW_118_1735 VGND VPWR sky130_fd_sc_hd__tapvpwrvgnd_1
X_4709_ _1172_ _2567_ VGND VGND VPWR VPWR _2568_ sky130_fd_sc_hd__nor2_1
X_5689_ net147 VGND VGND VPWR VPWR _0097_ sky130_fd_sc_hd__inv_2
XFILLER_118_77 VGND VGND VPWR VPWR sky130_fd_sc_hd__decap_6
XFILLER_116_581 VGND VGND VPWR VPWR sky130_fd_sc_hd__decap_6
XFILLER_1_325 VGND VGND VPWR VPWR sky130_fd_sc_hd__fill_1
XFILLER_103_264 VPWR VGND VPWR VGND sky130_ef_sc_hd__decap_12
XFILLER_89_498 VGND VGND VPWR VPWR sky130_fd_sc_hd__decap_6
XFILLER_49_318 VGND VGND VPWR VPWR sky130_fd_sc_hd__decap_4
XFILLER_85_671 VGND VGND VPWR VPWR sky130_fd_sc_hd__fill_1
XFILLER_57_340 VPWR VGND VPWR VGND sky130_ef_sc_hd__decap_12
XFILLER_84_170 VGND VGND VPWR VPWR sky130_fd_sc_hd__fill_2
XFILLER_72_343 VGND VGND VPWR VPWR sky130_fd_sc_hd__fill_1
XFILLER_32_229 VGND VGND VPWR VPWR sky130_fd_sc_hd__decap_8
XTAP_TAPCELL_ROW_15_449 VGND VPWR sky130_fd_sc_hd__tapvpwrvgnd_1
XFILLER_25_281 VGND VGND VPWR VPWR sky130_fd_sc_hd__fill_1
XFILLER_9_447 VGND VGND VPWR VPWR sky130_fd_sc_hd__fill_1
XTAP_TAPCELL_ROW_93_1429 VGND VPWR sky130_fd_sc_hd__tapvpwrvgnd_1
XFILLER_5_653 VPWR VGND VPWR VGND sky130_ef_sc_hd__decap_12
XFILLER_5_697 VPWR VGND VPWR VGND sky130_ef_sc_hd__decap_12
XFILLER_122_573 VPWR VGND VPWR VGND sky130_ef_sc_hd__decap_12
XFILLER_110_713 VGND VGND VPWR VPWR sky130_fd_sc_hd__decap_6
XFILLER_95_446 VGND VGND VPWR VPWR sky130_fd_sc_hd__fill_2
XFILLER_67_137 VPWR VGND VPWR VGND sky130_ef_sc_hd__decap_12
X_3040_ JMPOFF\[23\] _0967_ _0983_ VGND VGND VPWR VPWR _0984_ sky130_fd_sc_hd__a21bo_1
XFILLER_82_118 VGND VGND VPWR VPWR sky130_fd_sc_hd__fill_1
XFILLER_75_181 VGND VGND VPWR VPWR sky130_fd_sc_hd__fill_1
XFILLER_91_641 VPWR VGND VPWR VGND sky130_ef_sc_hd__decap_12
XFILLER_63_343 VGND VGND VPWR VPWR sky130_fd_sc_hd__decap_4
XFILLER_51_505 VPWR VGND VPWR VGND sky130_ef_sc_hd__decap_12
XFILLER_91_685 VPWR VGND VPWR VGND sky130_ef_sc_hd__decap_12
X_4991_ net136 _2783_ _2835_ _2277_ VGND VGND VPWR VPWR _2836_ sky130_fd_sc_hd__o211ai_1
XTAP_TAPCELL_ROW_102_1536 VGND VPWR sky130_fd_sc_hd__tapvpwrvgnd_1
X_3942_ _1855_ _1857_ _1695_ _1723_ _1753_ VGND VGND VPWR VPWR _1858_ sky130_fd_sc_hd__o2111a_1
X_3873_ reg_file_inst.registry\[4\]\[2\] _1114_ net142 VGND VGND VPWR VPWR _1792_
+ sky130_fd_sc_hd__and3_1
X_5612_ net146 VGND VGND VPWR VPWR _0020_ sky130_fd_sc_hd__inv_2
XTAP_TAPCELL_ROW_42_791 VGND VPWR sky130_fd_sc_hd__tapvpwrvgnd_1
X_5543_ _2842_ reg_file_inst.registry\[9\]\[20\] _3002_ VGND VGND VPWR VPWR _0523_
+ sky130_fd_sc_hd__mux2_1
X_5474_ reg_file_inst.registry\[5\]\[2\] _2501_ _2999_ VGND VGND VPWR VPWR _0589_
+ sky130_fd_sc_hd__mux2_1
XFILLER_105_529 VPWR VGND VPWR VGND sky130_ef_sc_hd__decap_12
X_4425_ net70 _2308_ _2310_ VGND VGND VPWR VPWR _2311_ sky130_fd_sc_hd__a21o_4
XTAP_TAPCELL_ROW_113_1676 VGND VPWR sky130_fd_sc_hd__tapvpwrvgnd_1
X_4356_ _2239_ _2241_ _1816_ VGND VGND VPWR VPWR _2244_ sky130_fd_sc_hd__mux2_1
XFILLER_113_573 VPWR VGND VPWR VGND sky130_ef_sc_hd__decap_12
X_3307_ reg_file_inst.registry\[4\]\[22\] _1092_ _1096_ reg_file_inst.registry\[11\]\[22\]
+ VGND VGND VPWR VPWR _1246_ sky130_fd_sc_hd__a22oi_1
XFILLER_59_638 VGND VGND VPWR VPWR sky130_fd_sc_hd__decap_8
XFILLER_58_104 VPWR VGND VPWR VGND sky130_ef_sc_hd__decap_12
XFILLER_48_18 VGND VGND VPWR VPWR sky130_fd_sc_hd__decap_8
XFILLER_48_29 VGND VGND VPWR VPWR sky130_fd_sc_hd__fill_1
X_4287_ _1874_ _2123_ _2125_ VGND VGND VPWR VPWR _2175_ sky130_fd_sc_hd__mux2_1
X_3238_ reg_file_inst.registry\[9\]\[25\] _1089_ _1095_ JMPOFF\[25\] VGND VGND VPWR
+ VPWR _1180_ sky130_fd_sc_hd__a22o_1
X_6026_ net148 VGND VGND VPWR VPWR _0434_ sky130_fd_sc_hd__inv_2
XFILLER_94_490 VGND VGND VPWR VPWR sky130_fd_sc_hd__fill_1
XTAP_TAPCELL_ROW_68_1111 VGND VPWR sky130_fd_sc_hd__tapvpwrvgnd_1
XFILLER_54_321 VGND VGND VPWR VPWR sky130_fd_sc_hd__decap_8
X_3169_ net43 _1111_ VGND VGND VPWR VPWR _1113_ sky130_fd_sc_hd__nand2_8
XFILLER_64_39 VPWR VGND VPWR VGND sky130_ef_sc_hd__decap_12
XFILLER_54_365 VPWR VGND VPWR VGND sky130_ef_sc_hd__decap_12
XTAP_TAPCELL_ROW_12_408 VGND VPWR sky130_fd_sc_hd__tapvpwrvgnd_1
XTAP_TAPCELL_ROW_12_419 VGND VPWR sky130_fd_sc_hd__tapvpwrvgnd_1
XFILLER_108_301 VGND VGND VPWR VPWR sky130_fd_sc_hd__decap_6
XFILLER_10_468 VGND VGND VPWR VPWR sky130_fd_sc_hd__decap_4
XTAP_TAPCELL_ROW_79_1251 VGND VPWR sky130_fd_sc_hd__tapvpwrvgnd_1
XFILLER_6_439 VGND VGND VPWR VPWR sky130_fd_sc_hd__decap_4
XFILLER_108_345 VPWR VGND VPWR VGND sky130_ef_sc_hd__decap_12
XFILLER_108_389 VPWR VGND VPWR VGND sky130_ef_sc_hd__decap_12
XFILLER_89_69 VGND VGND VPWR VPWR sky130_fd_sc_hd__decap_6
XFILLER_2_601 VPWR VGND VPWR VGND sky130_ef_sc_hd__decap_12
XFILLER_2_645 VPWR VGND VPWR VGND sky130_ef_sc_hd__decap_12
XFILLER_1_111 VGND VGND VPWR VPWR sky130_fd_sc_hd__fill_1
XFILLER_77_402 VGND VGND VPWR VPWR sky130_fd_sc_hd__decap_4
XFILLER_18_568 VPWR VGND VPWR VGND sky130_ef_sc_hd__decap_12
XFILLER_45_332 VGND VGND VPWR VPWR sky130_fd_sc_hd__decap_4
XFILLER_54_50 VGND VGND VPWR VPWR sky130_fd_sc_hd__decap_8
XFILLER_72_195 VGND VGND VPWR VPWR sky130_fd_sc_hd__fill_1
XFILLER_54_83 VGND VGND VPWR VPWR sky130_fd_sc_hd__fill_1
XFILLER_9_222 VGND VGND VPWR VPWR sky130_fd_sc_hd__fill_2
XFILLER_118_109 VPWR VGND VPWR VGND sky130_ef_sc_hd__decap_12
XFILLER_9_277 VGND VGND VPWR VPWR sky130_fd_sc_hd__decap_3
Xclkload25 clknet_leaf_19_clk VGND VGND VPWR VPWR clkload25/Y sky130_fd_sc_hd__clkinvlp_4
Xclkload14 clknet_leaf_6_clk VGND VGND VPWR VPWR clkload14/Y sky130_fd_sc_hd__clkinv_2
Xclkload47 clknet_leaf_29_clk VGND VGND VPWR VPWR clkload47/Y sky130_fd_sc_hd__inv_6
Xclkload58 clknet_leaf_42_clk VGND VGND VPWR VPWR clkload58/Y sky130_fd_sc_hd__bufinv_16
Xclkload36 clknet_leaf_56_clk VGND VGND VPWR VPWR clkload36/Y sky130_fd_sc_hd__clkinvlp_4
X_4210_ _1967_ _1968_ VGND VGND VPWR VPWR _2104_ sky130_fd_sc_hd__and2_1
X_5190_ _2897_ reg_file_inst.registry\[0\]\[15\] _2988_ VGND VGND VPWR VPWR _0862_
+ sky130_fd_sc_hd__mux2_1
XFILLER_122_381 VGND VGND VPWR VPWR sky130_fd_sc_hd__decap_8
X_4141_ net41 _2056_ VGND VGND VPWR VPWR _2057_ sky130_fd_sc_hd__xnor2_1
XFILLER_68_457 VGND VGND VPWR VPWR sky130_fd_sc_hd__decap_6
XFILLER_55_107 VGND VGND VPWR VPWR sky130_fd_sc_hd__decap_4
X_4072_ net103 _1984_ _1979_ VGND VGND VPWR VPWR _1988_ sky130_fd_sc_hd__a21bo_1
XFILLER_110_587 VGND VGND VPWR VPWR sky130_fd_sc_hd__fill_1
XFILLER_95_90 VGND VGND VPWR VPWR sky130_fd_sc_hd__fill_2
XFILLER_83_449 VGND VGND VPWR VPWR sky130_fd_sc_hd__decap_4
X_3023_ net41 net141 VGND VGND VPWR VPWR _0967_ sky130_fd_sc_hd__and2_4
XFILLER_64_652 VGND VGND VPWR VPWR sky130_fd_sc_hd__fill_2
XTAP_TAPCELL_ROW_47_850 VGND VPWR sky130_fd_sc_hd__tapvpwrvgnd_1
XFILLER_48_192 VGND VGND VPWR VPWR sky130_fd_sc_hd__fill_1
XFILLER_64_685 VPWR VGND VPWR VGND sky130_ef_sc_hd__decap_12
XFILLER_51_335 VGND VGND VPWR VPWR sky130_fd_sc_hd__fill_1
X_4974_ _1294_ _2282_ _2285_ _1295_ VGND VGND VPWR VPWR _2821_ sky130_fd_sc_hd__o22a_1
XTAP_TAPCELL_ROW_63_1052 VGND VPWR sky130_fd_sc_hd__tapvpwrvgnd_1
X_3925_ reg_file_inst.registry\[10\]\[0\] _1126_ _1138_ reg_file_inst.registry\[14\]\[0\]
+ VGND VGND VPWR VPWR _1842_ sky130_fd_sc_hd__a22o_1
Xclkload8 clknet_leaf_10_clk VGND VGND VPWR VPWR clkload8/X sky130_fd_sc_hd__clkbuf_4
X_3856_ reg_file_inst.registry\[10\]\[3\] _1126_ _1767_ _1769_ _1770_ VGND VGND VPWR
+ VPWR _1776_ sky130_fd_sc_hd__a2111o_1
XFILLER_118_643 VGND VGND VPWR VPWR sky130_fd_sc_hd__fill_1
X_3787_ reg_file_inst.registry\[0\]\[4\] _1076_ _1703_ _1707_ VGND VGND VPWR VPWR
+ _1709_ sky130_fd_sc_hd__o22ai_4
XTAP_TAPCELL_ROW_115_1705 VGND VPWR sky130_fd_sc_hd__tapvpwrvgnd_1
X_5526_ reg_file_inst.registry\[6\]\[8\] _2986_ _3001_ VGND VGND VPWR VPWR _0539_
+ sky130_fd_sc_hd__mux2_1
X_5457_ reg_file_inst.registry\[5\]\[19\] _2854_ _2999_ VGND VGND VPWR VPWR _0606_
+ sky130_fd_sc_hd__mux2_1
XFILLER_105_337 VGND VGND VPWR VPWR sky130_fd_sc_hd__decap_4
XFILLER_59_28 VGND VGND VPWR VPWR sky130_fd_sc_hd__fill_1
X_4408_ _2129_ _2294_ VGND VGND VPWR VPWR _2296_ sky130_fd_sc_hd__nor2_4
XFILLER_120_307 VGND VGND VPWR VPWR sky130_fd_sc_hd__fill_1
X_5388_ MEMOFF\[1\] _2528_ _2996_ VGND VGND VPWR VPWR _0672_ sky130_fd_sc_hd__mux2_1
XTAP_TAPCELL_ROW_74_1192 VGND VPWR sky130_fd_sc_hd__tapvpwrvgnd_1
X_4339_ _2223_ _2226_ net133 VGND VGND VPWR VPWR _2227_ sky130_fd_sc_hd__mux2_1
XFILLER_59_479 VGND VGND VPWR VPWR sky130_fd_sc_hd__decap_4
X_6009_ net148 VGND VGND VPWR VPWR _0417_ sky130_fd_sc_hd__inv_2
XFILLER_75_49 VGND VGND VPWR VPWR sky130_fd_sc_hd__fill_1
XFILLER_55_652 VGND VGND VPWR VPWR sky130_fd_sc_hd__decap_8
XFILLER_27_321 VGND VGND VPWR VPWR sky130_fd_sc_hd__fill_1
XFILLER_39_181 VGND VGND VPWR VPWR sky130_fd_sc_hd__fill_1
XFILLER_91_15 VPWR VGND VPWR VGND sky130_ef_sc_hd__decap_12
XFILLER_82_471 VGND VGND VPWR VPWR sky130_fd_sc_hd__fill_2
XFILLER_27_387 VGND VGND VPWR VPWR sky130_fd_sc_hd__decap_4
XFILLER_42_313 VGND VGND VPWR VPWR sky130_fd_sc_hd__fill_1
XFILLER_24_20 VGND VGND VPWR VPWR sky130_fd_sc_hd__decap_8
XFILLER_30_508 VGND VGND VPWR VPWR sky130_fd_sc_hd__decap_4
XFILLER_70_699 VGND VGND VPWR VPWR sky130_fd_sc_hd__fill_1
XTAP_TAPCELL_ROW_25_577 VGND VPWR sky130_fd_sc_hd__tapvpwrvgnd_1
XFILLER_6_225 VGND VGND VPWR VPWR sky130_fd_sc_hd__decap_6
XFILLER_6_203 VGND VGND VPWR VPWR sky130_fd_sc_hd__fill_1
XFILLER_109_665 VGND VGND VPWR VPWR sky130_fd_sc_hd__decap_6
XFILLER_6_258 VPWR VGND VPWR VGND sky130_ef_sc_hd__decap_12
XFILLER_108_153 VPWR VGND VPWR VGND sky130_ef_sc_hd__decap_12
XFILLER_40_85 VGND VGND VPWR VPWR sky130_fd_sc_hd__decap_8
XFILLER_108_197 VPWR VGND VPWR VGND sky130_ef_sc_hd__decap_12
XFILLER_111_329 VGND VGND VPWR VPWR sky130_fd_sc_hd__decap_6
XFILLER_77_232 VGND VGND VPWR VPWR sky130_fd_sc_hd__decap_4
XFILLER_77_221 VGND VGND VPWR VPWR sky130_fd_sc_hd__decap_3
XFILLER_65_405 VGND VGND VPWR VPWR sky130_fd_sc_hd__decap_6
XFILLER_38_619 VGND VGND VPWR VPWR sky130_fd_sc_hd__decap_8
XFILLER_92_224 VPWR VGND VPWR VGND sky130_ef_sc_hd__decap_12
XFILLER_65_438 VGND VGND VPWR VPWR sky130_fd_sc_hd__decap_8
XFILLER_65_449 VGND VGND VPWR VPWR sky130_fd_sc_hd__fill_1
XFILLER_1_57 VPWR VGND VPWR VGND sky130_ef_sc_hd__decap_12
Xclkbuf_leaf_57_clk clknet_3_4__leaf_clk VGND VGND VPWR VPWR clknet_leaf_57_clk sky130_fd_sc_hd__clkbuf_8
XFILLER_80_419 VGND VGND VPWR VPWR sky130_fd_sc_hd__fill_1
XFILLER_73_471 VGND VGND VPWR VPWR sky130_fd_sc_hd__fill_2
XFILLER_73_493 VGND VGND VPWR VPWR sky130_fd_sc_hd__fill_1
XTAP_TAPCELL_ROW_44_820 VGND VPWR sky130_fd_sc_hd__tapvpwrvgnd_1
XFILLER_81_81 VGND VGND VPWR VPWR sky130_fd_sc_hd__decap_8
XFILLER_60_176 VPWR VGND VPWR VGND sky130_ef_sc_hd__decap_12
X_3710_ _1242_ _1231_ VGND VGND VPWR VPWR _1634_ sky130_fd_sc_hd__nand2b_1
X_4690_ reg_file_inst.registry\[11\]\[26\] _2501_ _2551_ VGND VGND VPWR VPWR _0905_
+ sky130_fd_sc_hd__mux2_1
XFILLER_119_429 VPWR VGND VPWR VGND sky130_ef_sc_hd__decap_12
X_3641_ _1552_ _1566_ VGND VGND VPWR VPWR _1567_ sky130_fd_sc_hd__nor2_1
X_3572_ reg_file_inst.registry\[7\]\[14\] _1086_ _1093_ reg_file_inst.registry\[15\]\[14\]
+ VGND VGND VPWR VPWR _1501_ sky130_fd_sc_hd__a22o_1
XFILLER_60_3 VGND VGND VPWR VPWR sky130_fd_sc_hd__fill_1
X_6360_ clknet_leaf_11_clk _0768_ _0293_ VGND VGND VPWR VPWR reg_file_inst.registry\[2\]\[13\]
+ sky130_fd_sc_hd__dfrtp_1
X_5311_ _2842_ reg_file_inst.registry\[8\]\[20\] _2994_ VGND VGND VPWR VPWR _0747_
+ sky130_fd_sc_hd__mux2_1
X_6291_ clknet_leaf_56_clk _0699_ _0224_ VGND VGND VPWR VPWR reg_file_inst.registry\[3\]\[0\]
+ sky130_fd_sc_hd__dfrtp_1
XFILLER_102_307 VGND VGND VPWR VPWR sky130_fd_sc_hd__fill_1
X_5242_ _2528_ reg_file_inst.registry\[1\]\[1\] _2990_ VGND VGND VPWR VPWR _0812_
+ sky130_fd_sc_hd__mux2_1
XFILLER_114_189 VGND VGND VPWR VPWR sky130_fd_sc_hd__decap_6
XTAP_TAPCELL_ROW_110_1635 VGND VPWR sky130_fd_sc_hd__tapvpwrvgnd_1
X_5173_ reg_file_inst.registry\[7\]\[2\] _2501_ _2553_ VGND VGND VPWR VPWR _0877_
+ sky130_fd_sc_hd__mux2_1
X_4124_ _0978_ _0984_ _2038_ VGND VGND VPWR VPWR _2040_ sky130_fd_sc_hd__nand3_1
XFILLER_68_265 VPWR VGND VPWR VGND sky130_ef_sc_hd__decap_12
XFILLER_68_243 VGND VGND VPWR VPWR sky130_fd_sc_hd__decap_8
XFILLER_68_232 VGND VGND VPWR VPWR sky130_fd_sc_hd__decap_8
XFILLER_96_585 VGND VGND VPWR VPWR sky130_fd_sc_hd__decap_3
XFILLER_84_725 VGND VGND VPWR VPWR sky130_fd_sc_hd__fill_1
Xinput1 DataMemoryRead[0] VGND VGND VPWR VPWR net1 sky130_fd_sc_hd__clkbuf_1
X_4055_ _1968_ _1970_ VGND VGND VPWR VPWR _1971_ sky130_fd_sc_hd__or2_1
Xclkbuf_leaf_48_clk clknet_3_5__leaf_clk VGND VGND VPWR VPWR clknet_leaf_48_clk sky130_fd_sc_hd__clkbuf_8
XFILLER_37_685 VPWR VGND VPWR VGND sky130_ef_sc_hd__decap_12
X_3006_ net108 VGND VGND VPWR VPWR _0952_ sky130_fd_sc_hd__inv_2
XFILLER_91_290 VGND VGND VPWR VPWR sky130_fd_sc_hd__decap_6
XFILLER_36_173 VGND VGND VPWR VPWR sky130_fd_sc_hd__decap_8
XTAP_TAPCELL_ROW_121_1775 VGND VPWR sky130_fd_sc_hd__tapvpwrvgnd_1
XFILLER_101_69 VPWR VGND VPWR VGND sky130_ef_sc_hd__decap_12
X_4957_ reg_file_inst.registry\[7\]\[23\] _2806_ _2553_ VGND VGND VPWR VPWR _0898_
+ sky130_fd_sc_hd__mux2_1
XTAP_TAPCELL_ROW_22_536 VGND VPWR sky130_fd_sc_hd__tapvpwrvgnd_1
X_4888_ _2322_ _2744_ net136 VGND VGND VPWR VPWR _2745_ sky130_fd_sc_hd__mux2_1
X_3908_ _1822_ _1824_ _1825_ _1118_ reg_file_inst.registry\[0\]\[1\] VGND VGND VPWR
+ VPWR net84 sky130_fd_sc_hd__o32a_4
X_3839_ reg_file_inst.registry\[4\]\[3\] _1092_ _1758_ net139 VGND VGND VPWR VPWR
+ _1759_ sky130_fd_sc_hd__a211o_1
XFILLER_20_563 VGND VGND VPWR VPWR sky130_fd_sc_hd__fill_1
XTAP_TAPCELL_ROW_50_889 VGND VPWR sky130_fd_sc_hd__tapvpwrvgnd_1
XFILLER_106_613 VPWR VGND VPWR VGND sky130_ef_sc_hd__decap_12
XTAP_TAPCELL_ROW_76_1210 VGND VPWR sky130_fd_sc_hd__tapvpwrvgnd_1
XFILLER_106_657 VPWR VGND VPWR VGND sky130_ef_sc_hd__decap_12
X_5509_ reg_file_inst.registry\[6\]\[25\] _2767_ _3001_ VGND VGND VPWR VPWR _0556_
+ sky130_fd_sc_hd__mux2_1
X_6489_ clknet_leaf_34_clk _0897_ _0422_ VGND VGND VPWR VPWR reg_file_inst.registry\[7\]\[22\]
+ sky130_fd_sc_hd__dfrtp_1
XFILLER_105_167 VGND VGND VPWR VPWR sky130_fd_sc_hd__fill_1
XFILLER_86_15 VPWR VGND VPWR VGND sky130_ef_sc_hd__decap_12
XFILLER_59_221 VGND VGND VPWR VPWR sky130_fd_sc_hd__decap_3
XFILLER_59_254 VPWR VGND VPWR VGND sky130_ef_sc_hd__decap_12
XFILLER_47_438 VGND VGND VPWR VPWR sky130_fd_sc_hd__decap_8
Xclkbuf_leaf_39_clk clknet_3_7__leaf_clk VGND VGND VPWR VPWR clknet_leaf_39_clk sky130_fd_sc_hd__clkbuf_8
XFILLER_47_449 VPWR VGND VPWR VGND sky130_ef_sc_hd__decap_12
XTAP_TAPCELL_ROW_87_1350 VGND VPWR sky130_fd_sc_hd__tapvpwrvgnd_1
XFILLER_74_279 VPWR VGND VPWR VGND sky130_ef_sc_hd__decap_12
XTAP_TAPCELL_ROW_58_989 VGND VPWR sky130_fd_sc_hd__tapvpwrvgnd_1
XTAP_TAPCELL_ROW_2_283 VGND VPWR sky130_fd_sc_hd__tapvpwrvgnd_1
XTAP_TAPCELL_ROW_2_294 VGND VPWR sky130_fd_sc_hd__tapvpwrvgnd_1
XFILLER_15_324 VPWR VGND VPWR VGND sky130_ef_sc_hd__decap_12
XFILLER_27_184 VGND VGND VPWR VPWR sky130_fd_sc_hd__fill_2
XFILLER_28_696 VGND VGND VPWR VPWR sky130_fd_sc_hd__decap_4
XFILLER_35_30 VGND VGND VPWR VPWR sky130_fd_sc_hd__decap_4
XFILLER_43_644 VGND VGND VPWR VPWR sky130_fd_sc_hd__fill_1
XFILLER_42_165 VPWR VGND VPWR VGND sky130_ef_sc_hd__decap_12
XFILLER_43_688 VPWR VGND VPWR VGND sky130_ef_sc_hd__decap_12
XFILLER_11_585 VPWR VGND VPWR VGND sky130_ef_sc_hd__decap_12
XFILLER_109_473 VPWR VGND VPWR VGND sky130_ef_sc_hd__decap_12
XTAP_TAPCELL_ROW_98_1490 VGND VPWR sky130_fd_sc_hd__tapvpwrvgnd_1
XFILLER_111_137 VPWR VGND VPWR VGND sky130_ef_sc_hd__decap_12
XFILLER_120_693 VGND VGND VPWR VPWR sky130_fd_sc_hd__decap_6
XFILLER_66_725 VGND VGND VPWR VPWR sky130_fd_sc_hd__fill_1
XFILLER_93_533 VGND VGND VPWR VPWR sky130_fd_sc_hd__decap_6
XFILLER_65_246 VPWR VGND VPWR VGND sky130_ef_sc_hd__decap_12
XFILLER_19_652 VGND VGND VPWR VPWR sky130_fd_sc_hd__decap_8
XFILLER_19_685 VGND VGND VPWR VPWR sky130_fd_sc_hd__decap_6
X_5860_ net44 VGND VGND VPWR VPWR _0268_ sky130_fd_sc_hd__inv_2
XFILLER_18_173 VGND VGND VPWR VPWR sky130_fd_sc_hd__fill_1
X_4811_ _1345_ _2657_ _2659_ _1369_ VGND VGND VPWR VPWR _2670_ sky130_fd_sc_hd__a22o_1
XFILLER_33_154 VGND VGND VPWR VPWR sky130_fd_sc_hd__decap_8
XFILLER_33_165 VGND VGND VPWR VPWR sky130_fd_sc_hd__decap_3
X_5791_ net149 VGND VGND VPWR VPWR _0199_ sky130_fd_sc_hd__inv_2
XTAP_TAPCELL_ROW_60_1011 VGND VPWR sky130_fd_sc_hd__tapvpwrvgnd_1
X_4742_ _1552_ _2555_ _2126_ VGND VGND VPWR VPWR _2601_ sky130_fd_sc_hd__a21o_1
XFILLER_119_237 VPWR VGND VPWR VGND sky130_ef_sc_hd__decap_12
X_4673_ _2448_ _2530_ _2545_ _1764_ VGND VGND VPWR VPWR _2546_ sky130_fd_sc_hd__a22o_1
X_3624_ net139 _1543_ _1547_ _1550_ VGND VGND VPWR VPWR _1551_ sky130_fd_sc_hd__or4_1
X_6412_ clknet_leaf_7_clk _0820_ _0345_ VGND VGND VPWR VPWR reg_file_inst.registry\[1\]\[9\]
+ sky130_fd_sc_hd__dfrtp_1
X_6343_ clknet_leaf_32_clk _0751_ _0276_ VGND VGND VPWR VPWR reg_file_inst.registry\[8\]\[24\]
+ sky130_fd_sc_hd__dfrtp_1
X_3555_ reg_file_inst.registry\[2\]\[15\] _1137_ _1483_ _1484_ VGND VGND VPWR VPWR
+ _1485_ sky130_fd_sc_hd__a211o_1
XFILLER_88_305 VGND VGND VPWR VPWR sky130_fd_sc_hd__decap_3
X_6274_ clknet_leaf_61_clk _0682_ _0207_ VGND VGND VPWR VPWR MEMOFF\[11\] sky130_fd_sc_hd__dfrtp_1
X_3486_ _1403_ _1417_ VGND VGND VPWR VPWR _1418_ sky130_fd_sc_hd__nand2_1
X_5225_ _2863_ reg_file_inst.registry\[1\]\[18\] _2990_ VGND VGND VPWR VPWR _0829_
+ sky130_fd_sc_hd__mux2_1
XTAP_TAPCELL_ROW_71_1151 VGND VPWR sky130_fd_sc_hd__tapvpwrvgnd_1
XFILLER_57_703 VPWR VGND VPWR VGND sky130_ef_sc_hd__decap_12
XFILLER_111_671 VGND VGND VPWR VPWR sky130_fd_sc_hd__fill_1
XFILLER_96_382 VPWR VGND VPWR VGND sky130_ef_sc_hd__decap_12
XFILLER_56_29 VGND VGND VPWR VPWR sky130_fd_sc_hd__decap_6
X_5156_ net137 _2530_ _2976_ _1709_ VGND VGND VPWR VPWR _2977_ sky130_fd_sc_hd__o211a_1
XFILLER_84_533 VGND VGND VPWR VPWR sky130_fd_sc_hd__fill_1
X_4107_ JMPOFF\[20\] _0967_ _2022_ VGND VGND VPWR VPWR _2023_ sky130_fd_sc_hd__a21o_1
XFILLER_56_235 VGND VGND VPWR VPWR sky130_fd_sc_hd__fill_1
X_5087_ _2407_ _2711_ _2825_ _2279_ _2917_ VGND VGND VPWR VPWR _2918_ sky130_fd_sc_hd__a221o_1
X_4038_ _1012_ _1953_ VGND VGND VPWR VPWR _1954_ sky130_fd_sc_hd__nor2_1
XTAP_TAPCELL_ROW_27_606 VGND VPWR sky130_fd_sc_hd__tapvpwrvgnd_1
XTAP_TAPCELL_ROW_55_948 VGND VPWR sky130_fd_sc_hd__tapvpwrvgnd_1
XFILLER_37_482 VPWR VGND VPWR VGND sky130_ef_sc_hd__decap_12
X_5989_ net149 VGND VGND VPWR VPWR _0397_ sky130_fd_sc_hd__inv_2
XTAP_TAPCELL_ROW_82_1291 VGND VPWR sky130_fd_sc_hd__tapvpwrvgnd_1
XFILLER_8_309 VGND VGND VPWR VPWR sky130_fd_sc_hd__decap_8
XFILLER_12_349 VGND VGND VPWR VPWR sky130_fd_sc_hd__decap_3
XFILLER_4_504 VPWR VGND VPWR VGND sky130_ef_sc_hd__decap_12
XFILLER_106_421 VPWR VGND VPWR VGND sky130_ef_sc_hd__decap_12
XFILLER_97_47 VGND VGND VPWR VPWR sky130_fd_sc_hd__decap_3
XFILLER_79_349 VPWR VGND VPWR VGND sky130_ef_sc_hd__decap_12
XTAP_TAPCELL_ROW_7_353 VGND VPWR sky130_fd_sc_hd__tapvpwrvgnd_1
XFILLER_102_693 VGND VGND VPWR VPWR sky130_fd_sc_hd__decap_6
XFILLER_87_393 VPWR VGND VPWR VGND sky130_ef_sc_hd__decap_12
XFILLER_75_533 VPWR VGND VPWR VGND sky130_ef_sc_hd__decap_12
XFILLER_63_717 VGND VGND VPWR VPWR sky130_fd_sc_hd__decap_6
XFILLER_47_279 VGND VGND VPWR VPWR sky130_fd_sc_hd__fill_1
XFILLER_15_110 VGND VGND VPWR VPWR sky130_fd_sc_hd__fill_2
XFILLER_62_249 VGND VGND VPWR VPWR sky130_fd_sc_hd__decap_3
XFILLER_70_271 VGND VGND VPWR VPWR sky130_fd_sc_hd__fill_1
XFILLER_30_113 VGND VGND VPWR VPWR sky130_fd_sc_hd__decap_8
XFILLER_62_83 VGND VGND VPWR VPWR sky130_fd_sc_hd__fill_1
XFILLER_109_281 VPWR VGND VPWR VGND sky130_ef_sc_hd__decap_12
X_3340_ reg_file_inst.registry\[2\]\[21\] _1083_ _1096_ reg_file_inst.registry\[11\]\[21\]
+ _1271_ VGND VGND VPWR VPWR _1278_ sky130_fd_sc_hd__a221o_1
XFILLER_112_413 VGND VGND VPWR VPWR sky130_fd_sc_hd__decap_6
XFILLER_98_625 VPWR VGND VPWR VGND sky130_ef_sc_hd__decap_12
XFILLER_97_113 VGND VGND VPWR VPWR sky130_fd_sc_hd__decap_4
XFILLER_112_457 VPWR VGND VPWR VGND sky130_ef_sc_hd__decap_12
XFILLER_98_669 VPWR VGND VPWR VGND sky130_ef_sc_hd__decap_12
X_3271_ reg_file_inst.registry\[15\]\[24\] _1122_ _1129_ MEMOFF\[24\] _1211_ VGND
+ VGND VPWR VPWR _1212_ sky130_fd_sc_hd__a221o_1
X_5010_ _2296_ _2458_ _2721_ _2847_ _2852_ VGND VGND VPWR VPWR _2853_ sky130_fd_sc_hd__a221o_1
XFILLER_66_511 VGND VGND VPWR VPWR sky130_fd_sc_hd__fill_1
XFILLER_23_3 VGND VGND VPWR VPWR sky130_fd_sc_hd__fill_1
XFILLER_39_703 VGND VGND VPWR VPWR sky130_fd_sc_hd__fill_1
XFILLER_66_533 VGND VGND VPWR VPWR sky130_fd_sc_hd__decap_8
XFILLER_93_352 VGND VGND VPWR VPWR sky130_fd_sc_hd__fill_1
XFILLER_81_503 VGND VGND VPWR VPWR sky130_fd_sc_hd__fill_1
XFILLER_19_493 VGND VGND VPWR VPWR sky130_fd_sc_hd__decap_8
X_5912_ net147 VGND VGND VPWR VPWR _0320_ sky130_fd_sc_hd__inv_2
XTAP_TAPCELL_ROW_52_918 VGND VPWR sky130_fd_sc_hd__tapvpwrvgnd_1
XTAP_TAPCELL_ROW_105_1578 VGND VPWR sky130_fd_sc_hd__tapvpwrvgnd_1
X_5843_ net44 VGND VGND VPWR VPWR _0251_ sky130_fd_sc_hd__inv_2
XFILLER_21_113 VPWR VGND VPWR VGND sky130_ef_sc_hd__decap_12
XFILLER_22_669 VPWR VGND VPWR VGND sky130_ef_sc_hd__decap_12
X_5774_ net147 VGND VGND VPWR VPWR _0182_ sky130_fd_sc_hd__inv_2
XTAP_TAPCELL_ROW_32_664 VGND VPWR sky130_fd_sc_hd__tapvpwrvgnd_1
X_4725_ _2583_ VGND VGND VPWR VPWR _2584_ sky130_fd_sc_hd__inv_2
XFILLER_108_719 VGND VGND VPWR VPWR sky130_fd_sc_hd__fill_1
X_4656_ net136 _2432_ VGND VGND VPWR VPWR _2529_ sky130_fd_sc_hd__nor2_1
X_4587_ _2166_ _2154_ VGND VGND VPWR VPWR _2466_ sky130_fd_sc_hd__nand2b_1
X_3607_ reg_file_inst.registry\[15\]\[11\] _1122_ _1130_ JMPOFF\[11\] _1534_ VGND
+ VGND VPWR VPWR _1535_ sky130_fd_sc_hd__a221o_1
X_3538_ _1464_ _1465_ _1468_ _1118_ reg_file_inst.registry\[0\]\[13\] VGND VGND VPWR
+ VPWR net77 sky130_fd_sc_hd__o32a_1
X_6326_ clknet_leaf_47_clk _0734_ _0259_ VGND VGND VPWR VPWR reg_file_inst.registry\[8\]\[7\]
+ sky130_fd_sc_hd__dfrtp_1
XFILLER_115_273 VGND VGND VPWR VPWR sky130_fd_sc_hd__decap_6
XFILLER_107_57 VPWR VGND VPWR VGND sky130_ef_sc_hd__decap_12
XFILLER_103_424 VGND VGND VPWR VPWR sky130_fd_sc_hd__decap_4
XFILLER_103_402 VGND VGND VPWR VPWR sky130_fd_sc_hd__fill_2
XFILLER_1_529 VPWR VGND VPWR VGND sky130_ef_sc_hd__decap_12
X_6257_ clknet_leaf_36_clk _0665_ _0190_ VGND VGND VPWR VPWR reg_file_inst.registry\[4\]\[22\]
+ sky130_fd_sc_hd__dfrtp_1
X_3469_ _1397_ _1399_ _1401_ VGND VGND VPWR VPWR _1402_ sky130_fd_sc_hd__or3_2
X_5208_ reg_file_inst.registry\[11\]\[22\] _2375_ _2989_ VGND VGND VPWR VPWR _0845_
+ sky130_fd_sc_hd__mux2_1
X_6188_ clknet_leaf_27_clk _0596_ _0121_ VGND VGND VPWR VPWR reg_file_inst.registry\[5\]\[9\]
+ sky130_fd_sc_hd__dfrtp_1
XTAP_TAPCELL_ROW_4_312 VGND VPWR sky130_fd_sc_hd__tapvpwrvgnd_1
X_5139_ _2616_ _2619_ _2620_ VGND VGND VPWR VPWR _2962_ sky130_fd_sc_hd__a21oi_1
XFILLER_72_503 VGND VGND VPWR VPWR sky130_fd_sc_hd__fill_1
XTAP_TAPCELL_ROW_84_1320 VGND VPWR sky130_fd_sc_hd__tapvpwrvgnd_1
XFILLER_72_558 VGND VGND VPWR VPWR sky130_fd_sc_hd__fill_2
XFILLER_25_430 VGND VGND VPWR VPWR sky130_fd_sc_hd__fill_1
XFILLER_44_249 VGND VGND VPWR VPWR sky130_fd_sc_hd__decap_3
XFILLER_52_282 VGND VGND VPWR VPWR sky130_fd_sc_hd__decap_4
XFILLER_9_629 VPWR VGND VPWR VGND sky130_ef_sc_hd__decap_12
XFILLER_40_477 VGND VGND VPWR VPWR sky130_fd_sc_hd__decap_4
XFILLER_32_64 VGND VGND VPWR VPWR sky130_fd_sc_hd__fill_1
XFILLER_32_97 VGND VGND VPWR VPWR sky130_fd_sc_hd__decap_4
XFILLER_106_251 VGND VGND VPWR VPWR sky130_fd_sc_hd__fill_1
XFILLER_4_356 VGND VGND VPWR VPWR sky130_fd_sc_hd__decap_8
XFILLER_95_617 VPWR VGND VPWR VGND sky130_ef_sc_hd__decap_12
XFILLER_94_116 VGND VGND VPWR VPWR sky130_fd_sc_hd__fill_1
XFILLER_0_584 VGND VGND VPWR VPWR sky130_fd_sc_hd__decap_4
XFILLER_48_533 VGND VGND VPWR VPWR sky130_fd_sc_hd__fill_2
XFILLER_48_544 VPWR VGND VPWR VGND sky130_ef_sc_hd__decap_12
XFILLER_63_503 VGND VGND VPWR VPWR sky130_fd_sc_hd__fill_1
XFILLER_63_536 VGND VGND VPWR VPWR sky130_fd_sc_hd__decap_6
XFILLER_16_441 VGND VGND VPWR VPWR sky130_fd_sc_hd__decap_8
XFILLER_35_249 VPWR VGND VPWR VGND sky130_ef_sc_hd__decap_12
XFILLER_92_6 VPWR VGND VPWR VGND sky130_ef_sc_hd__decap_12
XFILLER_43_293 VGND VGND VPWR VPWR sky130_fd_sc_hd__fill_1
XFILLER_31_466 VGND VGND VPWR VPWR sky130_fd_sc_hd__fill_1
XFILLER_117_505 VPWR VGND VPWR VGND sky130_ef_sc_hd__decap_12
X_5490_ JMPOFF\[15\] _2897_ _3000_ VGND VGND VPWR VPWR _0574_ sky130_fd_sc_hd__mux2_1
X_4510_ _1765_ _2392_ VGND VGND VPWR VPWR _2393_ sky130_fd_sc_hd__nand2_1
X_4441_ _1692_ _2282_ _2285_ _1693_ _2325_ VGND VGND VPWR VPWR _2326_ sky130_fd_sc_hd__o221a_1
XPHY_EDGE_ROW_9_Right_9 VGND VGND VPWR VPWR sky130_fd_sc_hd__decap_3
X_6111_ clknet_leaf_18_clk _0519_ _0044_ VGND VGND VPWR VPWR reg_file_inst.registry\[9\]\[16\]
+ sky130_fd_sc_hd__dfrtp_1
X_4372_ _1840_ _2259_ _2258_ VGND VGND VPWR VPWR _2260_ sky130_fd_sc_hd__a21oi_1
XFILLER_112_221 VPWR VGND VPWR VGND sky130_ef_sc_hd__decap_12
XFILLER_98_455 VGND VGND VPWR VPWR sky130_fd_sc_hd__decap_8
X_3323_ MEMOFF\[22\] _1129_ _1130_ JMPOFF\[22\] _1261_ VGND VGND VPWR VPWR _1262_
+ sky130_fd_sc_hd__a221o_1
XFILLER_112_265 VPWR VGND VPWR VGND sky130_ef_sc_hd__decap_12
XPHY_EDGE_ROW_107_Right_107 VGND VGND VPWR VPWR sky130_fd_sc_hd__decap_3
XFILLER_98_477 VGND VGND VPWR VPWR sky130_fd_sc_hd__decap_6
XFILLER_85_105 VGND VGND VPWR VPWR sky130_fd_sc_hd__decap_6
X_6042_ net146 VGND VGND VPWR VPWR _0450_ sky130_fd_sc_hd__inv_2
X_3254_ _1194_ VGND VGND VPWR VPWR _1195_ sky130_fd_sc_hd__inv_2
XFILLER_100_438 VGND VGND VPWR VPWR sky130_fd_sc_hd__fill_1
XTAP_TAPCELL_ROW_107_1607 VGND VPWR sky130_fd_sc_hd__tapvpwrvgnd_1
XFILLER_66_352 VPWR VGND VPWR VGND sky130_ef_sc_hd__decap_12
X_3185_ _1121_ _1127_ VGND VGND VPWR VPWR _1129_ sky130_fd_sc_hd__and2_4
XFILLER_39_577 VGND VGND VPWR VPWR sky130_fd_sc_hd__fill_1
XFILLER_54_514 VGND VGND VPWR VPWR sky130_fd_sc_hd__decap_8
XTAP_TAPCELL_ROW_37_723 VGND VPWR sky130_fd_sc_hd__tapvpwrvgnd_1
XFILLER_81_399 VGND VGND VPWR VPWR sky130_fd_sc_hd__fill_1
XFILLER_81_388 VGND VGND VPWR VPWR sky130_fd_sc_hd__decap_4
XTAP_TAPCELL_ROW_66_1094 VGND VPWR sky130_fd_sc_hd__tapvpwrvgnd_1
XTAP_TAPCELL_ROW_66_1083 VGND VPWR sky130_fd_sc_hd__tapvpwrvgnd_1
XTAP_TAPCELL_ROW_17_480 VGND VPWR sky130_fd_sc_hd__tapvpwrvgnd_1
XFILLER_22_433 VGND VGND VPWR VPWR sky130_fd_sc_hd__decap_4
X_5826_ net148 VGND VGND VPWR VPWR _0234_ sky130_fd_sc_hd__inv_2
XFILLER_22_477 VPWR VGND VPWR VGND sky130_ef_sc_hd__decap_12
X_5757_ net148 VGND VGND VPWR VPWR _0165_ sky130_fd_sc_hd__inv_2
XTAP_TAPCELL_ROW_118_1736 VGND VPWR sky130_fd_sc_hd__tapvpwrvgnd_1
X_4708_ _1162_ _2566_ VGND VGND VPWR VPWR _2567_ sky130_fd_sc_hd__xnor2_1
X_5688_ net148 VGND VGND VPWR VPWR _0096_ sky130_fd_sc_hd__inv_2
X_4639_ _2461_ _2502_ net135 VGND VGND VPWR VPWR _2514_ sky130_fd_sc_hd__mux2_1
X_6309_ clknet_leaf_14_clk _0717_ _0242_ VGND VGND VPWR VPWR reg_file_inst.registry\[3\]\[18\]
+ sky130_fd_sc_hd__dfrtp_1
XFILLER_103_276 VGND VGND VPWR VPWR sky130_fd_sc_hd__decap_4
XFILLER_77_639 VGND VGND VPWR VPWR sky130_fd_sc_hd__fill_2
XFILLER_77_628 VGND VGND VPWR VPWR sky130_fd_sc_hd__fill_1
XTAP_TAPCELL_ROW_90_1390 VGND VPWR sky130_fd_sc_hd__tapvpwrvgnd_1
XFILLER_57_352 VPWR VGND VPWR VGND sky130_ef_sc_hd__decap_12
XFILLER_45_503 VGND VGND VPWR VPWR sky130_fd_sc_hd__fill_1
XFILLER_72_300 VGND VGND VPWR VPWR sky130_fd_sc_hd__decap_8
XFILLER_17_205 VGND VGND VPWR VPWR sky130_fd_sc_hd__fill_2
XFILLER_45_514 VGND VGND VPWR VPWR sky130_fd_sc_hd__decap_3
XFILLER_60_506 VGND VGND VPWR VPWR sky130_fd_sc_hd__decap_8
XFILLER_13_411 VPWR VGND VPWR VGND sky130_ef_sc_hd__decap_12
XFILLER_25_271 VGND VGND VPWR VPWR sky130_fd_sc_hd__decap_8
XFILLER_13_466 VGND VGND VPWR VPWR sky130_fd_sc_hd__fill_1
XFILLER_13_499 VGND VGND VPWR VPWR sky130_fd_sc_hd__decap_4
XFILLER_5_665 VGND VGND VPWR VPWR sky130_fd_sc_hd__decap_6
XFILLER_4_197 VPWR VGND VPWR VGND sky130_ef_sc_hd__decap_12
XFILLER_122_585 VGND VGND VPWR VPWR sky130_fd_sc_hd__decap_3
XFILLER_95_436 VGND VGND VPWR VPWR sky130_fd_sc_hd__fill_1
XFILLER_67_149 VPWR VGND VPWR VGND sky130_ef_sc_hd__decap_12
XFILLER_76_661 VPWR VGND VPWR VGND sky130_ef_sc_hd__decap_12
XFILLER_63_300 VPWR VGND VPWR VGND sky130_ef_sc_hd__decap_12
XFILLER_91_653 VPWR VGND VPWR VGND sky130_ef_sc_hd__decap_12
XFILLER_84_81 VGND VGND VPWR VPWR sky130_fd_sc_hd__decap_3
XFILLER_91_697 VPWR VGND VPWR VGND sky130_ef_sc_hd__decap_12
XFILLER_90_152 VGND VGND VPWR VPWR sky130_fd_sc_hd__fill_1
XFILLER_51_517 VGND VGND VPWR VPWR sky130_fd_sc_hd__decap_6
X_4990_ _1790_ _2776_ VGND VGND VPWR VPWR _2835_ sky130_fd_sc_hd__or2_1
XTAP_TAPCELL_ROW_102_1537 VGND VPWR sky130_fd_sc_hd__tapvpwrvgnd_1
XFILLER_16_282 VGND VGND VPWR VPWR sky130_fd_sc_hd__decap_8
X_3941_ _1765_ _1778_ _1856_ VGND VGND VPWR VPWR _1857_ sky130_fd_sc_hd__o21ai_1
XFILLER_44_580 VGND VGND VPWR VPWR sky130_fd_sc_hd__decap_8
X_3872_ reg_file_inst.registry\[0\]\[2\] net138 _1784_ _1789_ VGND VGND VPWR VPWR
+ _1791_ sky130_fd_sc_hd__o22ai_4
X_5611_ net147 VGND VGND VPWR VPWR _0019_ sky130_fd_sc_hd__inv_2
XTAP_TAPCELL_ROW_42_792 VGND VPWR sky130_fd_sc_hd__tapvpwrvgnd_1
X_5542_ _2829_ reg_file_inst.registry\[9\]\[21\] _3002_ VGND VGND VPWR VPWR _0524_
+ sky130_fd_sc_hd__mux2_1
XFILLER_117_335 VGND VGND VPWR VPWR sky130_fd_sc_hd__fill_1
X_5473_ reg_file_inst.registry\[5\]\[3\] _2478_ _2999_ VGND VGND VPWR VPWR _0590_
+ sky130_fd_sc_hd__mux2_1
X_4424_ net41 _2117_ net101 net26 VGND VGND VPWR VPWR _2310_ sky130_fd_sc_hd__a22o_1
XFILLER_113_541 VPWR VGND VPWR VGND sky130_ef_sc_hd__decap_12
XFILLER_98_241 VGND VGND VPWR VPWR sky130_fd_sc_hd__decap_8
X_4355_ _1151_ _1791_ VGND VGND VPWR VPWR _2243_ sky130_fd_sc_hd__or2_1
XTAP_TAPCELL_ROW_113_1677 VGND VPWR sky130_fd_sc_hd__tapvpwrvgnd_1
XFILLER_101_725 VGND VGND VPWR VPWR sky130_fd_sc_hd__fill_1
XFILLER_59_617 VPWR VGND VPWR VGND sky130_ef_sc_hd__decap_12
XFILLER_59_606 VGND VGND VPWR VPWR sky130_fd_sc_hd__decap_8
X_3306_ reg_file_inst.registry\[14\]\[22\] _1077_ _1080_ VGND VGND VPWR VPWR _1245_
+ sky130_fd_sc_hd__and3_1
XFILLER_113_585 VPWR VGND VPWR VGND sky130_ef_sc_hd__decap_12
XFILLER_58_116 VPWR VGND VPWR VGND sky130_ef_sc_hd__decap_12
X_4286_ _2137_ _2139_ _2173_ VGND VGND VPWR VPWR _2174_ sky130_fd_sc_hd__or3b_1
X_3237_ MEMOFF\[25\] _1079_ _1081_ reg_file_inst.registry\[14\]\[25\] _1178_ VGND
+ VGND VPWR VPWR _1179_ sky130_fd_sc_hd__a221o_1
XFILLER_67_650 VGND VGND VPWR VPWR sky130_fd_sc_hd__decap_4
X_6025_ net148 VGND VGND VPWR VPWR _0433_ sky130_fd_sc_hd__inv_2
XFILLER_39_352 VGND VGND VPWR VPWR sky130_fd_sc_hd__decap_6
XTAP_TAPCELL_ROW_68_1112 VGND VPWR sky130_fd_sc_hd__tapvpwrvgnd_1
XFILLER_27_503 VGND VGND VPWR VPWR sky130_fd_sc_hd__fill_1
X_3168_ net43 _1111_ VGND VGND VPWR VPWR _1112_ sky130_fd_sc_hd__and2_1
XFILLER_66_193 VGND VGND VPWR VPWR sky130_fd_sc_hd__decap_3
XFILLER_64_29 VGND VGND VPWR VPWR sky130_fd_sc_hd__fill_1
XFILLER_15_709 VPWR VGND VPWR VGND sky130_ef_sc_hd__decap_12
XFILLER_54_377 VPWR VGND VPWR VGND sky130_ef_sc_hd__decap_12
XFILLER_42_528 VGND VGND VPWR VPWR sky130_fd_sc_hd__decap_4
X_3099_ JMPOFF\[12\] net141 net41 VGND VGND VPWR VPWR _1043_ sky130_fd_sc_hd__a21o_1
XFILLER_80_17 VGND VGND VPWR VPWR sky130_fd_sc_hd__decap_8
XTAP_TAPCELL_ROW_12_409 VGND VPWR sky130_fd_sc_hd__tapvpwrvgnd_1
XFILLER_22_230 VGND VGND VPWR VPWR sky130_fd_sc_hd__fill_1
X_5809_ net149 VGND VGND VPWR VPWR _0217_ sky130_fd_sc_hd__inv_2
XFILLER_10_403 VPWR VGND VPWR VGND sky130_ef_sc_hd__decap_12
XFILLER_13_55 VGND VGND VPWR VPWR sky130_fd_sc_hd__fill_1
XTAP_TAPCELL_ROW_79_1252 VGND VPWR sky130_fd_sc_hd__tapvpwrvgnd_1
XFILLER_6_418 VGND VGND VPWR VPWR sky130_fd_sc_hd__fill_2
XFILLER_13_77 VGND VGND VPWR VPWR sky130_fd_sc_hd__fill_2
XFILLER_13_99 VPWR VGND VPWR VGND sky130_ef_sc_hd__decap_12
XFILLER_108_357 VGND VGND VPWR VPWR sky130_fd_sc_hd__decap_6
XFILLER_2_613 VPWR VGND VPWR VGND sky130_ef_sc_hd__decap_12
XFILLER_2_657 VPWR VGND VPWR VGND sky130_ef_sc_hd__decap_12
XFILLER_77_458 VGND VGND VPWR VPWR sky130_fd_sc_hd__decap_6
XFILLER_38_52 VGND VGND VPWR VPWR sky130_fd_sc_hd__decap_8
XFILLER_58_672 VGND VGND VPWR VPWR sky130_fd_sc_hd__decap_3
XFILLER_18_514 VPWR VGND VPWR VGND sky130_ef_sc_hd__decap_12
XFILLER_33_517 VGND VGND VPWR VPWR sky130_fd_sc_hd__fill_1
XFILLER_45_388 VGND VGND VPWR VPWR sky130_fd_sc_hd__decap_4
XFILLER_60_347 VPWR VGND VPWR VGND sky130_ef_sc_hd__decap_12
XFILLER_41_550 VGND VGND VPWR VPWR sky130_fd_sc_hd__decap_8
XFILLER_9_245 VPWR VGND VPWR VGND sky130_ef_sc_hd__decap_12
Xclkload26 clknet_leaf_8_clk VGND VGND VPWR VPWR clkload26/Y sky130_fd_sc_hd__inv_6
XFILLER_70_83 VGND VGND VPWR VPWR sky130_fd_sc_hd__fill_1
Xclkload15 clknet_leaf_7_clk VGND VGND VPWR VPWR clkload15/X sky130_fd_sc_hd__clkbuf_4
Xclkload48 clknet_leaf_30_clk VGND VGND VPWR VPWR clkload48/Y sky130_fd_sc_hd__inv_6
Xclkload37 clknet_leaf_57_clk VGND VGND VPWR VPWR clkload37/X sky130_fd_sc_hd__clkbuf_4
XFILLER_96_701 VPWR VGND VPWR VGND sky130_ef_sc_hd__decap_12
X_4140_ JMPOFF\[26\] net141 VGND VGND VPWR VPWR _2056_ sky130_fd_sc_hd__nand2_1
XFILLER_68_414 VGND VGND VPWR VPWR sky130_fd_sc_hd__decap_6
XFILLER_122_393 VPWR VGND VPWR VGND sky130_ef_sc_hd__decap_12
XFILLER_110_533 VPWR VGND VPWR VGND sky130_ef_sc_hd__decap_12
XFILLER_83_406 VPWR VGND VPWR VGND sky130_ef_sc_hd__decap_12
X_4071_ _1974_ _1975_ _1986_ VGND VGND VPWR VPWR _1987_ sky130_fd_sc_hd__a21o_1
X_3022_ net33 _0961_ _0964_ VGND VGND VPWR VPWR _0966_ sky130_fd_sc_hd__nor3_4
XFILLER_36_344 VGND VGND VPWR VPWR sky130_fd_sc_hd__decap_3
XTAP_TAPCELL_ROW_47_851 VGND VPWR sky130_fd_sc_hd__tapvpwrvgnd_1
XFILLER_64_697 VGND VGND VPWR VPWR sky130_fd_sc_hd__decap_3
X_4973_ _1280_ _1294_ _2288_ _2819_ VGND VGND VPWR VPWR _2820_ sky130_fd_sc_hd__o22a_1
XFILLER_36_388 VGND VGND VPWR VPWR sky130_fd_sc_hd__fill_1
XTAP_TAPCELL_ROW_63_1053 VGND VPWR sky130_fd_sc_hd__tapvpwrvgnd_1
X_3924_ reg_file_inst.registry\[0\]\[0\] _1076_ _1834_ _1839_ VGND VGND VPWR VPWR
+ _1841_ sky130_fd_sc_hd__o22ai_4
XFILLER_20_701 VGND VGND VPWR VPWR sky130_fd_sc_hd__decap_4
Xclkload9 clknet_leaf_11_clk VGND VGND VPWR VPWR clkload9/Y sky130_fd_sc_hd__clkinvlp_4
X_3855_ reg_file_inst.registry\[11\]\[3\] _1141_ _1766_ _1768_ _1771_ VGND VGND VPWR
+ VPWR _1775_ sky130_fd_sc_hd__a2111o_1
X_3786_ reg_file_inst.registry\[0\]\[4\] _1076_ _1703_ _1707_ VGND VGND VPWR VPWR
+ _1708_ sky130_fd_sc_hd__o22a_4
XTAP_TAPCELL_ROW_115_1706 VGND VPWR sky130_fd_sc_hd__tapvpwrvgnd_1
X_5525_ reg_file_inst.registry\[6\]\[9\] _2974_ _3001_ VGND VGND VPWR VPWR _0540_
+ sky130_fd_sc_hd__mux2_1
XFILLER_118_699 VGND VGND VPWR VPWR sky130_fd_sc_hd__fill_1
XFILLER_105_305 VPWR VGND VPWR VGND sky130_ef_sc_hd__decap_12
X_5456_ reg_file_inst.registry\[5\]\[20\] _2842_ _2999_ VGND VGND VPWR VPWR _0607_
+ sky130_fd_sc_hd__mux2_1
X_4407_ _1735_ _2294_ VGND VGND VPWR VPWR _2295_ sky130_fd_sc_hd__nor2_4
XFILLER_99_561 VPWR VGND VPWR VGND sky130_ef_sc_hd__decap_12
X_5387_ MEMOFF\[2\] _2501_ _2996_ VGND VGND VPWR VPWR _0673_ sky130_fd_sc_hd__mux2_1
XFILLER_113_393 VPWR VGND VPWR VGND sky130_ef_sc_hd__decap_12
XTAP_TAPCELL_ROW_74_1193 VGND VPWR sky130_fd_sc_hd__tapvpwrvgnd_1
X_4338_ _2224_ _2225_ _1840_ VGND VGND VPWR VPWR _2226_ sky130_fd_sc_hd__mux2_1
XFILLER_115_57 VPWR VGND VPWR VGND sky130_ef_sc_hd__decap_12
X_4269_ _1802_ _2156_ VGND VGND VPWR VPWR _2157_ sky130_fd_sc_hd__nand2_1
X_6008_ net44 VGND VGND VPWR VPWR _0416_ sky130_fd_sc_hd__inv_2
XFILLER_67_480 VGND VGND VPWR VPWR sky130_fd_sc_hd__fill_1
XFILLER_70_601 VPWR VGND VPWR VGND sky130_ef_sc_hd__decap_12
XFILLER_54_141 VPWR VGND VPWR VGND sky130_ef_sc_hd__decap_12
XFILLER_91_27 VGND VGND VPWR VPWR sky130_fd_sc_hd__decap_4
XFILLER_70_645 VPWR VGND VPWR VGND sky130_ef_sc_hd__decap_12
XPHY_EDGE_ROW_59_Left_182 VGND VGND VPWR VPWR sky130_fd_sc_hd__decap_3
XFILLER_23_561 VGND VGND VPWR VPWR sky130_fd_sc_hd__fill_2
XFILLER_23_572 VGND VGND VPWR VPWR sky130_fd_sc_hd__decap_8
XFILLER_24_76 VGND VGND VPWR VPWR sky130_fd_sc_hd__fill_1
XTAP_TAPCELL_ROW_25_578 VGND VPWR sky130_fd_sc_hd__tapvpwrvgnd_1
XFILLER_108_121 VPWR VGND VPWR VGND sky130_ef_sc_hd__decap_12
XFILLER_108_165 VPWR VGND VPWR VGND sky130_ef_sc_hd__decap_12
XFILLER_78_701 VGND VGND VPWR VPWR sky130_fd_sc_hd__decap_4
XPHY_EDGE_ROW_68_Left_191 VGND VGND VPWR VPWR sky130_fd_sc_hd__decap_3
XFILLER_2_465 VGND VGND VPWR VPWR sky130_fd_sc_hd__decap_8
XFILLER_49_40 VPWR VGND VPWR VGND sky130_ef_sc_hd__decap_12
XFILLER_92_236 VGND VGND VPWR VPWR sky130_fd_sc_hd__decap_8
XFILLER_1_69 VPWR VGND VPWR VGND sky130_ef_sc_hd__decap_12
XFILLER_45_163 VGND VGND VPWR VPWR sky130_fd_sc_hd__decap_4
XFILLER_46_664 VGND VGND VPWR VPWR sky130_fd_sc_hd__fill_2
XFILLER_61_645 VGND VGND VPWR VPWR sky130_fd_sc_hd__decap_8
XTAP_TAPCELL_ROW_44_810 VGND VPWR sky130_fd_sc_hd__tapvpwrvgnd_1
XFILLER_60_188 VGND VGND VPWR VPWR sky130_fd_sc_hd__decap_4
X_3640_ _1112_ net74 _1565_ VGND VGND VPWR VPWR _1566_ sky130_fd_sc_hd__o21ai_4
X_3571_ reg_file_inst.registry\[8\]\[14\] _1090_ _1098_ reg_file_inst.registry\[10\]\[14\]
+ VGND VGND VPWR VPWR _1500_ sky130_fd_sc_hd__a22o_1
X_6290_ clknet_leaf_14_clk _0698_ _0223_ VGND VGND VPWR VPWR MEMOFF\[27\] sky130_fd_sc_hd__dfrtp_1
X_5310_ _2829_ reg_file_inst.registry\[8\]\[21\] _2994_ VGND VGND VPWR VPWR _0748_
+ sky130_fd_sc_hd__mux2_1
XFILLER_53_3 VGND VGND VPWR VPWR sky130_fd_sc_hd__decap_4
XFILLER_5_281 VPWR VGND VPWR VGND sky130_ef_sc_hd__decap_12
X_5241_ _2501_ reg_file_inst.registry\[1\]\[2\] _2990_ VGND VGND VPWR VPWR _0813_
+ sky130_fd_sc_hd__mux2_1
XTAP_TAPCELL_ROW_110_1636 VGND VPWR sky130_fd_sc_hd__tapvpwrvgnd_1
X_5172_ reg_file_inst.registry\[7\]\[3\] _2478_ _2553_ VGND VGND VPWR VPWR _0878_
+ sky130_fd_sc_hd__mux2_1
XFILLER_96_553 VGND VGND VPWR VPWR sky130_fd_sc_hd__fill_2
X_4123_ _0978_ _2038_ _0984_ VGND VGND VPWR VPWR _2039_ sky130_fd_sc_hd__a21o_1
XFILLER_110_363 VGND VGND VPWR VPWR sky130_fd_sc_hd__fill_1
XFILLER_68_277 VPWR VGND VPWR VGND sky130_ef_sc_hd__decap_12
Xinput2 DataMemoryRead[10] VGND VGND VPWR VPWR net2 sky130_fd_sc_hd__buf_1
X_4054_ _1940_ _1943_ VGND VGND VPWR VPWR _1970_ sky130_fd_sc_hd__nand2_1
XFILLER_83_225 VGND VGND VPWR VPWR sky130_fd_sc_hd__decap_8
X_3005_ net110 VGND VGND VPWR VPWR _0951_ sky130_fd_sc_hd__inv_2
XFILLER_37_620 VGND VGND VPWR VPWR sky130_fd_sc_hd__decap_6
XFILLER_101_15 VPWR VGND VPWR VGND sky130_ef_sc_hd__decap_12
XFILLER_64_472 VGND VGND VPWR VPWR sky130_fd_sc_hd__decap_4
XFILLER_52_645 VPWR VGND VPWR VGND sky130_ef_sc_hd__decap_12
XFILLER_37_697 VGND VGND VPWR VPWR sky130_fd_sc_hd__decap_8
XTAP_TAPCELL_ROW_121_1776 VGND VPWR sky130_fd_sc_hd__tapvpwrvgnd_1
X_4956_ net16 net101 net60 _2308_ VGND VGND VPWR VPWR _2806_ sky130_fd_sc_hd__a22o_4
X_4887_ _2742_ _2743_ _1816_ VGND VGND VPWR VPWR _2744_ sky130_fd_sc_hd__mux2_1
XTAP_TAPCELL_ROW_22_537 VGND VPWR sky130_fd_sc_hd__tapvpwrvgnd_1
X_3907_ reg_file_inst.registry\[9\]\[1\] _1131_ _1142_ reg_file_inst.registry\[1\]\[1\]
+ _1818_ VGND VGND VPWR VPWR _1825_ sky130_fd_sc_hd__a221o_1
X_3838_ reg_file_inst.registry\[10\]\[3\] _1080_ _1088_ _1093_ reg_file_inst.registry\[15\]\[3\]
+ VGND VGND VPWR VPWR _1758_ sky130_fd_sc_hd__a32o_1
XFILLER_106_625 VPWR VGND VPWR VGND sky130_ef_sc_hd__decap_12
X_5508_ reg_file_inst.registry\[6\]\[26\] _2747_ _3001_ VGND VGND VPWR VPWR _0557_
+ sky130_fd_sc_hd__mux2_1
XTAP_TAPCELL_ROW_76_1211 VGND VPWR sky130_fd_sc_hd__tapvpwrvgnd_1
X_3769_ _1683_ _1685_ _1691_ _1118_ reg_file_inst.registry\[0\]\[6\] VGND VGND VPWR
+ VPWR net97 sky130_fd_sc_hd__o32a_2
XFILLER_105_113 VPWR VGND VPWR VGND sky130_ef_sc_hd__decap_12
X_6488_ clknet_leaf_42_clk _0896_ _0421_ VGND VGND VPWR VPWR reg_file_inst.registry\[7\]\[21\]
+ sky130_fd_sc_hd__dfrtp_1
XFILLER_121_617 VPWR VGND VPWR VGND sky130_ef_sc_hd__decap_12
XFILLER_106_669 VPWR VGND VPWR VGND sky130_ef_sc_hd__decap_12
X_5439_ _2986_ reg_file_inst.registry\[10\]\[8\] _2998_ VGND VGND VPWR VPWR _0623_
+ sky130_fd_sc_hd__mux2_1
XFILLER_87_520 VPWR VGND VPWR VGND sky130_ef_sc_hd__decap_12
XFILLER_86_38 VPWR VGND VPWR VGND sky130_ef_sc_hd__decap_12
XFILLER_86_27 VGND VGND VPWR VPWR sky130_fd_sc_hd__fill_1
XFILLER_99_391 VGND VGND VPWR VPWR sky130_fd_sc_hd__fill_1
XFILLER_59_266 VGND VGND VPWR VPWR sky130_fd_sc_hd__decap_6
XTAP_TAPCELL_ROW_87_1351 VGND VPWR sky130_fd_sc_hd__tapvpwrvgnd_1
XTAP_TAPCELL_ROW_2_295 VGND VPWR sky130_fd_sc_hd__tapvpwrvgnd_1
XTAP_TAPCELL_ROW_2_284 VGND VPWR sky130_fd_sc_hd__tapvpwrvgnd_1
XFILLER_28_686 VGND VGND VPWR VPWR sky130_fd_sc_hd__decap_3
XFILLER_15_347 VGND VGND VPWR VPWR sky130_fd_sc_hd__decap_6
XFILLER_42_177 VPWR VGND VPWR VGND sky130_ef_sc_hd__decap_12
XFILLER_23_391 VGND VGND VPWR VPWR sky130_fd_sc_hd__fill_1
XFILLER_7_502 VGND VGND VPWR VPWR sky130_fd_sc_hd__fill_2
XFILLER_109_441 VGND VGND VPWR VPWR sky130_fd_sc_hd__decap_6
XFILLER_11_597 VPWR VGND VPWR VGND sky130_ef_sc_hd__decap_12
XTAP_TAPCELL_ROW_98_1491 VGND VPWR sky130_fd_sc_hd__tapvpwrvgnd_1
XFILLER_109_485 VPWR VGND VPWR VGND sky130_ef_sc_hd__decap_12
XFILLER_111_105 VGND VGND VPWR VPWR sky130_fd_sc_hd__decap_6
XFILLER_111_149 VPWR VGND VPWR VGND sky130_ef_sc_hd__decap_12
XFILLER_78_531 VGND VGND VPWR VPWR sky130_fd_sc_hd__fill_1
XFILLER_2_284 VGND VGND VPWR VPWR sky130_fd_sc_hd__fill_1
XFILLER_93_512 VGND VGND VPWR VPWR sky130_fd_sc_hd__fill_1
XFILLER_65_225 VPWR VGND VPWR VGND sky130_ef_sc_hd__decap_12
XFILLER_65_258 VGND VGND VPWR VPWR sky130_fd_sc_hd__decap_4
XFILLER_18_141 VPWR VGND VPWR VGND sky130_ef_sc_hd__decap_12
XFILLER_46_461 VPWR VGND VPWR VGND sky130_ef_sc_hd__decap_12
XFILLER_80_228 VGND VGND VPWR VPWR sky130_fd_sc_hd__fill_1
XFILLER_61_431 VPWR VGND VPWR VGND sky130_ef_sc_hd__decap_12
X_4810_ _1392_ _2654_ _2664_ _1417_ VGND VGND VPWR VPWR _2669_ sky130_fd_sc_hd__a22o_1
XFILLER_61_497 VGND VGND VPWR VPWR sky130_fd_sc_hd__decap_6
X_5790_ net147 VGND VGND VPWR VPWR _0198_ sky130_fd_sc_hd__inv_2
XFILLER_33_177 VGND VGND VPWR VPWR sky130_fd_sc_hd__decap_3
XTAP_TAPCELL_ROW_60_1012 VGND VPWR sky130_fd_sc_hd__tapvpwrvgnd_1
X_4741_ _2585_ _2599_ VGND VGND VPWR VPWR _2600_ sky130_fd_sc_hd__nor2_1
XFILLER_14_391 VGND VGND VPWR VPWR sky130_fd_sc_hd__decap_6
XFILLER_119_205 VPWR VGND VPWR VGND sky130_ef_sc_hd__decap_12
X_4672_ _2245_ _2450_ _2243_ VGND VGND VPWR VPWR _2545_ sky130_fd_sc_hd__o21ai_1
XFILLER_119_249 VPWR VGND VPWR VGND sky130_ef_sc_hd__decap_12
X_3623_ reg_file_inst.registry\[3\]\[10\] _1091_ _1548_ _1549_ VGND VGND VPWR VPWR
+ _1550_ sky130_fd_sc_hd__a211o_1
X_6411_ clknet_leaf_50_clk _0819_ _0344_ VGND VGND VPWR VPWR reg_file_inst.registry\[1\]\[8\]
+ sky130_fd_sc_hd__dfrtp_1
X_6342_ clknet_leaf_33_clk _0750_ _0275_ VGND VGND VPWR VPWR reg_file_inst.registry\[8\]\[23\]
+ sky130_fd_sc_hd__dfrtp_1
X_3554_ reg_file_inst.registry\[7\]\[15\] _1133_ _1142_ reg_file_inst.registry\[1\]\[15\]
+ VGND VGND VPWR VPWR _1484_ sky130_fd_sc_hd__a22o_1
XFILLER_103_617 VPWR VGND VPWR VGND sky130_ef_sc_hd__decap_12
X_3485_ MEMOFF\[17\] net81 _1113_ VGND VGND VPWR VPWR _1417_ sky130_fd_sc_hd__mux2_4
X_6273_ clknet_leaf_27_clk _0681_ _0206_ VGND VGND VPWR VPWR MEMOFF\[10\] sky130_fd_sc_hd__dfrtp_1
X_5224_ _2854_ reg_file_inst.registry\[1\]\[19\] _2990_ VGND VGND VPWR VPWR _0830_
+ sky130_fd_sc_hd__mux2_1
XFILLER_88_317 VGND VGND VPWR VPWR sky130_fd_sc_hd__fill_1
XTAP_TAPCELL_ROW_71_1152 VGND VPWR sky130_fd_sc_hd__tapvpwrvgnd_1
XFILLER_69_542 VPWR VGND VPWR VGND sky130_ef_sc_hd__decap_12
XFILLER_84_501 VPWR VGND VPWR VGND sky130_ef_sc_hd__decap_12
XFILLER_57_715 VGND VGND VPWR VPWR sky130_fd_sc_hd__decap_8
X_5155_ net137 _2540_ VGND VGND VPWR VPWR _2976_ sky130_fd_sc_hd__nand2_1
XFILLER_96_394 VGND VGND VPWR VPWR sky130_fd_sc_hd__decap_6
X_4106_ _0976_ _1068_ _0982_ VGND VGND VPWR VPWR _2022_ sky130_fd_sc_hd__a21oi_1
XFILLER_56_247 VGND VGND VPWR VPWR sky130_fd_sc_hd__fill_2
X_5086_ _1470_ _2286_ _2914_ _2916_ VGND VGND VPWR VPWR _2917_ sky130_fd_sc_hd__a211o_1
XFILLER_84_589 VGND VGND VPWR VPWR sky130_fd_sc_hd__decap_4
XFILLER_84_578 VGND VGND VPWR VPWR sky130_fd_sc_hd__fill_1
X_4037_ _1007_ _1009_ _1011_ VGND VGND VPWR VPWR _1953_ sky130_fd_sc_hd__a21oi_1
XTAP_TAPCELL_ROW_27_607 VGND VPWR sky130_fd_sc_hd__tapvpwrvgnd_1
XTAP_TAPCELL_ROW_55_949 VGND VPWR sky130_fd_sc_hd__tapvpwrvgnd_1
XFILLER_37_494 VGND VGND VPWR VPWR sky130_fd_sc_hd__decap_8
XFILLER_52_453 VGND VGND VPWR VPWR sky130_fd_sc_hd__decap_4
X_5988_ net149 VGND VGND VPWR VPWR _0396_ sky130_fd_sc_hd__inv_2
XFILLER_25_689 VGND VGND VPWR VPWR sky130_fd_sc_hd__fill_2
XTAP_TAPCELL_ROW_82_1292 VGND VPWR sky130_fd_sc_hd__tapvpwrvgnd_1
X_4939_ _2593_ _2788_ _2589_ VGND VGND VPWR VPWR _2790_ sky130_fd_sc_hd__a21oi_1
XFILLER_4_516 VPWR VGND VPWR VGND sky130_ef_sc_hd__decap_12
XFILLER_20_394 VPWR VGND VPWR VGND sky130_ef_sc_hd__decap_12
XFILLER_21_55 VGND VGND VPWR VPWR sky130_fd_sc_hd__fill_1
XFILLER_106_433 VPWR VGND VPWR VGND sky130_ef_sc_hd__decap_12
XFILLER_97_15 VPWR VGND VPWR VGND sky130_ef_sc_hd__decap_12
XFILLER_21_99 VPWR VGND VPWR VGND sky130_ef_sc_hd__decap_12
XFILLER_106_477 VPWR VGND VPWR VGND sky130_ef_sc_hd__decap_12
XFILLER_121_447 VGND VGND VPWR VPWR sky130_fd_sc_hd__fill_1
XTAP_TAPCELL_ROW_7_354 VGND VPWR sky130_fd_sc_hd__tapvpwrvgnd_1
XFILLER_94_309 VPWR VGND VPWR VGND sky130_ef_sc_hd__decap_12
XFILLER_75_545 VPWR VGND VPWR VGND sky130_ef_sc_hd__decap_12
XFILLER_47_225 VGND VGND VPWR VPWR sky130_fd_sc_hd__decap_6
XFILLER_46_85 VPWR VGND VPWR VGND sky130_ef_sc_hd__decap_12
XFILLER_31_604 VGND VGND VPWR VPWR sky130_fd_sc_hd__decap_3
XFILLER_30_169 VGND VGND VPWR VPWR sky130_fd_sc_hd__fill_2
XFILLER_117_709 VPWR VGND VPWR VGND sky130_ef_sc_hd__decap_12
XFILLER_7_57 VPWR VGND VPWR VGND sky130_ef_sc_hd__decap_12
XFILLER_109_293 VPWR VGND VPWR VGND sky130_ef_sc_hd__decap_12
XFILLER_98_637 VGND VGND VPWR VPWR sky130_fd_sc_hd__decap_6
X_3270_ JMPOFF\[24\] _1130_ _1133_ reg_file_inst.registry\[7\]\[24\] _1117_ VGND VGND
+ VPWR VPWR _1211_ sky130_fd_sc_hd__a221o_1
XFILLER_112_469 VGND VGND VPWR VPWR sky130_fd_sc_hd__decap_6
XFILLER_97_169 VPWR VGND VPWR VGND sky130_ef_sc_hd__decap_12
XFILLER_66_501 VGND VGND VPWR VPWR sky130_fd_sc_hd__fill_1
XFILLER_53_217 VGND VGND VPWR VPWR sky130_fd_sc_hd__decap_6
X_5911_ net147 VGND VGND VPWR VPWR _0319_ sky130_fd_sc_hd__inv_2
XFILLER_81_559 VGND VGND VPWR VPWR sky130_fd_sc_hd__fill_1
XTAP_TAPCELL_ROW_52_908 VGND VPWR sky130_fd_sc_hd__tapvpwrvgnd_1
XTAP_TAPCELL_ROW_105_1579 VGND VPWR sky130_fd_sc_hd__tapvpwrvgnd_1
X_5842_ net147 VGND VGND VPWR VPWR _0250_ sky130_fd_sc_hd__inv_2
XTAP_TAPCELL_ROW_52_919 VGND VPWR sky130_fd_sc_hd__tapvpwrvgnd_1
XFILLER_21_125 VPWR VGND VPWR VGND sky130_ef_sc_hd__decap_12
X_5773_ net147 VGND VGND VPWR VPWR _0181_ sky130_fd_sc_hd__inv_2
X_4724_ _1267_ _2581_ VGND VGND VPWR VPWR _2583_ sky130_fd_sc_hd__xnor2_1
XTAP_TAPCELL_ROW_32_665 VGND VPWR sky130_fd_sc_hd__tapvpwrvgnd_1
X_4655_ reg_file_inst.registry\[11\]\[1\] _2528_ _2122_ VGND VGND VPWR VPWR _0916_
+ sky130_fd_sc_hd__mux2_1
X_4586_ _1764_ _2460_ _2464_ _1708_ VGND VGND VPWR VPWR _2465_ sky130_fd_sc_hd__a211o_1
X_3606_ MEMOFF\[11\] _1129_ _1135_ reg_file_inst.registry\[6\]\[11\] _1117_ VGND VGND
+ VPWR VPWR _1534_ sky130_fd_sc_hd__a221o_1
X_3537_ reg_file_inst.registry\[9\]\[13\] _1131_ _1462_ _1466_ _1467_ VGND VGND VPWR
+ VPWR _1468_ sky130_fd_sc_hd__a2111o_1
X_6325_ clknet_leaf_4_clk _0733_ _0258_ VGND VGND VPWR VPWR reg_file_inst.registry\[8\]\[6\]
+ sky130_fd_sc_hd__dfrtp_1
XFILLER_107_69 VPWR VGND VPWR VGND sky130_ef_sc_hd__decap_12
X_6256_ clknet_leaf_37_clk _0664_ _0189_ VGND VGND VPWR VPWR reg_file_inst.registry\[4\]\[21\]
+ sky130_fd_sc_hd__dfrtp_1
X_3468_ MEMOFF\[17\] _1079_ _1095_ JMPOFF\[17\] _1400_ VGND VGND VPWR VPWR _1401_
+ sky130_fd_sc_hd__a221o_1
X_3399_ reg_file_inst.registry\[11\]\[19\] _1119_ net144 VGND VGND VPWR VPWR _1335_
+ sky130_fd_sc_hd__and3_1
X_5207_ reg_file_inst.registry\[11\]\[23\] _2311_ _2989_ VGND VGND VPWR VPWR _0846_
+ sky130_fd_sc_hd__mux2_1
XFILLER_76_309 VGND VGND VPWR VPWR sky130_fd_sc_hd__fill_2
XTAP_TAPCELL_ROW_4_313 VGND VPWR sky130_fd_sc_hd__tapvpwrvgnd_1
XFILLER_29_203 VGND VGND VPWR VPWR sky130_fd_sc_hd__decap_6
X_6187_ clknet_leaf_50_clk _0595_ _0120_ VGND VGND VPWR VPWR reg_file_inst.registry\[5\]\[8\]
+ sky130_fd_sc_hd__dfrtp_1
X_5138_ _2616_ _2619_ _2620_ VGND VGND VPWR VPWR _2961_ sky130_fd_sc_hd__and3_1
XFILLER_29_225 VGND VGND VPWR VPWR sky130_fd_sc_hd__decap_6
XTAP_TAPCELL_ROW_84_1310 VGND VPWR sky130_fd_sc_hd__tapvpwrvgnd_1
X_5069_ net137 _2365_ VGND VGND VPWR VPWR _2902_ sky130_fd_sc_hd__or2_1
XFILLER_52_250 VGND VGND VPWR VPWR sky130_fd_sc_hd__fill_2
XFILLER_52_272 VGND VGND VPWR VPWR sky130_fd_sc_hd__fill_1
XFILLER_40_445 VPWR VGND VPWR VGND sky130_ef_sc_hd__decap_12
XFILLER_20_191 VGND VGND VPWR VPWR sky130_fd_sc_hd__decap_4
XFILLER_4_302 VGND VGND VPWR VPWR sky130_fd_sc_hd__decap_6
XTAP_TAPCELL_ROW_95_1450 VGND VPWR sky130_fd_sc_hd__tapvpwrvgnd_1
XFILLER_122_701 VPWR VGND VPWR VGND sky130_ef_sc_hd__decap_12
XFILLER_95_629 VPWR VGND VPWR VGND sky130_ef_sc_hd__decap_12
XFILLER_79_169 VGND VGND VPWR VPWR sky130_fd_sc_hd__decap_6
XFILLER_67_309 VGND VGND VPWR VPWR sky130_fd_sc_hd__fill_1
XFILLER_88_681 VPWR VGND VPWR VGND sky130_ef_sc_hd__decap_12
XFILLER_48_556 VPWR VGND VPWR VGND sky130_ef_sc_hd__decap_12
XFILLER_48_589 VPWR VGND VPWR VGND sky130_ef_sc_hd__decap_12
XFILLER_90_356 VGND VGND VPWR VPWR sky130_fd_sc_hd__decap_8
XFILLER_63_559 VGND VGND VPWR VPWR sky130_fd_sc_hd__fill_1
XFILLER_28_291 VGND VGND VPWR VPWR sky130_fd_sc_hd__decap_6
XFILLER_73_50 VGND VGND VPWR VPWR sky130_fd_sc_hd__decap_3
XFILLER_16_475 VGND VGND VPWR VPWR sky130_fd_sc_hd__fill_1
XFILLER_117_517 VPWR VGND VPWR VGND sky130_ef_sc_hd__decap_12
X_4440_ _1679_ _1692_ _2324_ VGND VGND VPWR VPWR _2325_ sky130_fd_sc_hd__o21ai_1
X_6110_ clknet_leaf_13_clk _0518_ _0043_ VGND VGND VPWR VPWR reg_file_inst.registry\[9\]\[15\]
+ sky130_fd_sc_hd__dfrtp_1
X_4371_ _1852_ _2190_ VGND VGND VPWR VPWR _2259_ sky130_fd_sc_hd__nand2_1
XFILLER_112_233 VPWR VGND VPWR VGND sky130_ef_sc_hd__decap_12
X_3322_ reg_file_inst.registry\[15\]\[22\] _1122_ _1133_ reg_file_inst.registry\[7\]\[22\]
+ _1117_ VGND VGND VPWR VPWR _1261_ sky130_fd_sc_hd__a221o_1
XFILLER_112_277 VPWR VGND VPWR VGND sky130_ef_sc_hd__decap_12
X_3253_ MEMOFF\[25\] net90 _1113_ VGND VGND VPWR VPWR _1194_ sky130_fd_sc_hd__mux2_4
XFILLER_79_670 VGND VGND VPWR VPWR sky130_fd_sc_hd__fill_2
XFILLER_58_309 VPWR VGND VPWR VGND sky130_ef_sc_hd__decap_12
X_6041_ net146 VGND VGND VPWR VPWR _0449_ sky130_fd_sc_hd__inv_2
XPHY_EDGE_ROW_13_Left_136 VGND VGND VPWR VPWR sky130_fd_sc_hd__decap_3
X_3184_ net29 _0957_ VGND VGND VPWR VPWR _1128_ sky130_fd_sc_hd__nand2_4
XFILLER_39_556 VGND VGND VPWR VPWR sky130_fd_sc_hd__decap_4
XFILLER_26_217 VGND VGND VPWR VPWR sky130_fd_sc_hd__decap_6
XTAP_TAPCELL_ROW_37_724 VGND VPWR sky130_fd_sc_hd__tapvpwrvgnd_1
XTAP_TAPCELL_ROW_66_1095 VGND VPWR sky130_fd_sc_hd__tapvpwrvgnd_1
XTAP_TAPCELL_ROW_66_1084 VGND VPWR sky130_fd_sc_hd__tapvpwrvgnd_1
XFILLER_62_581 VGND VGND VPWR VPWR sky130_fd_sc_hd__decap_6
X_5825_ net148 VGND VGND VPWR VPWR _0233_ sky130_fd_sc_hd__inv_2
XTAP_TAPCELL_ROW_17_481 VGND VPWR sky130_fd_sc_hd__tapvpwrvgnd_1
XPHY_EDGE_ROW_22_Left_145 VGND VGND VPWR VPWR sky130_fd_sc_hd__decap_3
XFILLER_22_467 VGND VGND VPWR VPWR sky130_fd_sc_hd__decap_8
X_5756_ net149 VGND VGND VPWR VPWR _0164_ sky130_fd_sc_hd__inv_2
XFILLER_22_489 VPWR VGND VPWR VGND sky130_ef_sc_hd__decap_12
XTAP_TAPCELL_ROW_118_1737 VGND VPWR sky130_fd_sc_hd__tapvpwrvgnd_1
X_4707_ _1185_ _2126_ _2565_ VGND VGND VPWR VPWR _2566_ sky130_fd_sc_hd__o21ai_1
X_5687_ net148 VGND VGND VPWR VPWR _0095_ sky130_fd_sc_hd__inv_2
X_4638_ _2279_ _2512_ _2510_ VGND VGND VPWR VPWR _2513_ sky130_fd_sc_hd__a21o_1
XFILLER_104_701 VPWR VGND VPWR VGND sky130_ef_sc_hd__decap_12
XFILLER_1_305 VGND VGND VPWR VPWR sky130_fd_sc_hd__decap_4
X_4569_ _2356_ _2367_ _1816_ VGND VGND VPWR VPWR _2450_ sky130_fd_sc_hd__mux2_1
XFILLER_103_222 VGND VGND VPWR VPWR sky130_fd_sc_hd__fill_2
XFILLER_89_445 VGND VGND VPWR VPWR sky130_fd_sc_hd__decap_3
XFILLER_89_434 VGND VGND VPWR VPWR sky130_fd_sc_hd__decap_3
X_6308_ clknet_leaf_25_clk _0716_ _0241_ VGND VGND VPWR VPWR reg_file_inst.registry\[3\]\[17\]
+ sky130_fd_sc_hd__dfrtp_1
XPHY_EDGE_ROW_31_Left_154 VGND VGND VPWR VPWR sky130_fd_sc_hd__decap_3
X_6239_ clknet_leaf_50_clk _0647_ _0172_ VGND VGND VPWR VPWR reg_file_inst.registry\[4\]\[4\]
+ sky130_fd_sc_hd__dfrtp_1
XTAP_TAPCELL_ROW_90_1391 VGND VPWR sky130_fd_sc_hd__tapvpwrvgnd_1
XFILLER_76_139 VGND VGND VPWR VPWR sky130_fd_sc_hd__fill_1
XFILLER_85_651 VPWR VGND VPWR VGND sky130_ef_sc_hd__decap_12
XFILLER_85_673 VPWR VGND VPWR VGND sky130_ef_sc_hd__decap_12
XFILLER_57_364 VGND VGND VPWR VPWR sky130_fd_sc_hd__decap_3
XFILLER_32_209 VPWR VGND VPWR VGND sky130_ef_sc_hd__decap_12
XPHY_EDGE_ROW_40_Left_163 VGND VGND VPWR VPWR sky130_fd_sc_hd__decap_3
XFILLER_13_423 VGND VGND VPWR VPWR sky130_fd_sc_hd__decap_8
XFILLER_41_721 VGND VGND VPWR VPWR sky130_fd_sc_hd__decap_4
XFILLER_40_242 VGND VGND VPWR VPWR sky130_fd_sc_hd__decap_8
XFILLER_40_253 VGND VGND VPWR VPWR sky130_fd_sc_hd__decap_8
XFILLER_9_449 VPWR VGND VPWR VGND sky130_ef_sc_hd__decap_12
XFILLER_107_561 VPWR VGND VPWR VGND sky130_ef_sc_hd__decap_12
XFILLER_4_154 VGND VGND VPWR VPWR sky130_fd_sc_hd__decap_8
XFILLER_68_61 VGND VGND VPWR VPWR sky130_fd_sc_hd__decap_8
XFILLER_76_651 VGND VGND VPWR VPWR sky130_fd_sc_hd__decap_6
XFILLER_0_393 VGND VGND VPWR VPWR sky130_fd_sc_hd__decap_4
XFILLER_76_673 VPWR VGND VPWR VGND sky130_ef_sc_hd__decap_12
XFILLER_63_312 VGND VGND VPWR VPWR sky130_fd_sc_hd__decap_6
XFILLER_91_665 VGND VGND VPWR VPWR sky130_fd_sc_hd__decap_6
XFILLER_63_356 VGND VGND VPWR VPWR sky130_fd_sc_hd__decap_4
X_3940_ _1765_ _1778_ net136 _1802_ VGND VGND VPWR VPWR _1856_ sky130_fd_sc_hd__a211o_1
XFILLER_90_197 VPWR VGND VPWR VGND sky130_ef_sc_hd__decap_12
XTAP_TAPCELL_ROW_102_1538 VGND VPWR sky130_fd_sc_hd__tapvpwrvgnd_1
XTAP_TAPCELL_ROW_14_440 VGND VPWR sky130_fd_sc_hd__tapvpwrvgnd_1
X_3871_ reg_file_inst.registry\[0\]\[2\] net138 _1784_ _1789_ VGND VGND VPWR VPWR
+ _1790_ sky130_fd_sc_hd__o22a_4
XFILLER_83_3 VGND VGND VPWR VPWR sky130_fd_sc_hd__decap_4
X_5610_ net147 VGND VGND VPWR VPWR _0018_ sky130_fd_sc_hd__inv_2
X_5541_ _2817_ reg_file_inst.registry\[9\]\[22\] _3002_ VGND VGND VPWR VPWR _0525_
+ sky130_fd_sc_hd__mux2_1
XFILLER_31_297 VPWR VGND VPWR VGND sky130_ef_sc_hd__decap_12
XTAP_TAPCELL_ROW_42_793 VGND VPWR sky130_fd_sc_hd__tapvpwrvgnd_1
X_5472_ reg_file_inst.registry\[5\]\[4\] _2455_ _2999_ VGND VGND VPWR VPWR _0591_
+ sky130_fd_sc_hd__mux2_1
XFILLER_99_721 VGND VGND VPWR VPWR sky130_fd_sc_hd__decap_4
X_4423_ _2309_ VGND VGND VPWR VPWR net101 sky130_fd_sc_hd__clkinv_16
X_4354_ _2239_ _2241_ _1816_ VGND VGND VPWR VPWR _2242_ sky130_fd_sc_hd__mux2_1
XFILLER_113_553 VGND VGND VPWR VPWR sky130_fd_sc_hd__decap_6
XTAP_TAPCELL_ROW_113_1678 VGND VPWR sky130_fd_sc_hd__tapvpwrvgnd_1
XFILLER_98_253 VPWR VGND VPWR VGND sky130_ef_sc_hd__decap_12
XFILLER_59_629 VGND VGND VPWR VPWR sky130_fd_sc_hd__decap_4
X_3305_ _1231_ _1242_ VGND VGND VPWR VPWR _1244_ sky130_fd_sc_hd__xor2_1
XFILLER_113_597 VPWR VGND VPWR VGND sky130_ef_sc_hd__decap_12
XFILLER_100_203 VGND VGND VPWR VPWR sky130_fd_sc_hd__fill_1
XFILLER_98_286 VPWR VGND VPWR VGND sky130_ef_sc_hd__decap_12
XFILLER_58_128 VPWR VGND VPWR VGND sky130_ef_sc_hd__decap_12
X_4285_ _2142_ _2145_ _2172_ VGND VGND VPWR VPWR _2173_ sky130_fd_sc_hd__nand3_1
X_6024_ net149 VGND VGND VPWR VPWR _0432_ sky130_fd_sc_hd__inv_2
XFILLER_100_247 VGND VGND VPWR VPWR sky130_fd_sc_hd__decap_4
X_3236_ reg_file_inst.registry\[3\]\[25\] _1091_ _1093_ reg_file_inst.registry\[15\]\[25\]
+ VGND VGND VPWR VPWR _1178_ sky130_fd_sc_hd__a22o_1
XTAP_TAPCELL_ROW_68_1113 VGND VPWR sky130_fd_sc_hd__tapvpwrvgnd_1
XFILLER_67_673 VPWR VGND VPWR VGND sky130_ef_sc_hd__decap_12
XFILLER_54_301 VGND VGND VPWR VPWR sky130_fd_sc_hd__decap_6
X_3167_ net31 net30 net32 _0963_ VGND VGND VPWR VPWR _1111_ sky130_fd_sc_hd__and4_2
XFILLER_82_643 VGND VGND VPWR VPWR sky130_fd_sc_hd__fill_1
X_3098_ JMPOFF\[12\] _0967_ VGND VGND VPWR VPWR _1042_ sky130_fd_sc_hd__nand2_1
XFILLER_42_518 VGND VGND VPWR VPWR sky130_fd_sc_hd__fill_1
XFILLER_54_389 VGND VGND VPWR VPWR sky130_fd_sc_hd__fill_2
XFILLER_80_29 VGND VGND VPWR VPWR sky130_fd_sc_hd__decap_3
X_5808_ net149 VGND VGND VPWR VPWR _0216_ sky130_fd_sc_hd__inv_2
XFILLER_10_415 VGND VGND VPWR VPWR sky130_fd_sc_hd__decap_4
XFILLER_22_253 VGND VGND VPWR VPWR sky130_fd_sc_hd__decap_3
XFILLER_22_264 VGND VGND VPWR VPWR sky130_fd_sc_hd__decap_8
XFILLER_50_573 VPWR VGND VPWR VGND sky130_ef_sc_hd__decap_12
X_5739_ net146 VGND VGND VPWR VPWR _0147_ sky130_fd_sc_hd__inv_2
XTAP_TAPCELL_ROW_79_1253 VGND VPWR sky130_fd_sc_hd__tapvpwrvgnd_1
XTAP_TAPCELL_ROW_92_1420 VGND VPWR sky130_fd_sc_hd__tapvpwrvgnd_1
XFILLER_104_520 VPWR VGND VPWR VGND sky130_ef_sc_hd__decap_12
XFILLER_2_625 VPWR VGND VPWR VGND sky130_ef_sc_hd__decap_12
XFILLER_2_669 VPWR VGND VPWR VGND sky130_ef_sc_hd__decap_12
XFILLER_49_139 VGND VGND VPWR VPWR sky130_fd_sc_hd__decap_3
XFILLER_92_429 VGND VGND VPWR VPWR sky130_fd_sc_hd__decap_4
XFILLER_18_526 VGND VGND VPWR VPWR sky130_fd_sc_hd__decap_6
XFILLER_73_654 VPWR VGND VPWR VGND sky130_ef_sc_hd__decap_12
XFILLER_45_356 VGND VGND VPWR VPWR sky130_fd_sc_hd__decap_4
XFILLER_73_698 VGND VGND VPWR VPWR sky130_fd_sc_hd__fill_1
XFILLER_72_197 VGND VGND VPWR VPWR sky130_fd_sc_hd__decap_8
XFILLER_26_581 VGND VGND VPWR VPWR sky130_fd_sc_hd__decap_6
XFILLER_60_359 VGND VGND VPWR VPWR sky130_fd_sc_hd__decap_4
XFILLER_9_257 VPWR VGND VPWR VGND sky130_ef_sc_hd__decap_12
XFILLER_13_286 VPWR VGND VPWR VGND sky130_ef_sc_hd__decap_12
Xclkload16 clknet_leaf_59_clk VGND VGND VPWR VPWR clkload16/Y sky130_fd_sc_hd__clkinv_4
Xclkload27 clknet_leaf_21_clk VGND VGND VPWR VPWR clkload27/Y sky130_fd_sc_hd__clkinv_4
Xclkload49 clknet_leaf_31_clk VGND VGND VPWR VPWR clkload49/Y sky130_fd_sc_hd__clkinv_4
Xclkload38 clknet_leaf_58_clk VGND VGND VPWR VPWR clkload38/X sky130_fd_sc_hd__clkbuf_8
XFILLER_107_391 VGND VGND VPWR VPWR sky130_fd_sc_hd__fill_1
XFILLER_5_485 VGND VGND VPWR VPWR sky130_fd_sc_hd__fill_1
XFILLER_48_6 VPWR VGND VPWR VGND sky130_ef_sc_hd__decap_12
XFILLER_96_713 VPWR VGND VPWR VGND sky130_ef_sc_hd__decap_12
XFILLER_122_361 VGND VGND VPWR VPWR sky130_fd_sc_hd__decap_3
XFILLER_110_501 VPWR VGND VPWR VGND sky130_ef_sc_hd__decap_12
XFILLER_110_545 VPWR VGND VPWR VGND sky130_ef_sc_hd__decap_12
X_4070_ _1981_ _1985_ VGND VGND VPWR VPWR _1986_ sky130_fd_sc_hd__or2_1
XFILLER_110_589 VPWR VGND VPWR VGND sky130_ef_sc_hd__decap_12
XFILLER_83_418 VGND VGND VPWR VPWR sky130_fd_sc_hd__decap_3
X_3021_ net33 _0964_ VGND VGND VPWR VPWR _0965_ sky130_fd_sc_hd__nor2_1
XFILLER_49_673 VPWR VGND VPWR VGND sky130_ef_sc_hd__decap_12
XFILLER_76_492 VGND VGND VPWR VPWR sky130_fd_sc_hd__decap_8
XFILLER_91_440 VGND VGND VPWR VPWR sky130_fd_sc_hd__decap_8
XTAP_TAPCELL_ROW_47_852 VGND VPWR sky130_fd_sc_hd__tapvpwrvgnd_1
XFILLER_51_337 VGND VGND VPWR VPWR sky130_fd_sc_hd__decap_4
XFILLER_17_570 VGND VGND VPWR VPWR sky130_fd_sc_hd__fill_1
XFILLER_17_592 VGND VGND VPWR VPWR sky130_fd_sc_hd__decap_3
X_4972_ _1280_ _2123_ _2286_ _1295_ VGND VGND VPWR VPWR _2819_ sky130_fd_sc_hd__a22o_1
XFILLER_24_529 VGND VGND VPWR VPWR sky130_fd_sc_hd__decap_3
X_3923_ reg_file_inst.registry\[0\]\[0\] _1076_ _1834_ _1839_ VGND VGND VPWR VPWR
+ _1840_ sky130_fd_sc_hd__o22a_4
XTAP_TAPCELL_ROW_63_1054 VGND VPWR sky130_fd_sc_hd__tapvpwrvgnd_1
X_3854_ MEMOFF\[3\] _1129_ _1130_ JMPOFF\[3\] _1773_ VGND VGND VPWR VPWR _1774_ sky130_fd_sc_hd__a221o_1
XFILLER_118_601 VPWR VGND VPWR VGND sky130_ef_sc_hd__decap_12
X_3785_ _1696_ _1704_ _1705_ _1706_ VGND VGND VPWR VPWR _1707_ sky130_fd_sc_hd__or4_2
XFILLER_118_645 VPWR VGND VPWR VGND sky130_ef_sc_hd__decap_12
XFILLER_117_111 VGND VGND VPWR VPWR sky130_fd_sc_hd__fill_1
XTAP_TAPCELL_ROW_115_1707 VGND VPWR sky130_fd_sc_hd__tapvpwrvgnd_1
X_5524_ reg_file_inst.registry\[6\]\[10\] _2960_ _3001_ VGND VGND VPWR VPWR _0541_
+ sky130_fd_sc_hd__mux2_1
XFILLER_105_317 VPWR VGND VPWR VGND sky130_ef_sc_hd__decap_12
X_5455_ reg_file_inst.registry\[5\]\[21\] _2829_ _2999_ VGND VGND VPWR VPWR _0608_
+ sky130_fd_sc_hd__mux2_1
X_4406_ net43 _2126_ _2251_ net30 VGND VGND VPWR VPWR _2294_ sky130_fd_sc_hd__or4b_4
XFILLER_120_309 VPWR VGND VPWR VGND sky130_ef_sc_hd__decap_12
XFILLER_99_573 VPWR VGND VPWR VGND sky130_ef_sc_hd__decap_12
X_5386_ MEMOFF\[3\] _2478_ _2996_ VGND VGND VPWR VPWR _0674_ sky130_fd_sc_hd__mux2_1
XFILLER_113_361 VPWR VGND VPWR VGND sky130_ef_sc_hd__decap_12
XTAP_TAPCELL_ROW_74_1194 VGND VPWR sky130_fd_sc_hd__tapvpwrvgnd_1
XTAP_TAPCELL_ROW_74_1183 VGND VPWR sky130_fd_sc_hd__tapvpwrvgnd_1
X_4337_ _1620_ _2190_ VGND VGND VPWR VPWR _2225_ sky130_fd_sc_hd__and2_1
XFILLER_115_69 VPWR VGND VPWR VGND sky130_ef_sc_hd__decap_12
X_4268_ _1790_ _2155_ VGND VGND VPWR VPWR _2156_ sky130_fd_sc_hd__xnor2_1
X_3219_ reg_file_inst.registry\[0\]\[26\] _1076_ _1154_ _1161_ VGND VGND VPWR VPWR
+ _1162_ sky130_fd_sc_hd__o22ai_4
X_6007_ net44 VGND VGND VPWR VPWR _0415_ sky130_fd_sc_hd__inv_2
X_4199_ _2097_ net103 net130 VGND VGND VPWR VPWR _0932_ sky130_fd_sc_hd__mux2_1
XFILLER_54_153 VPWR VGND VPWR VGND sky130_ef_sc_hd__decap_12
XFILLER_27_356 VPWR VGND VPWR VGND sky130_ef_sc_hd__decap_12
XFILLER_70_613 VPWR VGND VPWR VGND sky130_ef_sc_hd__decap_12
XFILLER_54_197 VGND VGND VPWR VPWR sky130_fd_sc_hd__decap_6
XFILLER_70_657 VPWR VGND VPWR VGND sky130_ef_sc_hd__decap_12
XFILLER_23_540 VPWR VGND VPWR VGND sky130_ef_sc_hd__decap_12
XTAP_TAPCELL_ROW_25_579 VGND VPWR sky130_fd_sc_hd__tapvpwrvgnd_1
XFILLER_10_223 VGND VGND VPWR VPWR sky130_fd_sc_hd__decap_4
XFILLER_24_99 VGND VGND VPWR VPWR sky130_fd_sc_hd__decap_8
XFILLER_50_381 VPWR VGND VPWR VGND sky130_ef_sc_hd__decap_12
XFILLER_10_267 VGND VGND VPWR VPWR sky130_fd_sc_hd__decap_3
XFILLER_108_133 VGND VGND VPWR VPWR sky130_fd_sc_hd__decap_6
XFILLER_6_249 VGND VGND VPWR VPWR sky130_fd_sc_hd__decap_3
XFILLER_108_177 VPWR VGND VPWR VGND sky130_ef_sc_hd__decap_12
XFILLER_2_477 VGND VGND VPWR VPWR sky130_fd_sc_hd__decap_8
XFILLER_49_52 VGND VGND VPWR VPWR sky130_fd_sc_hd__decap_4
XFILLER_1_15 VPWR VGND VPWR VGND sky130_ef_sc_hd__decap_12
XFILLER_18_301 VGND VGND VPWR VPWR sky130_fd_sc_hd__decap_6
XFILLER_33_337 VPWR VGND VPWR VGND sky130_ef_sc_hd__decap_12
XTAP_TAPCELL_ROW_44_811 VGND VPWR sky130_fd_sc_hd__tapvpwrvgnd_1
X_3570_ reg_file_inst.registry\[2\]\[14\] _1083_ _1096_ reg_file_inst.registry\[11\]\[14\]
+ VGND VGND VPWR VPWR _1499_ sky130_fd_sc_hd__a22o_1
XFILLER_115_615 VGND VGND VPWR VPWR sky130_fd_sc_hd__fill_1
X_5240_ _2478_ reg_file_inst.registry\[1\]\[3\] _2990_ VGND VGND VPWR VPWR _0814_
+ sky130_fd_sc_hd__mux2_1
XFILLER_102_309 VGND VGND VPWR VPWR sky130_fd_sc_hd__decap_4
XTAP_TAPCELL_ROW_110_1637 VGND VPWR sky130_fd_sc_hd__tapvpwrvgnd_1
XPHY_EDGE_ROW_18_Right_18 VGND VGND VPWR VPWR sky130_fd_sc_hd__decap_3
X_5171_ reg_file_inst.registry\[7\]\[4\] _2455_ _2553_ VGND VGND VPWR VPWR _0879_
+ sky130_fd_sc_hd__mux2_1
X_4122_ _0977_ _2037_ _0988_ VGND VGND VPWR VPWR _2038_ sky130_fd_sc_hd__a21o_1
XFILLER_68_289 VPWR VGND VPWR VGND sky130_ef_sc_hd__decap_12
XFILLER_56_418 VGND VGND VPWR VPWR sky130_fd_sc_hd__fill_2
X_4053_ _1967_ _1968_ VGND VGND VPWR VPWR _1969_ sky130_fd_sc_hd__nor2_1
X_3004_ net120 VGND VGND VPWR VPWR _0950_ sky130_fd_sc_hd__inv_2
Xinput3 DataMemoryRead[11] VGND VGND VPWR VPWR net3 sky130_fd_sc_hd__clkbuf_2
XFILLER_36_120 VGND VGND VPWR VPWR sky130_fd_sc_hd__decap_4
XFILLER_37_643 VGND VGND VPWR VPWR sky130_fd_sc_hd__fill_2
XFILLER_51_101 VGND VGND VPWR VPWR sky130_fd_sc_hd__decap_8
XFILLER_101_27 VPWR VGND VPWR VGND sky130_ef_sc_hd__decap_12
XFILLER_52_668 VGND VGND VPWR VPWR sky130_fd_sc_hd__decap_3
XFILLER_52_657 VGND VGND VPWR VPWR sky130_fd_sc_hd__fill_1
X_4955_ _2176_ _2792_ _2793_ _2804_ _2805_ VGND VGND VPWR VPWR net60 sky130_fd_sc_hd__a311o_1
XPHY_EDGE_ROW_27_Right_27 VGND VGND VPWR VPWR sky130_fd_sc_hd__decap_3
XFILLER_36_197 VGND VGND VPWR VPWR sky130_fd_sc_hd__decap_6
XTAP_TAPCELL_ROW_121_1777 VGND VPWR sky130_fd_sc_hd__tapvpwrvgnd_1
XFILLER_51_189 VGND VGND VPWR VPWR sky130_fd_sc_hd__fill_1
X_3906_ reg_file_inst.registry\[15\]\[1\] _1122_ _1129_ MEMOFF\[1\] _1823_ VGND VGND
+ VPWR VPWR _1824_ sky130_fd_sc_hd__a221o_1
XTAP_TAPCELL_ROW_22_538 VGND VPWR sky130_fd_sc_hd__tapvpwrvgnd_1
X_4886_ _2224_ _2225_ net132 VGND VGND VPWR VPWR _2743_ sky130_fd_sc_hd__mux2_1
X_3837_ reg_file_inst.registry\[8\]\[3\] _1090_ _1755_ _1756_ VGND VGND VPWR VPWR
+ _1757_ sky130_fd_sc_hd__a211o_1
XFILLER_20_587 VGND VGND VPWR VPWR sky130_fd_sc_hd__fill_1
X_3768_ reg_file_inst.registry\[10\]\[6\] _1126_ _1688_ _1689_ _1690_ VGND VGND VPWR
+ VPWR _1691_ sky130_fd_sc_hd__a2111o_1
XFILLER_118_475 VGND VGND VPWR VPWR sky130_fd_sc_hd__fill_1
X_5507_ reg_file_inst.registry\[6\]\[27\] _2715_ _3001_ VGND VGND VPWR VPWR _0558_
+ sky130_fd_sc_hd__mux2_1
XTAP_TAPCELL_ROW_76_1212 VGND VPWR sky130_fd_sc_hd__tapvpwrvgnd_1
XFILLER_106_637 VGND VGND VPWR VPWR sky130_fd_sc_hd__decap_6
XFILLER_105_125 VPWR VGND VPWR VGND sky130_ef_sc_hd__decap_12
X_6487_ clknet_leaf_41_clk _0895_ _0420_ VGND VGND VPWR VPWR reg_file_inst.registry\[7\]\[20\]
+ sky130_fd_sc_hd__dfrtp_1
XPHY_EDGE_ROW_5_Left_128 VGND VGND VPWR VPWR sky130_fd_sc_hd__decap_3
X_3699_ _1582_ _1594_ _1621_ _1568_ _1542_ VGND VGND VPWR VPWR _1623_ sky130_fd_sc_hd__a2111o_1
XFILLER_105_169 VPWR VGND VPWR VGND sky130_ef_sc_hd__decap_12
X_5438_ _2974_ reg_file_inst.registry\[10\]\[9\] _2998_ VGND VGND VPWR VPWR _0624_
+ sky130_fd_sc_hd__mux2_1
XPHY_EDGE_ROW_36_Right_36 VGND VGND VPWR VPWR sky130_fd_sc_hd__decap_3
XFILLER_121_629 VPWR VGND VPWR VGND sky130_ef_sc_hd__decap_12
XFILLER_114_681 VPWR VGND VPWR VGND sky130_ef_sc_hd__decap_12
XFILLER_99_370 VGND VGND VPWR VPWR sky130_fd_sc_hd__decap_6
X_5369_ MEMOFF\[20\] _2842_ _2996_ VGND VGND VPWR VPWR _0691_ sky130_fd_sc_hd__mux2_1
XFILLER_120_139 VGND VGND VPWR VPWR sky130_fd_sc_hd__fill_1
XFILLER_87_532 VPWR VGND VPWR VGND sky130_ef_sc_hd__decap_12
XFILLER_19_55 VGND VGND VPWR VPWR sky130_fd_sc_hd__fill_1
XFILLER_90_719 VGND VGND VPWR VPWR sky130_fd_sc_hd__fill_1
XTAP_TAPCELL_ROW_87_1352 VGND VPWR sky130_fd_sc_hd__tapvpwrvgnd_1
XFILLER_19_99 VGND VGND VPWR VPWR sky130_fd_sc_hd__fill_1
XFILLER_28_654 VPWR VGND VPWR VGND sky130_ef_sc_hd__decap_12
XTAP_TAPCELL_ROW_2_285 VGND VPWR sky130_fd_sc_hd__tapvpwrvgnd_1
XFILLER_43_613 VGND VGND VPWR VPWR sky130_fd_sc_hd__decap_3
XPHY_EDGE_ROW_45_Right_45 VGND VGND VPWR VPWR sky130_fd_sc_hd__decap_3
XFILLER_82_292 VGND VGND VPWR VPWR sky130_fd_sc_hd__fill_1
XFILLER_70_487 VPWR VGND VPWR VGND sky130_ef_sc_hd__decap_12
XFILLER_42_189 VGND VGND VPWR VPWR sky130_fd_sc_hd__decap_6
XTAP_TAPCELL_ROW_98_1492 VGND VPWR sky130_fd_sc_hd__tapvpwrvgnd_1
XFILLER_109_497 VGND VGND VPWR VPWR sky130_fd_sc_hd__decap_6
XPHY_EDGE_ROW_54_Right_54 VGND VGND VPWR VPWR sky130_fd_sc_hd__decap_3
XFILLER_2_241 VGND VGND VPWR VPWR sky130_fd_sc_hd__decap_8
XFILLER_2_274 VGND VGND VPWR VPWR sky130_fd_sc_hd__decap_4
XFILLER_93_502 VGND VGND VPWR VPWR sky130_fd_sc_hd__fill_2
XFILLER_19_610 VGND VGND VPWR VPWR sky130_fd_sc_hd__decap_6
XPHY_EDGE_ROW_63_Right_63 VGND VGND VPWR VPWR sky130_fd_sc_hd__decap_3
XFILLER_19_665 VGND VGND VPWR VPWR sky130_fd_sc_hd__decap_6
XFILLER_61_410 VGND VGND VPWR VPWR sky130_fd_sc_hd__fill_2
XTAP_TAPCELL_ROW_57_980 VGND VPWR sky130_fd_sc_hd__tapvpwrvgnd_1
XFILLER_18_153 VPWR VGND VPWR VGND sky130_ef_sc_hd__decap_12
XFILLER_19_698 VGND VGND VPWR VPWR sky130_fd_sc_hd__decap_6
XFILLER_34_624 VGND VGND VPWR VPWR sky130_fd_sc_hd__fill_1
XFILLER_46_473 VGND VGND VPWR VPWR sky130_fd_sc_hd__decap_3
XFILLER_92_71 VPWR VGND VPWR VGND sky130_ef_sc_hd__decap_12
XFILLER_61_443 VGND VGND VPWR VPWR sky130_fd_sc_hd__decap_4
XFILLER_34_668 VGND VGND VPWR VPWR sky130_fd_sc_hd__decap_8
XTAP_TAPCELL_ROW_60_1013 VGND VPWR sky130_fd_sc_hd__tapvpwrvgnd_1
X_4740_ _2589_ _2592_ VGND VGND VPWR VPWR _2599_ sky130_fd_sc_hd__or2_1
XFILLER_119_217 VGND VGND VPWR VPWR sky130_fd_sc_hd__decap_6
X_4671_ _1708_ _2533_ _2543_ VGND VGND VPWR VPWR _2544_ sky130_fd_sc_hd__a21boi_1
X_3622_ reg_file_inst.registry\[7\]\[10\] _1086_ _1087_ reg_file_inst.registry\[1\]\[10\]
+ VGND VGND VPWR VPWR _1549_ sky130_fd_sc_hd__a22o_1
X_6410_ clknet_leaf_40_clk _0818_ _0343_ VGND VGND VPWR VPWR reg_file_inst.registry\[1\]\[7\]
+ sky130_fd_sc_hd__dfrtp_1
X_6341_ clknet_leaf_37_clk _0749_ _0274_ VGND VGND VPWR VPWR reg_file_inst.registry\[8\]\[22\]
+ sky130_fd_sc_hd__dfrtp_1
XPHY_EDGE_ROW_72_Right_72 VGND VGND VPWR VPWR sky130_fd_sc_hd__decap_3
X_3553_ reg_file_inst.registry\[4\]\[15\] _1134_ _1135_ reg_file_inst.registry\[6\]\[15\]
+ _1482_ VGND VGND VPWR VPWR _1483_ sky130_fd_sc_hd__a221o_1
X_3484_ reg_file_inst.registry\[0\]\[17\] _1118_ _1412_ _1416_ VGND VGND VPWR VPWR
+ net81 sky130_fd_sc_hd__o22a_1
X_6272_ clknet_leaf_7_clk _0680_ _0205_ VGND VGND VPWR VPWR MEMOFF\[9\] sky130_fd_sc_hd__dfrtp_1
XFILLER_103_629 VPWR VGND VPWR VGND sky130_ef_sc_hd__decap_12
X_5223_ _2842_ reg_file_inst.registry\[1\]\[20\] _2990_ VGND VGND VPWR VPWR _0831_
+ sky130_fd_sc_hd__mux2_1
XFILLER_102_139 VGND VGND VPWR VPWR sky130_fd_sc_hd__fill_1
XTAP_TAPCELL_ROW_71_1153 VGND VPWR sky130_fd_sc_hd__tapvpwrvgnd_1
XFILLER_69_554 VGND VGND VPWR VPWR sky130_fd_sc_hd__decap_6
X_5154_ _2135_ _2178_ _2618_ VGND VGND VPWR VPWR _2975_ sky130_fd_sc_hd__or3b_1
XFILLER_111_673 VPWR VGND VPWR VGND sky130_ef_sc_hd__decap_12
XFILLER_84_513 VPWR VGND VPWR VGND sky130_ef_sc_hd__decap_12
X_4105_ _2019_ _2020_ VGND VGND VPWR VPWR _2021_ sky130_fd_sc_hd__and2_1
XPHY_EDGE_ROW_81_Right_81 VGND VGND VPWR VPWR sky130_fd_sc_hd__decap_3
X_5085_ _1458_ _1469_ _2288_ _2915_ VGND VGND VPWR VPWR _2916_ sky130_fd_sc_hd__o22a_1
X_4036_ _1951_ VGND VGND VPWR VPWR _1952_ sky130_fd_sc_hd__inv_2
XFILLER_112_26 VGND VGND VPWR VPWR sky130_fd_sc_hd__fill_2
XFILLER_37_473 VGND VGND VPWR VPWR sky130_fd_sc_hd__fill_2
X_5987_ net146 VGND VGND VPWR VPWR _0395_ sky130_fd_sc_hd__inv_2
XFILLER_12_307 VGND VGND VPWR VPWR sky130_fd_sc_hd__fill_1
X_4938_ _2598_ _2673_ _2591_ VGND VGND VPWR VPWR _2789_ sky130_fd_sc_hd__a21oi_1
XTAP_TAPCELL_ROW_35_696 VGND VPWR sky130_fd_sc_hd__tapvpwrvgnd_1
XTAP_TAPCELL_ROW_82_1293 VGND VPWR sky130_fd_sc_hd__tapvpwrvgnd_1
X_4869_ _2341_ _2343_ VGND VGND VPWR VPWR _2726_ sky130_fd_sc_hd__nor2_1
XPHY_EDGE_ROW_90_Right_90 VGND VGND VPWR VPWR sky130_fd_sc_hd__decap_3
XFILLER_20_384 VGND VGND VPWR VPWR sky130_fd_sc_hd__decap_6
XFILLER_20_373 VGND VGND VPWR VPWR sky130_fd_sc_hd__decap_3
XFILLER_106_401 VPWR VGND VPWR VGND sky130_ef_sc_hd__decap_12
X_6539_ clknet_leaf_39_clk _0947_ _0472_ VGND VGND VPWR VPWR net119 sky130_fd_sc_hd__dfrtp_1
XFILLER_4_528 VGND VGND VPWR VPWR sky130_fd_sc_hd__decap_4
XFILLER_106_445 VPWR VGND VPWR VGND sky130_ef_sc_hd__decap_12
XFILLER_97_27 VPWR VGND VPWR VGND sky130_ef_sc_hd__decap_12
XFILLER_106_489 VPWR VGND VPWR VGND sky130_ef_sc_hd__decap_12
XFILLER_79_329 VGND VGND VPWR VPWR sky130_fd_sc_hd__decap_6
XTAP_TAPCELL_ROW_7_355 VGND VPWR sky130_fd_sc_hd__tapvpwrvgnd_1
XFILLER_75_524 VGND VGND VPWR VPWR sky130_fd_sc_hd__fill_2
XFILLER_47_215 VGND VGND VPWR VPWR sky130_fd_sc_hd__decap_8
XFILLER_75_579 VGND VGND VPWR VPWR sky130_fd_sc_hd__decap_8
XFILLER_75_557 VGND VGND VPWR VPWR sky130_fd_sc_hd__decap_3
XFILLER_28_473 VGND VGND VPWR VPWR sky130_fd_sc_hd__decap_3
XFILLER_43_410 VGND VGND VPWR VPWR sky130_fd_sc_hd__decap_6
XFILLER_46_64 VPWR VGND VPWR VGND sky130_ef_sc_hd__decap_12
XFILLER_55_281 VGND VGND VPWR VPWR sky130_fd_sc_hd__decap_8
XFILLER_70_295 VGND VGND VPWR VPWR sky130_fd_sc_hd__decap_8
XFILLER_62_85 VPWR VGND VPWR VGND sky130_ef_sc_hd__decap_12
XFILLER_30_148 VGND VGND VPWR VPWR sky130_fd_sc_hd__decap_4
XFILLER_11_362 VGND VGND VPWR VPWR sky130_fd_sc_hd__decap_3
XFILLER_116_209 VPWR VGND VPWR VGND sky130_ef_sc_hd__decap_12
XFILLER_7_69 VPWR VGND VPWR VGND sky130_ef_sc_hd__decap_12
XFILLER_109_261 VPWR VGND VPWR VGND sky130_ef_sc_hd__decap_12
XFILLER_3_561 VPWR VGND VPWR VGND sky130_ef_sc_hd__decap_12
XFILLER_97_137 VPWR VGND VPWR VGND sky130_ef_sc_hd__decap_12
XFILLER_93_310 VGND VGND VPWR VPWR sky130_fd_sc_hd__decap_6
XFILLER_81_505 VPWR VGND VPWR VGND sky130_ef_sc_hd__decap_12
XFILLER_19_440 VGND VGND VPWR VPWR sky130_fd_sc_hd__decap_8
XFILLER_38_259 VPWR VGND VPWR VGND sky130_ef_sc_hd__decap_12
X_5910_ net148 VGND VGND VPWR VPWR _0318_ sky130_fd_sc_hd__inv_2
XFILLER_53_207 VGND VGND VPWR VPWR sky130_fd_sc_hd__fill_1
XTAP_TAPCELL_ROW_52_909 VGND VPWR sky130_fd_sc_hd__tapvpwrvgnd_1
XFILLER_34_421 VGND VGND VPWR VPWR sky130_fd_sc_hd__decap_6
X_5841_ net148 VGND VGND VPWR VPWR _0249_ sky130_fd_sc_hd__inv_2
XFILLER_61_240 VPWR VGND VPWR VGND sky130_ef_sc_hd__decap_12
XFILLER_22_616 VPWR VGND VPWR VGND sky130_ef_sc_hd__decap_12
X_5772_ net147 VGND VGND VPWR VPWR _0180_ sky130_fd_sc_hd__inv_2
XFILLER_34_487 VGND VGND VPWR VPWR sky130_fd_sc_hd__decap_8
X_4723_ _1267_ _2581_ VGND VGND VPWR VPWR _2582_ sky130_fd_sc_hd__and2_1
XFILLER_21_137 VPWR VGND VPWR VGND sky130_ef_sc_hd__decap_12
XTAP_TAPCELL_ROW_32_666 VGND VPWR sky130_fd_sc_hd__tapvpwrvgnd_1
XPHY_EDGE_ROW_86_Left_209 VGND VGND VPWR VPWR sky130_fd_sc_hd__decap_3
X_4654_ _2308_ net56 _2527_ VGND VGND VPWR VPWR _2528_ sky130_fd_sc_hd__a21o_4
X_4585_ _1791_ _2227_ _2463_ net137 VGND VGND VPWR VPWR _2464_ sky130_fd_sc_hd__o211a_1
X_3605_ reg_file_inst.registry\[4\]\[11\] _1134_ _1137_ reg_file_inst.registry\[2\]\[11\]
+ VGND VGND VPWR VPWR _1533_ sky130_fd_sc_hd__a22o_1
X_6324_ clknet_leaf_28_clk _0732_ _0257_ VGND VGND VPWR VPWR reg_file_inst.registry\[8\]\[5\]
+ sky130_fd_sc_hd__dfrtp_1
X_3536_ reg_file_inst.registry\[1\]\[13\] _1142_ _1459_ _1460_ _1461_ VGND VGND VPWR
+ VPWR _1467_ sky130_fd_sc_hd__a2111o_1
XFILLER_107_15 VPWR VGND VPWR VGND sky130_ef_sc_hd__decap_12
X_6255_ clknet_3_7__leaf_clk _0663_ _0188_ VGND VGND VPWR VPWR reg_file_inst.registry\[4\]\[20\]
+ sky130_fd_sc_hd__dfrtp_1
XFILLER_88_137 VGND VGND VPWR VPWR sky130_fd_sc_hd__decap_3
X_3467_ reg_file_inst.registry\[4\]\[17\] _1092_ _1098_ reg_file_inst.registry\[10\]\[17\]
+ VGND VGND VPWR VPWR _1400_ sky130_fd_sc_hd__a22o_1
X_5206_ _0961_ _1111_ VGND VGND VPWR VPWR _2989_ sky130_fd_sc_hd__and2_4
XFILLER_97_671 VGND VGND VPWR VPWR sky130_fd_sc_hd__fill_1
XPHY_EDGE_ROW_95_Left_218 VGND VGND VPWR VPWR sky130_fd_sc_hd__decap_3
X_3398_ reg_file_inst.registry\[0\]\[19\] net138 _1327_ _1332_ VGND VGND VPWR VPWR
+ _1334_ sky130_fd_sc_hd__o22ai_4
X_6186_ clknet_leaf_47_clk _0594_ _0119_ VGND VGND VPWR VPWR reg_file_inst.registry\[5\]\[7\]
+ sky130_fd_sc_hd__dfrtp_1
XTAP_TAPCELL_ROW_4_314 VGND VPWR sky130_fd_sc_hd__tapvpwrvgnd_1
X_5137_ reg_file_inst.registry\[7\]\[10\] _2960_ _2553_ VGND VGND VPWR VPWR _0885_
+ sky130_fd_sc_hd__mux2_1
XFILLER_96_192 VGND VGND VPWR VPWR sky130_fd_sc_hd__decap_4
X_5068_ _2129_ _2900_ _2721_ VGND VGND VPWR VPWR _2901_ sky130_fd_sc_hd__o21a_1
XFILLER_84_365 VPWR VGND VPWR VGND sky130_ef_sc_hd__decap_12
XFILLER_72_538 VPWR VGND VPWR VGND sky130_ef_sc_hd__decap_12
XFILLER_72_527 VGND VGND VPWR VPWR sky130_fd_sc_hd__decap_4
X_4019_ _1929_ _1930_ VGND VGND VPWR VPWR _1935_ sky130_fd_sc_hd__nand2_1
XFILLER_44_229 VPWR VGND VPWR VGND sky130_ef_sc_hd__decap_12
XTAP_TAPCELL_ROW_84_1311 VGND VPWR sky130_fd_sc_hd__tapvpwrvgnd_1
XPHY_EDGE_ROW_0_Right_0 VGND VGND VPWR VPWR sky130_fd_sc_hd__decap_3
XFILLER_12_148 VPWR VGND VPWR VGND sky130_ef_sc_hd__decap_12
XFILLER_9_609 VGND VGND VPWR VPWR sky130_fd_sc_hd__decap_6
XFILLER_40_457 VPWR VGND VPWR VGND sky130_ef_sc_hd__decap_12
XFILLER_20_170 VGND VGND VPWR VPWR sky130_fd_sc_hd__decap_6
XFILLER_113_3 VPWR VGND VPWR VGND sky130_ef_sc_hd__decap_12
XFILLER_107_721 VGND VGND VPWR VPWR sky130_fd_sc_hd__decap_4
XTAP_TAPCELL_ROW_95_1451 VGND VPWR sky130_fd_sc_hd__tapvpwrvgnd_1
XFILLER_122_713 VPWR VGND VPWR VGND sky130_ef_sc_hd__decap_12
XFILLER_106_253 VPWR VGND VPWR VGND sky130_ef_sc_hd__decap_12
XFILLER_121_223 VGND VGND VPWR VPWR sky130_fd_sc_hd__fill_1
XFILLER_0_553 VGND VGND VPWR VPWR sky130_fd_sc_hd__fill_1
XFILLER_88_693 VGND VGND VPWR VPWR sky130_fd_sc_hd__decap_6
XFILLER_0_597 VGND VGND VPWR VPWR sky130_fd_sc_hd__decap_8
XFILLER_48_513 VGND VGND VPWR VPWR sky130_fd_sc_hd__fill_1
XFILLER_48_568 VGND VGND VPWR VPWR sky130_fd_sc_hd__decap_4
XFILLER_75_376 VGND VGND VPWR VPWR sky130_fd_sc_hd__fill_1
XFILLER_63_505 VPWR VGND VPWR VGND sky130_ef_sc_hd__decap_12
XPHY_EDGE_ROW_121_Right_121 VGND VGND VPWR VPWR sky130_fd_sc_hd__decap_3
XFILLER_71_582 VPWR VGND VPWR VGND sky130_ef_sc_hd__decap_12
XFILLER_43_262 VPWR VGND VPWR VGND sky130_ef_sc_hd__decap_12
XFILLER_117_529 VPWR VGND VPWR VGND sky130_ef_sc_hd__decap_12
X_4370_ net132 _2257_ VGND VGND VPWR VPWR _2258_ sky130_fd_sc_hd__and2_1
X_3321_ reg_file_inst.registry\[11\]\[22\] _1119_ _1125_ VGND VGND VPWR VPWR _1260_
+ sky130_fd_sc_hd__and3_1
XFILLER_112_245 VGND VGND VPWR VPWR sky130_fd_sc_hd__decap_6
X_3252_ _1186_ _1188_ _1193_ _1118_ reg_file_inst.registry\[0\]\[25\] VGND VGND VPWR
+ VPWR net90 sky130_fd_sc_hd__o32a_2
XFILLER_3_391 VGND VGND VPWR VPWR sky130_fd_sc_hd__fill_1
X_6040_ net146 VGND VGND VPWR VPWR _0448_ sky130_fd_sc_hd__inv_2
XFILLER_112_289 VPWR VGND VPWR VGND sky130_ef_sc_hd__decap_12
X_3183_ net35 net29 VGND VGND VPWR VPWR _1127_ sky130_fd_sc_hd__and2b_4
XFILLER_66_321 VPWR VGND VPWR VGND sky130_ef_sc_hd__decap_12
XFILLER_78_181 VPWR VGND VPWR VGND sky130_ef_sc_hd__decap_12
XFILLER_93_151 VGND VGND VPWR VPWR sky130_fd_sc_hd__fill_1
XFILLER_66_365 VPWR VGND VPWR VGND sky130_ef_sc_hd__decap_12
XTAP_TAPCELL_ROW_37_725 VGND VPWR sky130_fd_sc_hd__tapvpwrvgnd_1
XFILLER_19_281 VGND VGND VPWR VPWR sky130_fd_sc_hd__decap_4
XFILLER_81_357 VPWR VGND VPWR VGND sky130_ef_sc_hd__decap_12
XTAP_TAPCELL_ROW_66_1085 VGND VPWR sky130_fd_sc_hd__tapvpwrvgnd_1
XFILLER_50_722 VGND VGND VPWR VPWR sky130_fd_sc_hd__fill_1
X_5824_ net149 VGND VGND VPWR VPWR _0232_ sky130_fd_sc_hd__inv_2
XTAP_TAPCELL_ROW_17_471 VGND VPWR sky130_fd_sc_hd__tapvpwrvgnd_1
XTAP_TAPCELL_ROW_17_482 VGND VPWR sky130_fd_sc_hd__tapvpwrvgnd_1
X_5755_ net146 VGND VGND VPWR VPWR _0163_ sky130_fd_sc_hd__inv_2
X_5686_ net149 VGND VGND VPWR VPWR _0094_ sky130_fd_sc_hd__inv_2
X_4706_ _1207_ _2127_ _2564_ VGND VGND VPWR VPWR _2565_ sky130_fd_sc_hd__a21oi_1
XFILLER_30_490 VGND VGND VPWR VPWR sky130_fd_sc_hd__fill_2
XTAP_TAPCELL_ROW_118_1738 VGND VPWR sky130_fd_sc_hd__tapvpwrvgnd_1
X_4637_ _2511_ VGND VGND VPWR VPWR _2512_ sky130_fd_sc_hd__inv_2
XFILLER_104_713 VPWR VGND VPWR VGND sky130_ef_sc_hd__decap_12
XFILLER_89_413 VGND VGND VPWR VPWR sky130_fd_sc_hd__decap_4
XFILLER_78_29 VPWR VGND VPWR VGND sky130_ef_sc_hd__decap_12
X_4568_ _1764_ _2191_ VGND VGND VPWR VPWR _2449_ sky130_fd_sc_hd__or2_1
XFILLER_103_201 VGND VGND VPWR VPWR sky130_fd_sc_hd__fill_1
X_6307_ clknet_leaf_16_clk _0715_ _0240_ VGND VGND VPWR VPWR reg_file_inst.registry\[3\]\[16\]
+ sky130_fd_sc_hd__dfrtp_1
X_3519_ reg_file_inst.registry\[7\]\[13\] _1086_ _1089_ reg_file_inst.registry\[9\]\[13\]
+ _1449_ VGND VGND VPWR VPWR _1450_ sky130_fd_sc_hd__a221o_1
X_4499_ _1790_ _2381_ _2380_ VGND VGND VPWR VPWR _2382_ sky130_fd_sc_hd__a21o_1
X_6238_ clknet_leaf_27_clk _0646_ _0171_ VGND VGND VPWR VPWR reg_file_inst.registry\[4\]\[3\]
+ sky130_fd_sc_hd__dfrtp_1
XTAP_TAPCELL_ROW_90_1392 VGND VPWR sky130_fd_sc_hd__tapvpwrvgnd_1
XFILLER_76_129 VGND VGND VPWR VPWR sky130_fd_sc_hd__fill_1
X_6169_ clknet_leaf_9_clk _0577_ _0102_ VGND VGND VPWR VPWR JMPOFF\[18\] sky130_fd_sc_hd__dfrtp_4
XFILLER_85_663 VGND VGND VPWR VPWR sky130_fd_sc_hd__decap_8
XFILLER_27_11 VGND VGND VPWR VPWR sky130_fd_sc_hd__fill_1
XFILLER_85_685 VPWR VGND VPWR VGND sky130_ef_sc_hd__decap_12
XFILLER_27_44 VPWR VGND VPWR VGND sky130_ef_sc_hd__decap_12
XFILLER_84_195 VGND VGND VPWR VPWR sky130_fd_sc_hd__fill_1
XFILLER_27_66 VPWR VGND VPWR VGND sky130_ef_sc_hd__decap_12
XFILLER_43_32 VPWR VGND VPWR VGND sky130_ef_sc_hd__decap_12
XFILLER_9_417 VPWR VGND VPWR VGND sky130_ef_sc_hd__decap_12
XFILLER_9_439 VGND VGND VPWR VPWR sky130_fd_sc_hd__decap_8
Xclkbuf_leaf_20_clk clknet_3_3__leaf_clk VGND VGND VPWR VPWR clknet_leaf_20_clk sky130_fd_sc_hd__clkbuf_8
XFILLER_107_573 VPWR VGND VPWR VGND sky130_ef_sc_hd__decap_12
XFILLER_4_26 VGND VGND VPWR VPWR sky130_fd_sc_hd__fill_2
XFILLER_95_405 VGND VGND VPWR VPWR sky130_fd_sc_hd__decap_6
XFILLER_95_449 VPWR VGND VPWR VGND sky130_ef_sc_hd__decap_12
XFILLER_76_641 VGND VGND VPWR VPWR sky130_fd_sc_hd__decap_3
XFILLER_48_332 VPWR VGND VPWR VGND sky130_ef_sc_hd__decap_12
XFILLER_76_685 VGND VGND VPWR VPWR sky130_fd_sc_hd__fill_1
XFILLER_48_365 VGND VGND VPWR VPWR sky130_fd_sc_hd__decap_8
XFILLER_90_110 VPWR VGND VPWR VGND sky130_ef_sc_hd__decap_12
XFILLER_84_61 VPWR VGND VPWR VGND sky130_ef_sc_hd__decap_12
XFILLER_63_335 VGND VGND VPWR VPWR sky130_fd_sc_hd__fill_1
XFILLER_36_549 VPWR VGND VPWR VGND sky130_ef_sc_hd__decap_12
XFILLER_44_560 VGND VGND VPWR VPWR sky130_fd_sc_hd__decap_8
XTAP_TAPCELL_ROW_102_1539 VGND VPWR sky130_fd_sc_hd__tapvpwrvgnd_1
XFILLER_31_221 VGND VGND VPWR VPWR sky130_fd_sc_hd__decap_3
X_3870_ _1785_ _1786_ _1787_ _1788_ VGND VGND VPWR VPWR _1789_ sky130_fd_sc_hd__or4_2
XTAP_TAPCELL_ROW_14_441 VGND VPWR sky130_fd_sc_hd__tapvpwrvgnd_1
XTAP_TAPCELL_ROW_42_783 VGND VPWR sky130_fd_sc_hd__tapvpwrvgnd_1
X_5540_ _2806_ reg_file_inst.registry\[9\]\[23\] _3002_ VGND VGND VPWR VPWR _0526_
+ sky130_fd_sc_hd__mux2_1
Xclkbuf_leaf_11_clk clknet_3_0__leaf_clk VGND VGND VPWR VPWR clknet_leaf_11_clk sky130_fd_sc_hd__clkbuf_8
XTAP_TAPCELL_ROW_42_794 VGND VPWR sky130_fd_sc_hd__tapvpwrvgnd_1
X_5471_ reg_file_inst.registry\[5\]\[5\] _2419_ _2999_ VGND VGND VPWR VPWR _0592_
+ sky130_fd_sc_hd__mux2_1
XFILLER_117_337 VPWR VGND VPWR VGND sky130_ef_sc_hd__decap_12
X_4422_ net42 _1113_ VGND VGND VPWR VPWR _2309_ sky130_fd_sc_hd__or2_4
X_4353_ _1194_ _2203_ _2240_ VGND VGND VPWR VPWR _2241_ sky130_fd_sc_hd__a21o_1
XTAP_TAPCELL_ROW_113_1679 VGND VPWR sky130_fd_sc_hd__tapvpwrvgnd_1
XFILLER_98_265 VGND VGND VPWR VPWR sky130_fd_sc_hd__fill_1
X_3304_ _1231_ _1242_ VGND VGND VPWR VPWR _1243_ sky130_fd_sc_hd__nand2_1
X_4284_ _1751_ _2144_ _2168_ _2169_ _2149_ VGND VGND VPWR VPWR _2172_ sky130_fd_sc_hd__a221o_1
XFILLER_98_298 VGND VGND VPWR VPWR sky130_fd_sc_hd__decap_8
X_3235_ reg_file_inst.registry\[6\]\[25\] _1094_ _1098_ reg_file_inst.registry\[10\]\[25\]
+ _1176_ VGND VGND VPWR VPWR _1177_ sky130_fd_sc_hd__a221o_1
X_6023_ net148 VGND VGND VPWR VPWR _0431_ sky130_fd_sc_hd__inv_2
XFILLER_39_310 VPWR VGND VPWR VGND sky130_ef_sc_hd__decap_12
XFILLER_67_641 VGND VGND VPWR VPWR sky130_fd_sc_hd__decap_4
XTAP_TAPCELL_ROW_68_1114 VGND VPWR sky130_fd_sc_hd__tapvpwrvgnd_1
XFILLER_67_685 VPWR VGND VPWR VGND sky130_ef_sc_hd__decap_12
X_3166_ net32 _0963_ VGND VGND VPWR VPWR _1110_ sky130_fd_sc_hd__nand2_1
X_3097_ _0992_ _1024_ _1027_ _1032_ _1040_ VGND VGND VPWR VPWR _1041_ sky130_fd_sc_hd__o2111ai_2
XFILLER_39_387 VGND VGND VPWR VPWR sky130_fd_sc_hd__fill_1
XFILLER_82_699 VGND VGND VPWR VPWR sky130_fd_sc_hd__fill_1
X_5807_ net147 VGND VGND VPWR VPWR _0215_ sky130_fd_sc_hd__inv_2
X_3999_ net105 net131 _1912_ _1913_ VGND VGND VPWR VPWR _1915_ sky130_fd_sc_hd__and4_1
XFILLER_50_585 VGND VGND VPWR VPWR sky130_fd_sc_hd__decap_3
X_5738_ net148 VGND VGND VPWR VPWR _0146_ sky130_fd_sc_hd__inv_2
XTAP_TAPCELL_ROW_79_1254 VGND VPWR sky130_fd_sc_hd__tapvpwrvgnd_1
X_5669_ net146 VGND VGND VPWR VPWR _0077_ sky130_fd_sc_hd__inv_2
XTAP_TAPCELL_ROW_92_1410 VGND VPWR sky130_fd_sc_hd__tapvpwrvgnd_1
XFILLER_2_637 VGND VGND VPWR VPWR sky130_fd_sc_hd__decap_6
XFILLER_104_587 VGND VGND VPWR VPWR sky130_fd_sc_hd__fill_1
XFILLER_77_427 VGND VGND VPWR VPWR sky130_fd_sc_hd__fill_1
XFILLER_58_652 VPWR VGND VPWR VGND sky130_ef_sc_hd__decap_12
XFILLER_85_460 VGND VGND VPWR VPWR sky130_fd_sc_hd__fill_1
XFILLER_58_696 VGND VGND VPWR VPWR sky130_fd_sc_hd__decap_4
XFILLER_73_666 VGND VGND VPWR VPWR sky130_fd_sc_hd__decap_6
XFILLER_13_221 VGND VGND VPWR VPWR sky130_fd_sc_hd__decap_3
XFILLER_9_225 VPWR VGND VPWR VGND sky130_ef_sc_hd__decap_12
XFILLER_9_214 VGND VGND VPWR VPWR sky130_fd_sc_hd__decap_8
XTAP_TAPCELL_ROW_11_400 VGND VPWR sky130_fd_sc_hd__tapvpwrvgnd_1
XFILLER_13_298 VGND VGND VPWR VPWR sky130_fd_sc_hd__fill_1
XFILLER_41_596 VGND VGND VPWR VPWR sky130_fd_sc_hd__decap_3
XFILLER_70_85 VPWR VGND VPWR VGND sky130_ef_sc_hd__decap_12
XFILLER_9_269 VGND VGND VPWR VPWR sky130_fd_sc_hd__decap_8
Xclkload17 clknet_leaf_60_clk VGND VGND VPWR VPWR clkload17/X sky130_fd_sc_hd__clkbuf_8
Xclkload28 clknet_leaf_22_clk VGND VGND VPWR VPWR clkload28/Y sky130_fd_sc_hd__clkinvlp_4
XFILLER_5_420 VPWR VGND VPWR VGND sky130_ef_sc_hd__decap_12
Xclkload39 clknet_leaf_46_clk VGND VGND VPWR VPWR clkload39/X sky130_fd_sc_hd__clkbuf_8
XFILLER_114_307 VGND VGND VPWR VPWR sky130_fd_sc_hd__fill_1
XFILLER_110_513 VPWR VGND VPWR VGND sky130_ef_sc_hd__decap_12
XFILLER_96_725 VGND VGND VPWR VPWR sky130_fd_sc_hd__fill_1
XFILLER_110_557 VPWR VGND VPWR VGND sky130_ef_sc_hd__decap_12
XFILLER_0_180 VGND VGND VPWR VPWR sky130_fd_sc_hd__decap_8
X_3020_ net31 net30 net32 net34 VGND VGND VPWR VPWR _0964_ sky130_fd_sc_hd__or4b_4
Xclkbuf_leaf_0_clk clknet_3_0__leaf_clk VGND VGND VPWR VPWR clknet_leaf_0_clk sky130_fd_sc_hd__clkbuf_8
XFILLER_48_162 VPWR VGND VPWR VGND sky130_ef_sc_hd__decap_12
XFILLER_49_685 VPWR VGND VPWR VGND sky130_ef_sc_hd__decap_12
XTAP_TAPCELL_ROW_19_500 VGND VPWR sky130_fd_sc_hd__tapvpwrvgnd_1
XTAP_TAPCELL_ROW_47_853 VGND VPWR sky130_fd_sc_hd__tapvpwrvgnd_1
X_4971_ _2599_ _2789_ VGND VGND VPWR VPWR _2818_ sky130_fd_sc_hd__xor2_1
X_3922_ _1075_ _1835_ _1836_ _1838_ VGND VGND VPWR VPWR _1839_ sky130_fd_sc_hd__or4_4
XTAP_TAPCELL_ROW_63_1055 VGND VPWR sky130_fd_sc_hd__tapvpwrvgnd_1
X_3853_ reg_file_inst.registry\[15\]\[3\] _1122_ _1138_ reg_file_inst.registry\[14\]\[3\]
+ _1117_ VGND VGND VPWR VPWR _1773_ sky130_fd_sc_hd__a221o_1
XFILLER_118_613 VPWR VGND VPWR VGND sky130_ef_sc_hd__decap_12
X_3784_ JMPOFF\[4\] _1095_ _1096_ reg_file_inst.registry\[11\]\[4\] VGND VGND VPWR
+ VPWR _1706_ sky130_fd_sc_hd__a22o_1
XFILLER_118_657 VPWR VGND VPWR VGND sky130_ef_sc_hd__decap_12
X_5523_ reg_file_inst.registry\[6\]\[11\] _2948_ _3001_ VGND VGND VPWR VPWR _0542_
+ sky130_fd_sc_hd__mux2_1
XFILLER_117_167 VGND VGND VPWR VPWR sky130_fd_sc_hd__fill_1
X_5454_ reg_file_inst.registry\[5\]\[22\] _2817_ _2999_ VGND VGND VPWR VPWR _0609_
+ sky130_fd_sc_hd__mux2_1
XFILLER_105_329 VGND VGND VPWR VPWR sky130_fd_sc_hd__decap_6
X_5385_ MEMOFF\[4\] _2455_ _2996_ VGND VGND VPWR VPWR _0675_ sky130_fd_sc_hd__mux2_1
X_4405_ _2274_ _2280_ _2292_ VGND VGND VPWR VPWR _2293_ sky130_fd_sc_hd__o21ai_1
X_4336_ _1667_ _2190_ VGND VGND VPWR VPWR _2224_ sky130_fd_sc_hd__and2_1
XFILLER_115_15 VPWR VGND VPWR VGND sky130_ef_sc_hd__decap_12
XFILLER_113_373 VPWR VGND VPWR VGND sky130_ef_sc_hd__decap_12
XFILLER_99_585 VPWR VGND VPWR VGND sky130_ef_sc_hd__decap_12
XFILLER_87_725 VGND VGND VPWR VPWR sky130_fd_sc_hd__fill_1
XFILLER_86_213 VGND VGND VPWR VPWR sky130_fd_sc_hd__decap_8
XTAP_TAPCELL_ROW_74_1195 VGND VPWR sky130_fd_sc_hd__tapvpwrvgnd_1
XTAP_TAPCELL_ROW_74_1184 VGND VPWR sky130_fd_sc_hd__tapvpwrvgnd_1
XFILLER_59_449 VGND VGND VPWR VPWR sky130_fd_sc_hd__decap_6
X_4267_ net135 _1841_ _2126_ VGND VGND VPWR VPWR _2155_ sky130_fd_sc_hd__a21oi_1
X_3218_ _1156_ _1158_ _1160_ VGND VGND VPWR VPWR _1161_ sky130_fd_sc_hd__or3_1
X_6006_ net147 VGND VGND VPWR VPWR _0414_ sky130_fd_sc_hd__inv_2
XFILLER_55_611 VGND VGND VPWR VPWR sky130_fd_sc_hd__decap_4
X_4198_ _1985_ _2096_ VGND VGND VPWR VPWR _2097_ sky130_fd_sc_hd__xnor2_1
X_3149_ net38 net39 net40 net41 net34 VGND VGND VPWR VPWR _1093_ sky130_fd_sc_hd__a41o_4
XFILLER_27_335 VGND VGND VPWR VPWR sky130_fd_sc_hd__fill_1
XFILLER_82_463 VGND VGND VPWR VPWR sky130_fd_sc_hd__decap_8
XFILLER_82_441 VGND VGND VPWR VPWR sky130_fd_sc_hd__fill_2
XFILLER_27_346 VGND VGND VPWR VPWR sky130_fd_sc_hd__decap_6
XFILLER_70_625 VPWR VGND VPWR VGND sky130_ef_sc_hd__decap_12
XFILLER_70_669 VGND VGND VPWR VPWR sky130_fd_sc_hd__fill_2
XFILLER_11_725 VGND VGND VPWR VPWR sky130_fd_sc_hd__fill_1
XFILLER_23_552 VGND VGND VPWR VPWR sky130_fd_sc_hd__decap_8
XFILLER_10_279 VGND VGND VPWR VPWR sky130_fd_sc_hd__decap_4
XFILLER_40_66 VPWR VGND VPWR VGND sky130_ef_sc_hd__decap_12
XFILLER_108_189 VGND VGND VPWR VPWR sky130_fd_sc_hd__decap_6
XFILLER_6_3 VPWR VGND VPWR VGND sky130_ef_sc_hd__decap_12
XFILLER_2_434 VGND VGND VPWR VPWR sky130_fd_sc_hd__fill_1
XFILLER_1_27 VPWR VGND VPWR VGND sky130_ef_sc_hd__decap_12
XFILLER_105_81 VPWR VGND VPWR VGND sky130_ef_sc_hd__decap_12
XFILLER_33_316 VPWR VGND VPWR VGND sky130_ef_sc_hd__decap_12
XTAP_TAPCELL_ROW_44_812 VGND VPWR sky130_fd_sc_hd__tapvpwrvgnd_1
XFILLER_45_187 VGND VGND VPWR VPWR sky130_fd_sc_hd__fill_1
XFILLER_33_349 VPWR VGND VPWR VGND sky130_ef_sc_hd__decap_12
XFILLER_81_51 VGND VGND VPWR VPWR sky130_fd_sc_hd__decap_4
XFILLER_14_585 VGND VGND VPWR VPWR sky130_fd_sc_hd__decap_3
XFILLER_41_393 VGND VGND VPWR VPWR sky130_fd_sc_hd__decap_8
XTAP_TAPCELL_ROW_110_1638 VGND VPWR sky130_fd_sc_hd__tapvpwrvgnd_1
X_5170_ reg_file_inst.registry\[7\]\[5\] _2419_ _2553_ VGND VGND VPWR VPWR _0880_
+ sky130_fd_sc_hd__mux2_1
XFILLER_39_3 VPWR VGND VPWR VGND sky130_ef_sc_hd__decap_12
XFILLER_122_181 VPWR VGND VPWR VGND sky130_ef_sc_hd__decap_12
XFILLER_110_321 VPWR VGND VPWR VGND sky130_ef_sc_hd__decap_12
X_4121_ _0986_ _2022_ VGND VGND VPWR VPWR _2037_ sky130_fd_sc_hd__nand2_1
XFILLER_110_365 VPWR VGND VPWR VGND sky130_ef_sc_hd__decap_12
X_4052_ _0953_ _1942_ VGND VGND VPWR VPWR _1968_ sky130_fd_sc_hd__xnor2_1
Xinput4 DataMemoryRead[12] VGND VGND VPWR VPWR net4 sky130_fd_sc_hd__clkbuf_2
XFILLER_37_655 VGND VGND VPWR VPWR sky130_fd_sc_hd__decap_4
XFILLER_64_485 VGND VGND VPWR VPWR sky130_fd_sc_hd__fill_1
XFILLER_101_39 VPWR VGND VPWR VGND sky130_ef_sc_hd__decap_12
XFILLER_51_113 VGND VGND VPWR VPWR sky130_fd_sc_hd__decap_4
X_4954_ _2129_ _2248_ _2721_ VGND VGND VPWR VPWR _2805_ sky130_fd_sc_hd__o21a_1
XFILLER_17_390 VGND VGND VPWR VPWR sky130_fd_sc_hd__fill_2
XFILLER_32_360 VGND VGND VPWR VPWR sky130_fd_sc_hd__decap_4
X_3905_ JMPOFF\[1\] _1130_ _1141_ reg_file_inst.registry\[11\]\[1\] _1117_ VGND VGND
+ VPWR VPWR _1823_ sky130_fd_sc_hd__a221o_1
XTAP_TAPCELL_ROW_121_1778 VGND VPWR sky130_fd_sc_hd__tapvpwrvgnd_1
XFILLER_20_522 VGND VGND VPWR VPWR sky130_fd_sc_hd__fill_1
X_4885_ _2332_ _2335_ VGND VGND VPWR VPWR _2742_ sky130_fd_sc_hd__nor2_1
XTAP_TAPCELL_ROW_22_539 VGND VPWR sky130_fd_sc_hd__tapvpwrvgnd_1
X_3836_ MEMOFF\[3\] _1079_ _1089_ reg_file_inst.registry\[9\]\[3\] VGND VGND VPWR
+ VPWR _1756_ sky130_fd_sc_hd__a22o_1
XFILLER_118_421 VPWR VGND VPWR VGND sky130_ef_sc_hd__decap_12
X_3767_ reg_file_inst.registry\[4\]\[6\] _1134_ _1137_ reg_file_inst.registry\[2\]\[6\]
+ VGND VGND VPWR VPWR _1690_ sky130_fd_sc_hd__a22o_1
XTAP_TAPCELL_ROW_76_1213 VGND VPWR sky130_fd_sc_hd__tapvpwrvgnd_1
X_5506_ _1124_ _2552_ VGND VGND VPWR VPWR _3001_ sky130_fd_sc_hd__nor2_8
X_6486_ clknet_leaf_20_clk _0894_ _0419_ VGND VGND VPWR VPWR reg_file_inst.registry\[7\]\[19\]
+ sky130_fd_sc_hd__dfrtp_1
X_3698_ _1582_ _1594_ VGND VGND VPWR VPWR _1622_ sky130_fd_sc_hd__xnor2_1
XFILLER_105_137 VPWR VGND VPWR VGND sky130_ef_sc_hd__decap_12
X_5437_ _2960_ reg_file_inst.registry\[10\]\[10\] _2998_ VGND VGND VPWR VPWR _0625_
+ sky130_fd_sc_hd__mux2_1
X_5368_ MEMOFF\[21\] _2829_ _2996_ VGND VGND VPWR VPWR _0692_ sky130_fd_sc_hd__mux2_1
XFILLER_59_213 VGND VGND VPWR VPWR sky130_fd_sc_hd__decap_8
XFILLER_114_693 VGND VGND VPWR VPWR sky130_fd_sc_hd__decap_6
XFILLER_113_181 VPWR VGND VPWR VGND sky130_ef_sc_hd__decap_12
XFILLER_99_393 VPWR VGND VPWR VGND sky130_ef_sc_hd__decap_12
XFILLER_87_544 VPWR VGND VPWR VGND sky130_ef_sc_hd__decap_12
XFILLER_59_246 VGND VGND VPWR VPWR sky130_fd_sc_hd__decap_3
X_4319_ _2205_ _2206_ _1841_ VGND VGND VPWR VPWR _2207_ sky130_fd_sc_hd__mux2_1
X_5299_ _2478_ reg_file_inst.registry\[2\]\[3\] _2993_ VGND VGND VPWR VPWR _0758_
+ sky130_fd_sc_hd__mux2_1
XFILLER_59_279 VGND VGND VPWR VPWR sky130_fd_sc_hd__fill_1
XTAP_TAPCELL_ROW_87_1353 VGND VPWR sky130_fd_sc_hd__tapvpwrvgnd_1
XFILLER_28_666 VPWR VGND VPWR VGND sky130_ef_sc_hd__decap_12
XTAP_TAPCELL_ROW_2_286 VGND VPWR sky130_fd_sc_hd__tapvpwrvgnd_1
XPHY_EDGE_ROW_106_Left_229 VGND VGND VPWR VPWR sky130_fd_sc_hd__decap_3
XFILLER_35_66 VGND VGND VPWR VPWR sky130_fd_sc_hd__decap_6
XFILLER_70_477 VGND VGND VPWR VPWR sky130_fd_sc_hd__fill_2
XFILLER_70_499 VGND VGND VPWR VPWR sky130_fd_sc_hd__decap_6
XFILLER_11_522 VPWR VGND VPWR VGND sky130_ef_sc_hd__decap_12
XFILLER_23_393 VPWR VGND VPWR VGND sky130_ef_sc_hd__decap_12
XFILLER_7_559 VGND VGND VPWR VPWR sky130_fd_sc_hd__fill_1
XTAP_TAPCELL_ROW_98_1493 VGND VPWR sky130_fd_sc_hd__tapvpwrvgnd_1
XFILLER_3_721 VGND VGND VPWR VPWR sky130_fd_sc_hd__decap_4
XPHY_EDGE_ROW_115_Left_238 VGND VGND VPWR VPWR sky130_fd_sc_hd__decap_3
XFILLER_105_671 VGND VGND VPWR VPWR sky130_fd_sc_hd__fill_1
XFILLER_78_533 VGND VGND VPWR VPWR sky130_fd_sc_hd__fill_1
XFILLER_80_208 VPWR VGND VPWR VGND sky130_ef_sc_hd__decap_12
XFILLER_73_260 VGND VGND VPWR VPWR sky130_fd_sc_hd__fill_1
XTAP_TAPCELL_ROW_57_981 VGND VPWR sky130_fd_sc_hd__tapvpwrvgnd_1
XFILLER_18_165 VGND VGND VPWR VPWR sky130_fd_sc_hd__decap_4
XFILLER_33_113 VPWR VGND VPWR VGND sky130_ef_sc_hd__decap_12
XFILLER_34_658 VGND VGND VPWR VPWR sky130_fd_sc_hd__decap_3
XFILLER_92_83 VGND VGND VPWR VPWR sky130_fd_sc_hd__fill_1
XTAP_TAPCELL_ROW_60_1014 VGND VPWR sky130_fd_sc_hd__tapvpwrvgnd_1
X_4670_ _1764_ _2540_ _2542_ _1708_ VGND VGND VPWR VPWR _2543_ sky130_fd_sc_hd__a211o_1
X_3621_ reg_file_inst.registry\[8\]\[10\] _1090_ _1098_ reg_file_inst.registry\[10\]\[10\]
+ VGND VGND VPWR VPWR _1548_ sky130_fd_sc_hd__a22o_1
X_3552_ reg_file_inst.registry\[10\]\[15\] _1123_ net143 VGND VGND VPWR VPWR _1482_
+ sky130_fd_sc_hd__and3_1
X_6340_ clknet_leaf_37_clk _0748_ _0273_ VGND VGND VPWR VPWR reg_file_inst.registry\[8\]\[21\]
+ sky130_fd_sc_hd__dfrtp_1
XFILLER_6_581 VGND VGND VPWR VPWR sky130_fd_sc_hd__decap_6
X_3483_ reg_file_inst.registry\[6\]\[17\] _1135_ _1413_ _1414_ _1415_ VGND VGND VPWR
+ VPWR _1416_ sky130_fd_sc_hd__a2111o_1
X_6271_ clknet_leaf_56_clk _0679_ _0204_ VGND VGND VPWR VPWR MEMOFF\[8\] sky130_fd_sc_hd__dfrtp_2
X_5222_ _2829_ reg_file_inst.registry\[1\]\[21\] _2990_ VGND VGND VPWR VPWR _0832_
+ sky130_fd_sc_hd__mux2_1
XTAP_TAPCELL_ROW_71_1154 VGND VPWR sky130_fd_sc_hd__tapvpwrvgnd_1
X_5153_ reg_file_inst.registry\[7\]\[9\] _2974_ _2553_ VGND VGND VPWR VPWR _0884_
+ sky130_fd_sc_hd__mux2_1
XFILLER_111_641 VPWR VGND VPWR VGND sky130_ef_sc_hd__decap_12
XFILLER_96_363 VGND VGND VPWR VPWR sky130_fd_sc_hd__fill_1
X_4104_ _1991_ _1992_ _2004_ _2018_ VGND VGND VPWR VPWR _2020_ sky130_fd_sc_hd__a211o_1
XFILLER_111_685 VPWR VGND VPWR VGND sky130_ef_sc_hd__decap_12
XFILLER_84_525 VGND VGND VPWR VPWR sky130_fd_sc_hd__decap_6
X_5084_ _1457_ _2124_ VGND VGND VPWR VPWR _2915_ sky130_fd_sc_hd__nor2_1
XFILLER_110_195 VGND VGND VPWR VPWR sky130_fd_sc_hd__fill_1
X_4035_ net123 _1017_ _1878_ _1950_ VGND VGND VPWR VPWR _1951_ sky130_fd_sc_hd__and4_1
XFILLER_52_400 VGND VGND VPWR VPWR sky130_fd_sc_hd__decap_8
XFILLER_25_625 VGND VGND VPWR VPWR sky130_fd_sc_hd__fill_2
X_5986_ net149 VGND VGND VPWR VPWR _0394_ sky130_fd_sc_hd__inv_2
XFILLER_52_477 VGND VGND VPWR VPWR sky130_fd_sc_hd__decap_6
XFILLER_24_157 VPWR VGND VPWR VGND sky130_ef_sc_hd__decap_12
XTAP_TAPCELL_ROW_82_1283 VGND VPWR sky130_fd_sc_hd__tapvpwrvgnd_1
X_4937_ _2598_ _2673_ VGND VGND VPWR VPWR _2788_ sky130_fd_sc_hd__nand2_1
XTAP_TAPCELL_ROW_35_697 VGND VPWR sky130_fd_sc_hd__tapvpwrvgnd_1
XANTENNA_20 net88 VGND VGND VPWR VPWR sky130_fd_sc_hd__diode_2
XTAP_TAPCELL_ROW_82_1294 VGND VPWR sky130_fd_sc_hd__tapvpwrvgnd_1
X_4868_ _2723_ _2724_ net133 VGND VGND VPWR VPWR _2725_ sky130_fd_sc_hd__mux2_1
X_3819_ reg_file_inst.registry\[7\]\[5\] _1119_ _1132_ VGND VGND VPWR VPWR _1740_
+ sky130_fd_sc_hd__and3_1
XFILLER_20_363 VGND VGND VPWR VPWR sky130_fd_sc_hd__fill_1
XFILLER_118_251 VGND VGND VPWR VPWR sky130_fd_sc_hd__fill_1
X_4799_ _1345_ _2657_ VGND VGND VPWR VPWR _2658_ sky130_fd_sc_hd__xnor2_1
XFILLER_106_413 VGND VGND VPWR VPWR sky130_fd_sc_hd__decap_6
X_6538_ clknet_leaf_39_clk _0946_ _0471_ VGND VGND VPWR VPWR net118 sky130_fd_sc_hd__dfrtp_1
XFILLER_108_6 VPWR VGND VPWR VGND sky130_ef_sc_hd__decap_12
XFILLER_106_457 VPWR VGND VPWR VGND sky130_ef_sc_hd__decap_12
X_6469_ clknet_leaf_62_clk _0877_ _0402_ VGND VGND VPWR VPWR reg_file_inst.registry\[7\]\[2\]
+ sky130_fd_sc_hd__dfrtp_1
XFILLER_121_405 VPWR VGND VPWR VGND sky130_ef_sc_hd__decap_12
XFILLER_97_39 VGND VGND VPWR VPWR sky130_fd_sc_hd__decap_8
XFILLER_121_449 VPWR VGND VPWR VGND sky130_ef_sc_hd__decap_12
XTAP_TAPCELL_ROW_7_356 VGND VPWR sky130_fd_sc_hd__tapvpwrvgnd_1
XPHY_EDGE_ROW_102_Right_102 VGND VGND VPWR VPWR sky130_fd_sc_hd__decap_3
XFILLER_75_503 VGND VGND VPWR VPWR sky130_fd_sc_hd__fill_1
XFILLER_47_205 VGND VGND VPWR VPWR sky130_fd_sc_hd__decap_3
XFILLER_75_569 VGND VGND VPWR VPWR sky130_fd_sc_hd__fill_1
XFILLER_62_219 VPWR VGND VPWR VGND sky130_ef_sc_hd__decap_12
XFILLER_46_76 VGND VGND VPWR VPWR sky130_fd_sc_hd__decap_8
XTAP_TAPCELL_ROW_54_940 VGND VPWR sky130_fd_sc_hd__tapvpwrvgnd_1
XFILLER_15_102 VGND VGND VPWR VPWR sky130_fd_sc_hd__decap_8
XFILLER_15_113 VGND VGND VPWR VPWR sky130_fd_sc_hd__fill_2
XFILLER_70_241 VGND VGND VPWR VPWR sky130_fd_sc_hd__decap_8
XFILLER_31_617 VGND VGND VPWR VPWR sky130_fd_sc_hd__fill_1
XFILLER_43_477 VGND VGND VPWR VPWR sky130_fd_sc_hd__fill_1
XFILLER_62_97 VGND VGND VPWR VPWR sky130_fd_sc_hd__fill_2
XFILLER_23_190 VGND VGND VPWR VPWR sky130_fd_sc_hd__fill_1
XFILLER_7_15 VPWR VGND VPWR VGND sky130_ef_sc_hd__decap_12
XFILLER_109_273 VGND VGND VPWR VPWR sky130_fd_sc_hd__decap_6
XFILLER_7_389 VGND VGND VPWR VPWR sky130_fd_sc_hd__decap_3
XFILLER_3_573 VPWR VGND VPWR VGND sky130_ef_sc_hd__decap_12
XFILLER_97_149 VPWR VGND VPWR VGND sky130_ef_sc_hd__decap_12
XFILLER_78_352 VGND VGND VPWR VPWR sky130_fd_sc_hd__decap_3
XFILLER_66_525 VGND VGND VPWR VPWR sky130_fd_sc_hd__decap_6
XFILLER_38_205 VGND VGND VPWR VPWR sky130_fd_sc_hd__fill_1
XFILLER_93_344 VGND VGND VPWR VPWR sky130_fd_sc_hd__fill_1
XFILLER_38_249 VGND VGND VPWR VPWR sky130_fd_sc_hd__decap_3
XFILLER_93_388 VGND VGND VPWR VPWR sky130_fd_sc_hd__decap_4
XFILLER_93_377 VGND VGND VPWR VPWR sky130_fd_sc_hd__fill_2
XFILLER_81_517 VPWR VGND VPWR VGND sky130_ef_sc_hd__decap_12
XFILLER_19_485 VGND VGND VPWR VPWR sky130_fd_sc_hd__decap_4
X_5840_ net146 VGND VGND VPWR VPWR _0248_ sky130_fd_sc_hd__inv_2
XFILLER_61_252 VGND VGND VPWR VPWR sky130_fd_sc_hd__decap_6
XFILLER_34_444 VGND VGND VPWR VPWR sky130_fd_sc_hd__decap_3
XFILLER_34_477 VGND VGND VPWR VPWR sky130_fd_sc_hd__fill_2
XFILLER_15_680 VGND VGND VPWR VPWR sky130_fd_sc_hd__fill_2
XFILLER_22_628 VPWR VGND VPWR VGND sky130_ef_sc_hd__decap_12
X_5771_ net147 VGND VGND VPWR VPWR _0179_ sky130_fd_sc_hd__inv_2
X_4722_ _1256_ _2563_ VGND VGND VPWR VPWR _2581_ sky130_fd_sc_hd__xnor2_1
XFILLER_21_149 VPWR VGND VPWR VGND sky130_ef_sc_hd__decap_12
XTAP_TAPCELL_ROW_32_667 VGND VPWR sky130_fd_sc_hd__tapvpwrvgnd_1
Xinput40 instr[6] VGND VGND VPWR VPWR net40 sky130_fd_sc_hd__clkbuf_8
X_4653_ net35 _2117_ net101 net12 VGND VGND VPWR VPWR _2527_ sky130_fd_sc_hd__a22o_1
X_4584_ _1790_ _2462_ VGND VGND VPWR VPWR _2463_ sky130_fd_sc_hd__or2_1
X_3604_ reg_file_inst.registry\[10\]\[11\] _1123_ net143 VGND VGND VPWR VPWR _1532_
+ sky130_fd_sc_hd__and3_1
X_3535_ reg_file_inst.registry\[2\]\[13\] _1137_ _1138_ reg_file_inst.registry\[14\]\[13\]
+ VGND VGND VPWR VPWR _1466_ sky130_fd_sc_hd__a22o_1
X_6323_ clknet_leaf_50_clk _0731_ _0256_ VGND VGND VPWR VPWR reg_file_inst.registry\[8\]\[4\]
+ sky130_fd_sc_hd__dfrtp_1
XFILLER_107_27 VPWR VGND VPWR VGND sky130_ef_sc_hd__decap_12
X_6254_ clknet_leaf_20_clk _0662_ _0187_ VGND VGND VPWR VPWR reg_file_inst.registry\[4\]\[19\]
+ sky130_fd_sc_hd__dfrtp_1
XFILLER_89_617 VPWR VGND VPWR VGND sky130_ef_sc_hd__decap_12
XFILLER_88_105 VPWR VGND VPWR VGND sky130_ef_sc_hd__decap_12
X_3466_ reg_file_inst.registry\[14\]\[17\] _1081_ _1087_ reg_file_inst.registry\[1\]\[17\]
+ _1398_ VGND VGND VPWR VPWR _1399_ sky130_fd_sc_hd__a221o_1
X_5205_ _2550_ reg_file_inst.registry\[0\]\[0\] _2988_ VGND VGND VPWR VPWR _0847_
+ sky130_fd_sc_hd__mux2_1
X_3397_ reg_file_inst.registry\[0\]\[19\] net138 _1327_ _1332_ VGND VGND VPWR VPWR
+ _1333_ sky130_fd_sc_hd__o22a_1
XTAP_TAPCELL_ROW_4_315 VGND VPWR sky130_fd_sc_hd__tapvpwrvgnd_1
X_6185_ clknet_leaf_5_clk _0593_ _0118_ VGND VGND VPWR VPWR reg_file_inst.registry\[5\]\[6\]
+ sky130_fd_sc_hd__dfrtp_1
XFILLER_57_536 VGND VGND VPWR VPWR sky130_fd_sc_hd__decap_4
X_5136_ net2 net101 net46 _2308_ VGND VGND VPWR VPWR _2960_ sky130_fd_sc_hd__a22o_4
X_5067_ net137 _2362_ _2369_ _2899_ _2191_ VGND VGND VPWR VPWR _2900_ sky130_fd_sc_hd__o32a_1
XFILLER_84_377 VPWR VGND VPWR VGND sky130_ef_sc_hd__decap_12
X_4018_ _1930_ _1933_ VGND VGND VPWR VPWR _1934_ sky130_fd_sc_hd__nand2_1
XTAP_TAPCELL_ROW_84_1312 VGND VPWR sky130_fd_sc_hd__tapvpwrvgnd_1
XFILLER_25_455 VGND VGND VPWR VPWR sky130_fd_sc_hd__fill_1
X_5969_ net149 VGND VGND VPWR VPWR _0377_ sky130_fd_sc_hd__inv_2
XFILLER_40_469 VGND VGND VPWR VPWR sky130_fd_sc_hd__decap_6
XFILLER_32_56 VGND VGND VPWR VPWR sky130_fd_sc_hd__decap_8
XFILLER_106_221 VPWR VGND VPWR VGND sky130_ef_sc_hd__decap_12
XFILLER_106_3 VPWR VGND VPWR VGND sky130_ef_sc_hd__decap_12
XTAP_TAPCELL_ROW_95_1452 VGND VPWR sky130_fd_sc_hd__tapvpwrvgnd_1
XFILLER_122_725 VGND VGND VPWR VPWR sky130_fd_sc_hd__fill_1
XFILLER_106_265 VPWR VGND VPWR VGND sky130_ef_sc_hd__decap_12
XFILLER_95_609 VGND VGND VPWR VPWR sky130_fd_sc_hd__decap_6
XFILLER_121_279 VGND VGND VPWR VPWR sky130_fd_sc_hd__fill_1
XFILLER_57_53 VGND VGND VPWR VPWR sky130_fd_sc_hd__decap_3
XFILLER_48_503 VGND VGND VPWR VPWR sky130_fd_sc_hd__decap_4
XFILLER_63_517 VGND VGND VPWR VPWR sky130_fd_sc_hd__decap_6
XFILLER_113_81 VPWR VGND VPWR VGND sky130_ef_sc_hd__decap_12
XFILLER_71_561 VGND VGND VPWR VPWR sky130_fd_sc_hd__fill_1
XTAP_TAPCELL_ROW_104_1570 VGND VPWR sky130_fd_sc_hd__tapvpwrvgnd_1
XFILLER_71_594 VGND VGND VPWR VPWR sky130_fd_sc_hd__decap_8
XFILLER_43_274 VGND VGND VPWR VPWR sky130_fd_sc_hd__decap_6
XFILLER_12_672 VGND VGND VPWR VPWR sky130_fd_sc_hd__decap_8
XFILLER_11_160 VGND VGND VPWR VPWR sky130_fd_sc_hd__decap_8
XFILLER_8_643 VGND VGND VPWR VPWR sky130_fd_sc_hd__fill_1
XFILLER_12_683 VGND VGND VPWR VPWR sky130_fd_sc_hd__fill_2
XFILLER_12_694 VGND VGND VPWR VPWR sky130_fd_sc_hd__decap_6
XFILLER_7_175 VGND VGND VPWR VPWR sky130_fd_sc_hd__decap_8
XFILLER_98_71 VPWR VGND VPWR VGND sky130_ef_sc_hd__decap_12
X_3320_ reg_file_inst.registry\[10\]\[22\] _1126_ _1134_ reg_file_inst.registry\[4\]\[22\]
+ VGND VGND VPWR VPWR _1259_ sky130_fd_sc_hd__a22o_1
XFILLER_3_381 VGND VGND VPWR VPWR sky130_fd_sc_hd__fill_1
X_3251_ reg_file_inst.registry\[5\]\[25\] _1139_ _1191_ _1192_ VGND VGND VPWR VPWR
+ _1193_ sky130_fd_sc_hd__a211o_1
XFILLER_100_419 VGND VGND VPWR VPWR sky130_fd_sc_hd__fill_1
X_3182_ _1123_ net144 VGND VGND VPWR VPWR _1126_ sky130_fd_sc_hd__and2_4
XFILLER_21_3 VPWR VGND VPWR VGND sky130_ef_sc_hd__decap_12
XFILLER_94_642 VGND VGND VPWR VPWR sky130_fd_sc_hd__fill_2
XFILLER_78_193 VGND VGND VPWR VPWR sky130_fd_sc_hd__decap_3
XFILLER_66_333 VGND VGND VPWR VPWR sky130_fd_sc_hd__decap_8
XFILLER_81_303 VGND VGND VPWR VPWR sky130_fd_sc_hd__decap_6
XFILLER_66_377 VGND VGND VPWR VPWR sky130_fd_sc_hd__decap_3
XFILLER_19_293 VGND VGND VPWR VPWR sky130_fd_sc_hd__fill_2
XFILLER_35_720 VGND VGND VPWR VPWR sky130_fd_sc_hd__decap_3
XTAP_TAPCELL_ROW_37_726 VGND VPWR sky130_fd_sc_hd__tapvpwrvgnd_1
XFILLER_81_369 VGND VGND VPWR VPWR sky130_fd_sc_hd__decap_4
XFILLER_50_701 VPWR VGND VPWR VGND sky130_ef_sc_hd__decap_12
XTAP_TAPCELL_ROW_66_1086 VGND VPWR sky130_fd_sc_hd__tapvpwrvgnd_1
X_5823_ net146 VGND VGND VPWR VPWR _0231_ sky130_fd_sc_hd__inv_2
XTAP_TAPCELL_ROW_17_472 VGND VPWR sky130_fd_sc_hd__tapvpwrvgnd_1
X_5754_ net146 VGND VGND VPWR VPWR _0162_ sky130_fd_sc_hd__inv_2
X_5685_ net148 VGND VGND VPWR VPWR _0093_ sky130_fd_sc_hd__inv_2
X_4705_ _2126_ _2181_ _2563_ VGND VGND VPWR VPWR _2564_ sky130_fd_sc_hd__o21ai_1
XTAP_TAPCELL_ROW_118_1739 VGND VPWR sky130_fd_sc_hd__tapvpwrvgnd_1
XFILLER_118_15 VPWR VGND VPWR VGND sky130_ef_sc_hd__decap_12
X_4636_ _1790_ _2405_ VGND VGND VPWR VPWR _2511_ sky130_fd_sc_hd__or2_1
X_6306_ clknet_leaf_14_clk _0714_ _0239_ VGND VGND VPWR VPWR reg_file_inst.registry\[3\]\[15\]
+ sky130_fd_sc_hd__dfrtp_1
X_4567_ _1764_ _2191_ VGND VGND VPWR VPWR _2448_ sky130_fd_sc_hd__nor2_1
XFILLER_104_725 VGND VGND VPWR VPWR sky130_fd_sc_hd__fill_1
X_3518_ reg_file_inst.registry\[1\]\[13\] _1087_ _1095_ JMPOFF\[13\] VGND VGND VPWR
+ VPWR _1449_ sky130_fd_sc_hd__a22o_1
X_4498_ _2196_ _2207_ _1816_ VGND VGND VPWR VPWR _2381_ sky130_fd_sc_hd__mux2_1
XFILLER_89_469 VGND VGND VPWR VPWR sky130_fd_sc_hd__fill_1
X_3449_ _1382_ VGND VGND VPWR VPWR _1383_ sky130_fd_sc_hd__inv_2
X_6237_ clknet_leaf_0_clk _0645_ _0170_ VGND VGND VPWR VPWR reg_file_inst.registry\[4\]\[2\]
+ sky130_fd_sc_hd__dfrtp_1
XTAP_TAPCELL_ROW_90_1393 VGND VPWR sky130_fd_sc_hd__tapvpwrvgnd_1
X_6168_ clknet_leaf_7_clk _0576_ _0101_ VGND VGND VPWR VPWR JMPOFF\[17\] sky130_fd_sc_hd__dfrtp_4
X_5119_ net137 _2460_ _2945_ VGND VGND VPWR VPWR _2946_ sky130_fd_sc_hd__a21oi_1
X_6099_ clknet_leaf_50_clk _0507_ _0032_ VGND VGND VPWR VPWR reg_file_inst.registry\[9\]\[4\]
+ sky130_fd_sc_hd__dfrtp_1
XFILLER_85_697 VPWR VGND VPWR VGND sky130_ef_sc_hd__decap_12
XFILLER_27_78 VGND VGND VPWR VPWR sky130_fd_sc_hd__decap_3
XFILLER_53_561 VGND VGND VPWR VPWR sky130_fd_sc_hd__decap_3
XFILLER_25_263 VGND VGND VPWR VPWR sky130_fd_sc_hd__decap_4
XFILLER_41_712 VGND VGND VPWR VPWR sky130_fd_sc_hd__decap_6
XFILLER_9_407 VGND VGND VPWR VPWR sky130_fd_sc_hd__decap_4
XFILLER_13_436 VPWR VGND VPWR VGND sky130_ef_sc_hd__decap_12
XFILLER_43_44 VPWR VGND VPWR VGND sky130_ef_sc_hd__decap_12
XFILLER_9_429 VGND VGND VPWR VPWR sky130_fd_sc_hd__decap_4
XFILLER_21_480 VGND VGND VPWR VPWR sky130_fd_sc_hd__fill_2
XFILLER_21_491 VPWR VGND VPWR VGND sky130_ef_sc_hd__decap_12
XFILLER_4_123 VGND VGND VPWR VPWR sky130_fd_sc_hd__fill_2
XFILLER_107_541 VPWR VGND VPWR VGND sky130_ef_sc_hd__decap_12
XFILLER_122_533 VPWR VGND VPWR VGND sky130_ef_sc_hd__decap_12
XFILLER_107_585 VPWR VGND VPWR VGND sky130_ef_sc_hd__decap_12
XFILLER_68_85 VGND VGND VPWR VPWR sky130_fd_sc_hd__decap_4
XFILLER_0_362 VGND VGND VPWR VPWR sky130_fd_sc_hd__fill_2
XFILLER_88_491 VGND VGND VPWR VPWR sky130_fd_sc_hd__fill_1
XFILLER_48_344 VPWR VGND VPWR VGND sky130_ef_sc_hd__decap_12
XFILLER_90_122 VGND VGND VPWR VPWR sky130_fd_sc_hd__decap_3
XFILLER_84_73 VGND VGND VPWR VPWR sky130_fd_sc_hd__decap_8
XFILLER_16_241 VGND VGND VPWR VPWR sky130_fd_sc_hd__decap_8
XFILLER_32_701 VPWR VGND VPWR VGND sky130_ef_sc_hd__decap_12
XFILLER_71_391 VGND VGND VPWR VPWR sky130_fd_sc_hd__fill_1
XTAP_TAPCELL_ROW_14_442 VGND VPWR sky130_fd_sc_hd__tapvpwrvgnd_1
XTAP_TAPCELL_ROW_42_784 VGND VPWR sky130_fd_sc_hd__tapvpwrvgnd_1
XTAP_TAPCELL_ROW_42_795 VGND VPWR sky130_fd_sc_hd__tapvpwrvgnd_1
XFILLER_117_305 VPWR VGND VPWR VGND sky130_ef_sc_hd__decap_12
X_5470_ reg_file_inst.registry\[5\]\[6\] _2375_ _2999_ VGND VGND VPWR VPWR _0593_
+ sky130_fd_sc_hd__mux2_1
XFILLER_117_349 VPWR VGND VPWR VGND sky130_ef_sc_hd__decap_12
X_4421_ _2125_ _2307_ VGND VGND VPWR VPWR _2308_ sky130_fd_sc_hd__nand2_8
X_4352_ _1171_ _1840_ _2190_ VGND VGND VPWR VPWR _2240_ sky130_fd_sc_hd__and3_1
X_3303_ MEMOFF\[23\] net88 _1113_ VGND VGND VPWR VPWR _1242_ sky130_fd_sc_hd__mux2_8
X_4283_ _2168_ _2169_ _2149_ VGND VGND VPWR VPWR _2171_ sky130_fd_sc_hd__a21o_1
X_3234_ reg_file_inst.registry\[8\]\[25\] _1090_ _1092_ reg_file_inst.registry\[4\]\[25\]
+ VGND VGND VPWR VPWR _1176_ sky130_fd_sc_hd__a22o_1
XFILLER_86_428 VGND VGND VPWR VPWR sky130_fd_sc_hd__decap_3
XFILLER_86_417 VGND VGND VPWR VPWR sky130_fd_sc_hd__decap_3
X_6022_ net148 VGND VGND VPWR VPWR _0430_ sky130_fd_sc_hd__inv_2
XFILLER_39_322 VPWR VGND VPWR VGND sky130_ef_sc_hd__decap_12
XFILLER_82_601 VPWR VGND VPWR VGND sky130_ef_sc_hd__decap_12
XFILLER_66_141 VPWR VGND VPWR VGND sky130_ef_sc_hd__decap_12
X_3165_ _1108_ VGND VGND VPWR VPWR _1109_ sky130_fd_sc_hd__inv_2
XFILLER_82_645 VPWR VGND VPWR VGND sky130_ef_sc_hd__decap_12
XTAP_TAPCELL_ROW_68_1115 VGND VPWR sky130_fd_sc_hd__tapvpwrvgnd_1
XFILLER_67_697 VGND VGND VPWR VPWR sky130_fd_sc_hd__decap_6
XFILLER_54_336 VGND VGND VPWR VPWR sky130_fd_sc_hd__decap_4
X_3096_ _1036_ _1039_ VGND VGND VPWR VPWR _1040_ sky130_fd_sc_hd__nor2_1
XFILLER_81_133 VPWR VGND VPWR VGND sky130_ef_sc_hd__decap_12
X_5806_ net147 VGND VGND VPWR VPWR _0214_ sky130_fd_sc_hd__inv_2
X_3998_ net131 _1912_ _1913_ net105 VGND VGND VPWR VPWR _1914_ sky130_fd_sc_hd__a31oi_1
X_5737_ net149 VGND VGND VPWR VPWR _0145_ sky130_fd_sc_hd__inv_2
XTAP_TAPCELL_ROW_79_1255 VGND VPWR sky130_fd_sc_hd__tapvpwrvgnd_1
X_5668_ net149 VGND VGND VPWR VPWR _0076_ sky130_fd_sc_hd__inv_2
XTAP_TAPCELL_ROW_92_1411 VGND VPWR sky130_fd_sc_hd__tapvpwrvgnd_1
X_5599_ net146 VGND VGND VPWR VPWR _0007_ sky130_fd_sc_hd__inv_2
X_4619_ net136 _2279_ _2318_ _2493_ VGND VGND VPWR VPWR _2496_ sky130_fd_sc_hd__a31o_1
XFILLER_104_533 VPWR VGND VPWR VGND sky130_ef_sc_hd__decap_12
XFILLER_1_137 VPWR VGND VPWR VGND sky130_ef_sc_hd__decap_12
XFILLER_58_642 VGND VGND VPWR VPWR sky130_fd_sc_hd__fill_2
XFILLER_58_664 VGND VGND VPWR VPWR sky130_fd_sc_hd__decap_8
XFILLER_57_152 VPWR VGND VPWR VGND sky130_ef_sc_hd__decap_12
XFILLER_57_130 VGND VGND VPWR VPWR sky130_fd_sc_hd__fill_2
XFILLER_73_634 VGND VGND VPWR VPWR sky130_fd_sc_hd__fill_1
XFILLER_72_111 VGND VGND VPWR VPWR sky130_fd_sc_hd__decap_8
XFILLER_72_133 VGND VGND VPWR VPWR sky130_fd_sc_hd__decap_6
XFILLER_60_306 VGND VGND VPWR VPWR sky130_fd_sc_hd__fill_2
XFILLER_54_65 VGND VGND VPWR VPWR sky130_fd_sc_hd__fill_1
XFILLER_14_701 VGND VGND VPWR VPWR sky130_fd_sc_hd__decap_4
XFILLER_13_233 VGND VGND VPWR VPWR sky130_fd_sc_hd__fill_1
XTAP_TAPCELL_ROW_11_401 VGND VPWR sky130_fd_sc_hd__tapvpwrvgnd_1
XFILLER_9_237 VGND VGND VPWR VPWR sky130_fd_sc_hd__fill_2
XFILLER_13_277 VGND VGND VPWR VPWR sky130_fd_sc_hd__decap_3
Xclkload29 clknet_leaf_23_clk VGND VGND VPWR VPWR clkload29/Y sky130_fd_sc_hd__clkinv_2
Xclkload18 clknet_leaf_9_clk VGND VGND VPWR VPWR clkload18/Y sky130_fd_sc_hd__inv_6
XFILLER_70_97 VPWR VGND VPWR VGND sky130_ef_sc_hd__decap_12
XFILLER_5_443 VGND VGND VPWR VPWR sky130_fd_sc_hd__decap_4
XFILLER_5_432 VGND VGND VPWR VPWR sky130_fd_sc_hd__decap_4
XFILLER_107_393 VPWR VGND VPWR VGND sky130_ef_sc_hd__decap_12
XFILLER_110_525 VGND VGND VPWR VPWR sky130_fd_sc_hd__decap_6
XFILLER_1_671 VGND VGND VPWR VPWR sky130_fd_sc_hd__fill_1
XFILLER_95_225 VPWR VGND VPWR VGND sky130_ef_sc_hd__decap_12
XFILLER_110_569 VPWR VGND VPWR VGND sky130_ef_sc_hd__decap_12
XFILLER_64_601 VGND VGND VPWR VPWR sky130_fd_sc_hd__decap_4
XFILLER_48_141 VGND VGND VPWR VPWR sky130_fd_sc_hd__decap_8
XFILLER_64_645 VGND VGND VPWR VPWR sky130_fd_sc_hd__fill_2
XFILLER_63_111 VGND VGND VPWR VPWR sky130_fd_sc_hd__fill_1
XTAP_TAPCELL_ROW_19_501 VGND VPWR sky130_fd_sc_hd__tapvpwrvgnd_1
XFILLER_36_325 VGND VGND VPWR VPWR sky130_fd_sc_hd__fill_2
XFILLER_36_336 VGND VGND VPWR VPWR sky130_fd_sc_hd__decap_8
XFILLER_48_174 VPWR VGND VPWR VGND sky130_ef_sc_hd__decap_12
XFILLER_49_697 VGND VGND VPWR VPWR sky130_fd_sc_hd__decap_8
XTAP_TAPCELL_ROW_47_854 VGND VPWR sky130_fd_sc_hd__tapvpwrvgnd_1
X_4970_ reg_file_inst.registry\[7\]\[22\] _2817_ _2553_ VGND VGND VPWR VPWR _0897_
+ sky130_fd_sc_hd__mux2_1
XFILLER_51_306 VGND VGND VPWR VPWR sky130_fd_sc_hd__decap_4
XFILLER_32_520 VPWR VGND VPWR VGND sky130_ef_sc_hd__decap_12
X_3921_ MEMOFF\[0\] _1079_ _1829_ _1830_ _1837_ VGND VGND VPWR VPWR _1838_ sky130_fd_sc_hd__a2111o_1
XTAP_TAPCELL_ROW_63_1056 VGND VPWR sky130_fd_sc_hd__tapvpwrvgnd_1
X_3852_ reg_file_inst.registry\[7\]\[3\] _1133_ _1140_ reg_file_inst.registry\[3\]\[3\]
+ VGND VGND VPWR VPWR _1772_ sky130_fd_sc_hd__a22o_1
XFILLER_32_553 VGND VGND VPWR VPWR sky130_fd_sc_hd__fill_2
XFILLER_118_625 VPWR VGND VPWR VGND sky130_ef_sc_hd__decap_12
X_5522_ reg_file_inst.registry\[6\]\[12\] _2934_ _3001_ VGND VGND VPWR VPWR _0543_
+ sky130_fd_sc_hd__mux2_1
X_3783_ reg_file_inst.registry\[8\]\[4\] _1090_ _1697_ _1698_ _1700_ VGND VGND VPWR
+ VPWR _1705_ sky130_fd_sc_hd__a2111o_1
XFILLER_117_113 VPWR VGND VPWR VGND sky130_ef_sc_hd__decap_12
XFILLER_8_281 VPWR VGND VPWR VGND sky130_ef_sc_hd__decap_12
XFILLER_118_669 VPWR VGND VPWR VGND sky130_ef_sc_hd__decap_12
X_5453_ reg_file_inst.registry\[5\]\[23\] _2806_ _2999_ VGND VGND VPWR VPWR _0610_
+ sky130_fd_sc_hd__mux2_1
X_4404_ _1667_ _2282_ _2285_ _1668_ _2291_ VGND VGND VPWR VPWR _2292_ sky130_fd_sc_hd__o221a_1
X_5384_ MEMOFF\[5\] _2419_ _2996_ VGND VGND VPWR VPWR _0676_ sky130_fd_sc_hd__mux2_1
X_4335_ _2220_ _2222_ VGND VGND VPWR VPWR _2223_ sky130_fd_sc_hd__nor2_1
XFILLER_115_27 VPWR VGND VPWR VGND sky130_ef_sc_hd__decap_12
XFILLER_99_597 VPWR VGND VPWR VGND sky130_ef_sc_hd__decap_12
XFILLER_86_203 VGND VGND VPWR VPWR sky130_fd_sc_hd__fill_1
XTAP_TAPCELL_ROW_74_1185 VGND VPWR sky130_fd_sc_hd__tapvpwrvgnd_1
XFILLER_113_385 VGND VGND VPWR VPWR sky130_fd_sc_hd__decap_6
X_4266_ _2152_ _2153_ VGND VGND VPWR VPWR _2154_ sky130_fd_sc_hd__nand2b_1
X_3217_ MEMOFF\[26\] _1079_ _1093_ reg_file_inst.registry\[15\]\[26\] _1159_ VGND
+ VGND VPWR VPWR _1160_ sky130_fd_sc_hd__a221o_1
X_6005_ net147 VGND VGND VPWR VPWR _0413_ sky130_fd_sc_hd__inv_2
X_4197_ _1976_ _1981_ _1979_ VGND VGND VPWR VPWR _2096_ sky130_fd_sc_hd__o21ai_1
XFILLER_39_141 VPWR VGND VPWR VGND sky130_ef_sc_hd__decap_12
XPHY_EDGE_ROW_19_Left_142 VGND VGND VPWR VPWR sky130_fd_sc_hd__decap_3
X_3148_ _1074_ _1084_ VGND VGND VPWR VPWR _1092_ sky130_fd_sc_hd__and2_4
XFILLER_55_678 VPWR VGND VPWR VGND sky130_ef_sc_hd__decap_12
XFILLER_82_486 VPWR VGND VPWR VGND sky130_ef_sc_hd__decap_12
XFILLER_70_637 VGND VGND VPWR VPWR sky130_fd_sc_hd__fill_1
XFILLER_54_177 VGND VGND VPWR VPWR sky130_fd_sc_hd__decap_8
X_3079_ _0999_ _1022_ _0997_ VGND VGND VPWR VPWR _1023_ sky130_fd_sc_hd__a21oi_1
XFILLER_42_317 VPWR VGND VPWR VGND sky130_ef_sc_hd__decap_12
XFILLER_23_520 VPWR VGND VPWR VGND sky130_ef_sc_hd__decap_12
XFILLER_35_391 VGND VGND VPWR VPWR sky130_fd_sc_hd__fill_1
XFILLER_50_361 VGND VGND VPWR VPWR sky130_fd_sc_hd__decap_3
XPHY_EDGE_ROW_28_Left_151 VGND VGND VPWR VPWR sky130_fd_sc_hd__decap_3
XFILLER_40_78 VGND VGND VPWR VPWR sky130_fd_sc_hd__decap_6
XFILLER_104_363 VGND VGND VPWR VPWR sky130_fd_sc_hd__fill_1
XPHY_EDGE_ROW_37_Left_160 VGND VGND VPWR VPWR sky130_fd_sc_hd__decap_3
XFILLER_105_93 VPWR VGND VPWR VGND sky130_ef_sc_hd__decap_12
XFILLER_100_580 VGND VGND VPWR VPWR sky130_fd_sc_hd__decap_8
XFILLER_65_42 VGND VGND VPWR VPWR sky130_fd_sc_hd__decap_8
XFILLER_58_494 VGND VGND VPWR VPWR sky130_fd_sc_hd__fill_1
XFILLER_58_472 VGND VGND VPWR VPWR sky130_fd_sc_hd__decap_4
XFILLER_1_39 VPWR VGND VPWR VGND sky130_ef_sc_hd__decap_12
XFILLER_65_75 VGND VGND VPWR VPWR sky130_fd_sc_hd__decap_4
XFILLER_65_53 VGND VGND VPWR VPWR sky130_fd_sc_hd__decap_3
XFILLER_46_656 VGND VGND VPWR VPWR sky130_fd_sc_hd__decap_8
XFILLER_61_637 VGND VGND VPWR VPWR sky130_fd_sc_hd__fill_2
XFILLER_61_604 VGND VGND VPWR VPWR sky130_fd_sc_hd__decap_3
XFILLER_33_328 VGND VGND VPWR VPWR sky130_fd_sc_hd__decap_8
XTAP_TAPCELL_ROW_44_813 VGND VPWR sky130_fd_sc_hd__tapvpwrvgnd_1
XFILLER_121_81 VPWR VGND VPWR VGND sky130_ef_sc_hd__decap_12
XFILLER_14_553 VPWR VGND VPWR VGND sky130_ef_sc_hd__decap_12
XTAP_TAPCELL_ROW_24_570 VGND VPWR sky130_fd_sc_hd__tapvpwrvgnd_1
XFILLER_41_361 VGND VGND VPWR VPWR sky130_fd_sc_hd__decap_8
XFILLER_41_372 VPWR VGND VPWR VGND sky130_ef_sc_hd__decap_12
XPHY_EDGE_ROW_116_Right_116 VGND VGND VPWR VPWR sky130_fd_sc_hd__decap_3
XFILLER_115_617 VPWR VGND VPWR VGND sky130_ef_sc_hd__decap_12
XTAP_TAPCELL_ROW_110_1639 VGND VPWR sky130_fd_sc_hd__tapvpwrvgnd_1
XFILLER_69_715 VGND VGND VPWR VPWR sky130_fd_sc_hd__decap_3
XFILLER_122_193 VGND VGND VPWR VPWR sky130_fd_sc_hd__decap_3
XFILLER_110_333 VPWR VGND VPWR VGND sky130_ef_sc_hd__decap_12
X_4120_ _2019_ _2020_ _2035_ VGND VGND VPWR VPWR _2036_ sky130_fd_sc_hd__a21o_1
XFILLER_96_589 VPWR VGND VPWR VGND sky130_ef_sc_hd__decap_12
X_4051_ _1952_ _1966_ _1949_ VGND VGND VPWR VPWR _1967_ sky130_fd_sc_hd__a21o_1
XFILLER_110_377 VPWR VGND VPWR VGND sky130_ef_sc_hd__decap_12
Xinput5 DataMemoryRead[13] VGND VGND VPWR VPWR net5 sky130_fd_sc_hd__clkbuf_2
XFILLER_76_291 VGND VGND VPWR VPWR sky130_fd_sc_hd__fill_2
XFILLER_64_464 VGND VGND VPWR VPWR sky130_fd_sc_hd__fill_1
X_4953_ _1709_ _2302_ _2803_ VGND VGND VPWR VPWR _2804_ sky130_fd_sc_hd__a21o_1
XFILLER_24_328 VPWR VGND VPWR VGND sky130_ef_sc_hd__decap_12
X_3904_ reg_file_inst.registry\[2\]\[1\] _1137_ _1819_ _1820_ _1821_ VGND VGND VPWR
+ VPWR _1822_ sky130_fd_sc_hd__a2111o_1
XTAP_TAPCELL_ROW_121_1779 VGND VPWR sky130_fd_sc_hd__tapvpwrvgnd_1
X_4884_ _1765_ _2296_ _2497_ _2737_ _2740_ VGND VGND VPWR VPWR _2741_ sky130_fd_sc_hd__a311o_1
X_3835_ reg_file_inst.registry\[14\]\[3\] _1081_ _1083_ reg_file_inst.registry\[2\]\[3\]
+ VGND VGND VPWR VPWR _1755_ sky130_fd_sc_hd__a22o_1
XFILLER_118_433 VPWR VGND VPWR VGND sky130_ef_sc_hd__decap_12
X_3766_ reg_file_inst.registry\[5\]\[6\] _1139_ _1140_ reg_file_inst.registry\[3\]\[6\]
+ VGND VGND VPWR VPWR _1689_ sky130_fd_sc_hd__a22o_1
X_6485_ clknet_leaf_9_clk _0893_ _0418_ VGND VGND VPWR VPWR reg_file_inst.registry\[7\]\[18\]
+ sky130_fd_sc_hd__dfrtp_1
XTAP_TAPCELL_ROW_76_1214 VGND VPWR sky130_fd_sc_hd__tapvpwrvgnd_1
X_5505_ JMPOFF\[0\] _2550_ _3000_ VGND VGND VPWR VPWR _0559_ sky130_fd_sc_hd__mux2_1
XFILLER_118_477 VPWR VGND VPWR VGND sky130_ef_sc_hd__decap_12
XFILLER_105_105 VGND VGND VPWR VPWR sky130_fd_sc_hd__decap_6
XFILLER_10_15 VPWR VGND VPWR VGND sky130_ef_sc_hd__decap_12
X_3697_ _1582_ _1594_ _1608_ _1620_ VGND VGND VPWR VPWR _1621_ sky130_fd_sc_hd__o22a_1
X_5436_ _2948_ reg_file_inst.registry\[10\]\[11\] _2998_ VGND VGND VPWR VPWR _0626_
+ sky130_fd_sc_hd__mux2_1
XFILLER_121_609 VGND VGND VPWR VPWR sky130_fd_sc_hd__decap_6
XFILLER_105_149 VPWR VGND VPWR VGND sky130_ef_sc_hd__decap_12
X_5367_ MEMOFF\[22\] _2817_ _2996_ VGND VGND VPWR VPWR _0693_ sky130_fd_sc_hd__mux2_1
XFILLER_59_225 VGND VGND VPWR VPWR sky130_fd_sc_hd__fill_1
X_4318_ _1345_ _2190_ VGND VGND VPWR VPWR _2206_ sky130_fd_sc_hd__and2_1
X_5298_ _2455_ reg_file_inst.registry\[2\]\[4\] _2993_ VGND VGND VPWR VPWR _0759_
+ sky130_fd_sc_hd__mux2_1
XFILLER_113_193 VPWR VGND VPWR VGND sky130_ef_sc_hd__decap_12
XFILLER_101_333 VGND VGND VPWR VPWR sky130_fd_sc_hd__decap_3
XFILLER_87_556 VGND VGND VPWR VPWR sky130_fd_sc_hd__decap_4
X_4249_ _2135_ _2136_ VGND VGND VPWR VPWR _2137_ sky130_fd_sc_hd__nor2_1
XFILLER_74_228 VGND VGND VPWR VPWR sky130_fd_sc_hd__decap_4
XFILLER_19_57 VPWR VGND VPWR VGND sky130_ef_sc_hd__decap_12
XFILLER_27_111 VGND VGND VPWR VPWR sky130_fd_sc_hd__fill_1
XTAP_TAPCELL_ROW_87_1354 VGND VPWR sky130_fd_sc_hd__tapvpwrvgnd_1
XTAP_TAPCELL_ROW_2_287 VGND VPWR sky130_fd_sc_hd__tapvpwrvgnd_1
XFILLER_28_678 VGND VGND VPWR VPWR sky130_fd_sc_hd__decap_8
XFILLER_35_34 VGND VGND VPWR VPWR sky130_fd_sc_hd__fill_1
XFILLER_43_626 VGND VGND VPWR VPWR sky130_fd_sc_hd__decap_3
XFILLER_70_434 VGND VGND VPWR VPWR sky130_fd_sc_hd__fill_2
XFILLER_42_125 VPWR VGND VPWR VGND sky130_ef_sc_hd__decap_12
XFILLER_51_692 VGND VGND VPWR VPWR sky130_fd_sc_hd__decap_4
XFILLER_51_22 VGND VGND VPWR VPWR sky130_fd_sc_hd__decap_8
XFILLER_11_534 VPWR VGND VPWR VGND sky130_ef_sc_hd__decap_12
XFILLER_7_505 VPWR VGND VPWR VGND sky130_ef_sc_hd__decap_12
XFILLER_51_77 VPWR VGND VPWR VGND sky130_ef_sc_hd__decap_12
XFILLER_51_55 VGND VGND VPWR VPWR sky130_fd_sc_hd__fill_1
XTAP_TAPCELL_ROW_98_1483 VGND VPWR sky130_fd_sc_hd__tapvpwrvgnd_1
XTAP_TAPCELL_ROW_98_1494 VGND VPWR sky130_fd_sc_hd__tapvpwrvgnd_1
XFILLER_78_501 VPWR VGND VPWR VGND sky130_ef_sc_hd__decap_12
XFILLER_78_589 VPWR VGND VPWR VGND sky130_ef_sc_hd__decap_12
XFILLER_65_217 VGND VGND VPWR VPWR sky130_fd_sc_hd__decap_6
XFILLER_65_206 VGND VGND VPWR VPWR sky130_fd_sc_hd__decap_8
XFILLER_58_291 VGND VGND VPWR VPWR sky130_fd_sc_hd__fill_2
XFILLER_18_122 VGND VGND VPWR VPWR sky130_fd_sc_hd__decap_3
XTAP_TAPCELL_ROW_57_982 VGND VPWR sky130_fd_sc_hd__tapvpwrvgnd_1
XTAP_TAPCELL_ROW_57_971 VGND VPWR sky130_fd_sc_hd__tapvpwrvgnd_1
XFILLER_46_453 VGND VGND VPWR VPWR sky130_fd_sc_hd__fill_1
XFILLER_33_125 VGND VGND VPWR VPWR sky130_fd_sc_hd__decap_8
XFILLER_61_467 VGND VGND VPWR VPWR sky130_fd_sc_hd__fill_1
XFILLER_33_169 VGND VGND VPWR VPWR sky130_fd_sc_hd__decap_8
XTAP_TAPCELL_ROW_60_1015 VGND VPWR sky130_fd_sc_hd__tapvpwrvgnd_1
X_3620_ JMPOFF\[10\] _1095_ _1097_ reg_file_inst.registry\[5\]\[10\] _1546_ VGND VGND
+ VPWR VPWR _1547_ sky130_fd_sc_hd__a221o_1
X_3551_ reg_file_inst.registry\[5\]\[15\] _1127_ net142 VGND VGND VPWR VPWR _1481_
+ sky130_fd_sc_hd__and3_1
XFILLER_115_447 VGND VGND VPWR VPWR sky130_fd_sc_hd__fill_1
X_3482_ reg_file_inst.registry\[2\]\[17\] _1137_ _1405_ _1406_ _1407_ VGND VGND VPWR
+ VPWR _1415_ sky130_fd_sc_hd__a2111o_1
X_6270_ clknet_leaf_45_clk _0678_ _0203_ VGND VGND VPWR VPWR MEMOFF\[7\] sky130_fd_sc_hd__dfrtp_2
XFILLER_103_609 VGND VGND VPWR VPWR sky130_fd_sc_hd__decap_6
XFILLER_88_309 VGND VGND VPWR VPWR sky130_fd_sc_hd__decap_8
X_5221_ _2817_ reg_file_inst.registry\[1\]\[22\] _2990_ VGND VGND VPWR VPWR _0833_
+ sky130_fd_sc_hd__mux2_1
XFILLER_69_501 VGND VGND VPWR VPWR sky130_fd_sc_hd__decap_3
X_5152_ net28 net101 net72 _2308_ VGND VGND VPWR VPWR _2974_ sky130_fd_sc_hd__a22o_4
XFILLER_111_653 VPWR VGND VPWR VGND sky130_ef_sc_hd__decap_12
XFILLER_110_141 VPWR VGND VPWR VGND sky130_ef_sc_hd__decap_12
XTAP_TAPCELL_ROW_71_1155 VGND VPWR sky130_fd_sc_hd__tapvpwrvgnd_1
X_4103_ _2009_ _2012_ _2014_ _2018_ _2013_ VGND VGND VPWR VPWR _2019_ sky130_fd_sc_hd__o221a_1
XFILLER_29_409 VPWR VGND VPWR VGND sky130_ef_sc_hd__decap_12
XFILLER_111_697 VPWR VGND VPWR VGND sky130_ef_sc_hd__decap_12
X_5083_ _1458_ _1469_ _2284_ _2913_ VGND VGND VPWR VPWR _2914_ sky130_fd_sc_hd__a31o_1
XFILLER_84_548 VPWR VGND VPWR VGND sky130_ef_sc_hd__decap_12
XFILLER_56_239 VGND VGND VPWR VPWR sky130_fd_sc_hd__decap_8
X_4034_ _1013_ _1015_ VGND VGND VPWR VPWR _1950_ sky130_fd_sc_hd__nand2_1
XFILLER_64_250 VGND VGND VPWR VPWR sky130_fd_sc_hd__fill_2
X_5985_ net149 VGND VGND VPWR VPWR _0393_ sky130_fd_sc_hd__inv_2
XFILLER_24_147 VGND VGND VPWR VPWR sky130_fd_sc_hd__fill_1
XFILLER_24_169 VGND VGND VPWR VPWR sky130_fd_sc_hd__fill_2
X_4936_ reg_file_inst.registry\[7\]\[24\] _2787_ _2553_ VGND VGND VPWR VPWR _0899_
+ sky130_fd_sc_hd__mux2_1
XTAP_TAPCELL_ROW_35_698 VGND VPWR sky130_fd_sc_hd__tapvpwrvgnd_1
XANTENNA_21 net89 VGND VGND VPWR VPWR sky130_fd_sc_hd__diode_2
XTAP_TAPCELL_ROW_82_1295 VGND VPWR sky130_fd_sc_hd__tapvpwrvgnd_1
XTAP_TAPCELL_ROW_82_1284 VGND VPWR sky130_fd_sc_hd__tapvpwrvgnd_1
XANTENNA_10 _1132_ VGND VGND VPWR VPWR sky130_fd_sc_hd__diode_2
X_4867_ _2328_ _2344_ VGND VGND VPWR VPWR _2724_ sky130_fd_sc_hd__nor2_1
X_3818_ _1737_ _1738_ VGND VGND VPWR VPWR _1739_ sky130_fd_sc_hd__or2_1
X_6537_ clknet_leaf_39_clk _0945_ _0470_ VGND VGND VPWR VPWR net117 sky130_fd_sc_hd__dfrtp_1
X_4798_ _1334_ _2562_ VGND VGND VPWR VPWR _2657_ sky130_fd_sc_hd__xnor2_1
X_3749_ JMPOFF\[6\] _1095_ _1097_ reg_file_inst.registry\[5\]\[6\] VGND VGND VPWR
+ VPWR _1672_ sky130_fd_sc_hd__a22o_1
X_6468_ clknet_leaf_44_clk _0876_ _0401_ VGND VGND VPWR VPWR reg_file_inst.registry\[7\]\[1\]
+ sky130_fd_sc_hd__dfrtp_1
XFILLER_121_417 VPWR VGND VPWR VGND sky130_ef_sc_hd__decap_12
XFILLER_106_469 VGND VGND VPWR VPWR sky130_fd_sc_hd__decap_6
X_6399_ clknet_leaf_32_clk _0807_ _0332_ VGND VGND VPWR VPWR reg_file_inst.registry\[14\]\[24\]
+ sky130_fd_sc_hd__dfrtp_1
X_5419_ _1124_ _2117_ _2120_ VGND VGND VPWR VPWR _2998_ sky130_fd_sc_hd__or3_4
XTAP_TAPCELL_ROW_7_357 VGND VPWR sky130_fd_sc_hd__tapvpwrvgnd_1
XTAP_TAPCELL_ROW_7_346 VGND VPWR sky130_fd_sc_hd__tapvpwrvgnd_1
XFILLER_62_209 VGND VGND VPWR VPWR sky130_fd_sc_hd__fill_1
XFILLER_55_294 VGND VGND VPWR VPWR sky130_fd_sc_hd__decap_4
XFILLER_16_626 VGND VGND VPWR VPWR sky130_fd_sc_hd__fill_1
XFILLER_70_253 VGND VGND VPWR VPWR sky130_fd_sc_hd__fill_2
XTAP_TAPCELL_ROW_54_941 VGND VPWR sky130_fd_sc_hd__tapvpwrvgnd_1
XFILLER_102_83 VGND VGND VPWR VPWR sky130_fd_sc_hd__fill_1
XFILLER_11_331 VGND VGND VPWR VPWR sky130_fd_sc_hd__fill_1
Xcpu_150 VGND VGND VPWR VPWR cpu_150/HI IC[0] sky130_fd_sc_hd__conb_1
XFILLER_30_139 VGND VGND VPWR VPWR sky130_fd_sc_hd__fill_1
XFILLER_11_342 VGND VGND VPWR VPWR sky130_fd_sc_hd__decap_4
XFILLER_7_27 VPWR VGND VPWR VGND sky130_ef_sc_hd__decap_12
XFILLER_3_541 VPWR VGND VPWR VGND sky130_ef_sc_hd__decap_12
XFILLER_3_585 VPWR VGND VPWR VGND sky130_ef_sc_hd__decap_12
XTAP_TAPCELL_ROW_109_1630 VGND VPWR sky130_fd_sc_hd__tapvpwrvgnd_1
XFILLER_16_6 VPWR VGND VPWR VGND sky130_ef_sc_hd__decap_12
XFILLER_93_367 VGND VGND VPWR VPWR sky130_fd_sc_hd__decap_3
XFILLER_81_529 VGND VGND VPWR VPWR sky130_fd_sc_hd__decap_6
XFILLER_19_464 VPWR VGND VPWR VGND sky130_ef_sc_hd__decap_12
XFILLER_46_261 VGND VGND VPWR VPWR sky130_fd_sc_hd__fill_1
XFILLER_99_3 VPWR VGND VPWR VGND sky130_ef_sc_hd__decap_12
X_5770_ net149 VGND VGND VPWR VPWR _0178_ sky130_fd_sc_hd__inv_2
XFILLER_15_670 VGND VGND VPWR VPWR sky130_fd_sc_hd__fill_2
X_4721_ _1242_ _2578_ VGND VGND VPWR VPWR _2580_ sky130_fd_sc_hd__xor2_1
XFILLER_14_191 VGND VGND VPWR VPWR sky130_fd_sc_hd__decap_4
X_4652_ _2255_ _2525_ _2526_ _2522_ VGND VGND VPWR VPWR net56 sky130_fd_sc_hd__a31o_2
XTAP_TAPCELL_ROW_32_668 VGND VPWR sky130_fd_sc_hd__tapvpwrvgnd_1
Xinput30 instr[10] VGND VGND VPWR VPWR net30 sky130_fd_sc_hd__buf_4
XFILLER_30_684 VGND VGND VPWR VPWR sky130_fd_sc_hd__decap_4
X_3603_ reg_file_inst.registry\[1\]\[11\] net145 _1127_ VGND VGND VPWR VPWR _1531_
+ sky130_fd_sc_hd__and3_1
XFILLER_116_701 VPWR VGND VPWR VGND sky130_ef_sc_hd__decap_12
Xinput41 instr[7] VGND VGND VPWR VPWR net41 sky130_fd_sc_hd__buf_12
X_4583_ _2376_ _2461_ net135 VGND VGND VPWR VPWR _2462_ sky130_fd_sc_hd__mux2_1
X_3534_ reg_file_inst.registry\[10\]\[13\] _1126_ _1133_ reg_file_inst.registry\[7\]\[13\]
+ VGND VGND VPWR VPWR _1465_ sky130_fd_sc_hd__a22o_1
X_6322_ clknet_leaf_5_clk _0730_ _0255_ VGND VGND VPWR VPWR reg_file_inst.registry\[8\]\[3\]
+ sky130_fd_sc_hd__dfrtp_1
XFILLER_107_39 VPWR VGND VPWR VGND sky130_ef_sc_hd__decap_12
XFILLER_89_629 VPWR VGND VPWR VGND sky130_ef_sc_hd__decap_12
X_6253_ clknet_leaf_9_clk _0661_ _0186_ VGND VGND VPWR VPWR reg_file_inst.registry\[4\]\[18\]
+ sky130_fd_sc_hd__dfrtp_1
X_3465_ reg_file_inst.registry\[9\]\[17\] _1089_ _1093_ reg_file_inst.registry\[15\]\[17\]
+ VGND VGND VPWR VPWR _1398_ sky130_fd_sc_hd__a22o_1
XFILLER_103_428 VGND VGND VPWR VPWR sky130_fd_sc_hd__fill_1
XFILLER_88_117 VPWR VGND VPWR VGND sky130_ef_sc_hd__decap_12
X_5204_ _2528_ reg_file_inst.registry\[0\]\[1\] _2988_ VGND VGND VPWR VPWR _0848_
+ sky130_fd_sc_hd__mux2_1
X_3396_ _1328_ _1329_ _1330_ _1331_ VGND VGND VPWR VPWR _1332_ sky130_fd_sc_hd__or4_2
X_6184_ clknet_leaf_44_clk _0592_ _0117_ VGND VGND VPWR VPWR reg_file_inst.registry\[5\]\[5\]
+ sky130_fd_sc_hd__dfrtp_1
XFILLER_111_461 VPWR VGND VPWR VGND sky130_ef_sc_hd__decap_12
XFILLER_97_673 VPWR VGND VPWR VGND sky130_ef_sc_hd__decap_12
XTAP_TAPCELL_ROW_4_316 VGND VPWR sky130_fd_sc_hd__tapvpwrvgnd_1
X_5135_ _2176_ _2949_ _2958_ _2959_ VGND VGND VPWR VPWR net46 sky130_fd_sc_hd__a211o_2
X_5066_ _1764_ _2347_ VGND VGND VPWR VPWR _2899_ sky130_fd_sc_hd__or2_1
XFILLER_84_389 VPWR VGND VPWR VGND sky130_ef_sc_hd__decap_12
X_4017_ net127 _1878_ _1932_ VGND VGND VPWR VPWR _1933_ sky130_fd_sc_hd__and3_1
XFILLER_44_209 VPWR VGND VPWR VGND sky130_ef_sc_hd__decap_12
XTAP_TAPCELL_ROW_84_1313 VGND VPWR sky130_fd_sc_hd__tapvpwrvgnd_1
XFILLER_52_253 VGND VGND VPWR VPWR sky130_fd_sc_hd__decap_6
XFILLER_52_286 VGND VGND VPWR VPWR sky130_fd_sc_hd__fill_1
XTAP_TAPCELL_ROW_51_900 VGND VPWR sky130_fd_sc_hd__tapvpwrvgnd_1
XFILLER_13_629 VGND VGND VPWR VPWR sky130_fd_sc_hd__fill_1
X_5968_ net149 VGND VGND VPWR VPWR _0376_ sky130_fd_sc_hd__inv_2
X_4919_ _2727_ _2732_ net134 VGND VGND VPWR VPWR _2772_ sky130_fd_sc_hd__mux2_1
X_5899_ net44 VGND VGND VPWR VPWR _0307_ sky130_fd_sc_hd__inv_2
XFILLER_21_673 VPWR VGND VPWR VGND sky130_ef_sc_hd__decap_12
XFILLER_119_561 VPWR VGND VPWR VGND sky130_ef_sc_hd__decap_12
XFILLER_106_233 VPWR VGND VPWR VGND sky130_ef_sc_hd__decap_12
XTAP_TAPCELL_ROW_95_1453 VGND VPWR sky130_fd_sc_hd__tapvpwrvgnd_1
XFILLER_121_225 VPWR VGND VPWR VGND sky130_ef_sc_hd__decap_12
XFILLER_106_277 VPWR VGND VPWR VGND sky130_ef_sc_hd__decap_12
XFILLER_0_533 VGND VGND VPWR VPWR sky130_fd_sc_hd__decap_8
XFILLER_87_194 VPWR VGND VPWR VGND sky130_ef_sc_hd__decap_12
XFILLER_75_356 VGND VGND VPWR VPWR sky130_fd_sc_hd__fill_2
XFILLER_28_261 VPWR VGND VPWR VGND sky130_ef_sc_hd__decap_12
XFILLER_113_93 VPWR VGND VPWR VGND sky130_ef_sc_hd__decap_12
XTAP_TAPCELL_ROW_104_1560 VGND VPWR sky130_fd_sc_hd__tapvpwrvgnd_1
XFILLER_16_489 VGND VGND VPWR VPWR sky130_fd_sc_hd__fill_2
XFILLER_7_154 VPWR VGND VPWR VGND sky130_ef_sc_hd__decap_12
XFILLER_8_699 VGND VGND VPWR VPWR sky130_fd_sc_hd__fill_1
XFILLER_22_90 VPWR VGND VPWR VGND sky130_ef_sc_hd__decap_12
XFILLER_98_61 VGND VGND VPWR VPWR sky130_fd_sc_hd__fill_1
XFILLER_98_83 VGND VGND VPWR VPWR sky130_fd_sc_hd__fill_1
X_3250_ reg_file_inst.registry\[14\]\[25\] _1138_ _1141_ reg_file_inst.registry\[11\]\[25\]
+ _1190_ VGND VGND VPWR VPWR _1192_ sky130_fd_sc_hd__a221o_1
XFILLER_3_393 VGND VGND VPWR VPWR sky130_fd_sc_hd__decap_4
XFILLER_94_610 VPWR VGND VPWR VGND sky130_ef_sc_hd__decap_12
X_3181_ net34 net36 net37 VGND VGND VPWR VPWR _1125_ sky130_fd_sc_hd__nor3b_4
XFILLER_79_673 VPWR VGND VPWR VGND sky130_ef_sc_hd__decap_12
XFILLER_66_301 VGND VGND VPWR VPWR sky130_fd_sc_hd__decap_6
XFILLER_14_3 VPWR VGND VPWR VGND sky130_ef_sc_hd__decap_12
XTAP_TAPCELL_ROW_37_727 VGND VPWR sky130_fd_sc_hd__tapvpwrvgnd_1
XTAP_TAPCELL_ROW_66_1087 VGND VPWR sky130_fd_sc_hd__tapvpwrvgnd_1
XFILLER_50_713 VGND VGND VPWR VPWR sky130_fd_sc_hd__decap_6
XTAP_TAPCELL_ROW_17_473 VGND VPWR sky130_fd_sc_hd__tapvpwrvgnd_1
XFILLER_34_275 VGND VGND VPWR VPWR sky130_fd_sc_hd__fill_1
X_5822_ net148 VGND VGND VPWR VPWR _0230_ sky130_fd_sc_hd__inv_2
X_5753_ net146 VGND VGND VPWR VPWR _0161_ sky130_fd_sc_hd__inv_2
X_4704_ _2126_ _2180_ _2562_ VGND VGND VPWR VPWR _2563_ sky130_fd_sc_hd__o21a_1
X_5684_ net146 VGND VGND VPWR VPWR _0092_ sky130_fd_sc_hd__inv_2
X_4635_ _2162_ _2505_ _2508_ _2509_ VGND VGND VPWR VPWR _2510_ sky130_fd_sc_hd__a211o_1
XFILLER_118_27 VGND VGND VPWR VPWR sky130_fd_sc_hd__fill_1
XFILLER_116_531 VGND VGND VPWR VPWR sky130_fd_sc_hd__fill_1
X_4566_ _1708_ _2192_ _2427_ VGND VGND VPWR VPWR _2447_ sky130_fd_sc_hd__or3_1
X_6305_ clknet_leaf_11_clk _0713_ _0238_ VGND VGND VPWR VPWR reg_file_inst.registry\[3\]\[14\]
+ sky130_fd_sc_hd__dfrtp_1
X_3517_ reg_file_inst.registry\[8\]\[13\] _1090_ _1098_ reg_file_inst.registry\[10\]\[13\]
+ VGND VGND VPWR VPWR _1448_ sky130_fd_sc_hd__a22o_1
XFILLER_103_225 VGND VGND VPWR VPWR sky130_fd_sc_hd__decap_3
XFILLER_1_319 VGND VGND VPWR VPWR sky130_fd_sc_hd__decap_6
X_4497_ _1791_ _2379_ VGND VGND VPWR VPWR _2380_ sky130_fd_sc_hd__and2_1
X_3448_ reg_file_inst.registry\[0\]\[16\] net138 _1375_ _1381_ VGND VGND VPWR VPWR
+ _1382_ sky130_fd_sc_hd__o22a_2
X_6236_ clknet_leaf_44_clk _0644_ _0169_ VGND VGND VPWR VPWR reg_file_inst.registry\[4\]\[1\]
+ sky130_fd_sc_hd__dfrtp_1
XTAP_TAPCELL_ROW_90_1394 VGND VPWR sky130_fd_sc_hd__tapvpwrvgnd_1
XTAP_TAPCELL_ROW_90_1383 VGND VPWR sky130_fd_sc_hd__tapvpwrvgnd_1
X_6167_ clknet_leaf_14_clk _0575_ _0100_ VGND VGND VPWR VPWR JMPOFF\[16\] sky130_fd_sc_hd__dfrtp_4
X_3379_ MEMOFF\[20\] _1129_ _1130_ JMPOFF\[20\] _1315_ VGND VGND VPWR VPWR _1316_
+ sky130_fd_sc_hd__a221o_1
XFILLER_69_194 VGND VGND VPWR VPWR sky130_fd_sc_hd__decap_8
X_5118_ _1764_ _2459_ _1708_ VGND VGND VPWR VPWR _2945_ sky130_fd_sc_hd__a21o_1
X_6098_ clknet_leaf_5_clk _0506_ _0031_ VGND VGND VPWR VPWR reg_file_inst.registry\[9\]\[3\]
+ sky130_fd_sc_hd__dfrtp_1
XFILLER_84_197 VPWR VGND VPWR VGND sky130_ef_sc_hd__decap_12
X_5049_ _2633_ _2650_ _2647_ VGND VGND VPWR VPWR _2884_ sky130_fd_sc_hd__a21boi_1
XFILLER_38_581 VGND VGND VPWR VPWR sky130_fd_sc_hd__decap_6
XFILLER_25_220 VGND VGND VPWR VPWR sky130_fd_sc_hd__fill_1
XFILLER_53_584 VGND VGND VPWR VPWR sky130_fd_sc_hd__decap_4
XFILLER_119_391 VGND VGND VPWR VPWR sky130_fd_sc_hd__fill_1
XFILLER_107_553 VGND VGND VPWR VPWR sky130_fd_sc_hd__decap_6
XFILLER_122_501 VGND VGND VPWR VPWR sky130_fd_sc_hd__decap_3
XFILLER_107_597 VPWR VGND VPWR VGND sky130_ef_sc_hd__decap_12
XFILLER_122_545 VPWR VGND VPWR VGND sky130_ef_sc_hd__decap_12
XFILLER_122_589 VPWR VGND VPWR VGND sky130_ef_sc_hd__decap_12
XFILLER_91_613 VGND VGND VPWR VPWR sky130_fd_sc_hd__decap_3
XFILLER_48_356 VGND VGND VPWR VPWR sky130_fd_sc_hd__decap_8
XFILLER_63_337 VGND VGND VPWR VPWR sky130_fd_sc_hd__decap_3
XFILLER_84_85 VGND VGND VPWR VPWR sky130_fd_sc_hd__fill_2
XFILLER_29_592 VGND VGND VPWR VPWR sky130_fd_sc_hd__fill_2
XFILLER_90_178 VPWR VGND VPWR VGND sky130_ef_sc_hd__decap_12
XFILLER_16_253 VPWR VGND VPWR VGND sky130_ef_sc_hd__decap_12
XFILLER_17_90 VPWR VGND VPWR VGND sky130_ef_sc_hd__decap_12
XFILLER_32_713 VPWR VGND VPWR VGND sky130_ef_sc_hd__decap_12
XFILLER_31_212 VGND VGND VPWR VPWR sky130_fd_sc_hd__decap_3
XTAP_TAPCELL_ROW_14_443 VGND VPWR sky130_fd_sc_hd__tapvpwrvgnd_1
XTAP_TAPCELL_ROW_42_785 VGND VPWR sky130_fd_sc_hd__tapvpwrvgnd_1
XFILLER_117_317 VPWR VGND VPWR VGND sky130_ef_sc_hd__decap_12
XFILLER_8_485 VGND VGND VPWR VPWR sky130_fd_sc_hd__fill_1
X_4420_ net30 net43 _1110_ _2113_ VGND VGND VPWR VPWR _2307_ sky130_fd_sc_hd__o31a_2
X_4351_ _1242_ _2203_ _2238_ VGND VGND VPWR VPWR _2239_ sky130_fd_sc_hd__a21o_1
X_3302_ _1237_ _1238_ _1241_ _1118_ reg_file_inst.registry\[0\]\[23\] VGND VGND VPWR
+ VPWR net88 sky130_fd_sc_hd__o32a_4
X_4282_ _2168_ _2169_ VGND VGND VPWR VPWR _2170_ sky130_fd_sc_hd__nand2_1
X_6021_ net148 VGND VGND VPWR VPWR _0429_ sky130_fd_sc_hd__inv_2
X_3233_ _1152_ _1174_ VGND VGND VPWR VPWR _1175_ sky130_fd_sc_hd__or2_1
XFILLER_39_334 VGND VGND VPWR VPWR sky130_fd_sc_hd__fill_2
XFILLER_104_29 VPWR VGND VPWR VGND sky130_ef_sc_hd__decap_12
X_3164_ reg_file_inst.registry\[0\]\[27\] net138 _1100_ _1107_ VGND VGND VPWR VPWR
+ _1108_ sky130_fd_sc_hd__o22a_2
XFILLER_66_153 VGND VGND VPWR VPWR sky130_fd_sc_hd__decap_4
XFILLER_66_131 VGND VGND VPWR VPWR sky130_fd_sc_hd__decap_4
XFILLER_94_484 VGND VGND VPWR VPWR sky130_fd_sc_hd__decap_6
XFILLER_94_473 VGND VGND VPWR VPWR sky130_fd_sc_hd__decap_3
XFILLER_82_613 VPWR VGND VPWR VGND sky130_ef_sc_hd__decap_12
XTAP_TAPCELL_ROW_68_1116 VGND VPWR sky130_fd_sc_hd__tapvpwrvgnd_1
X_3095_ _1037_ _1038_ VGND VGND VPWR VPWR _1039_ sky130_fd_sc_hd__nand2_1
XFILLER_82_657 VPWR VGND VPWR VGND sky130_ef_sc_hd__decap_12
XFILLER_81_156 VGND VGND VPWR VPWR sky130_fd_sc_hd__decap_4
XFILLER_81_145 VGND VGND VPWR VPWR sky130_fd_sc_hd__decap_4
XFILLER_66_197 VGND VGND VPWR VPWR sky130_fd_sc_hd__decap_4
XFILLER_81_189 VGND VGND VPWR VPWR sky130_fd_sc_hd__fill_1
XFILLER_81_167 VGND VGND VPWR VPWR sky130_fd_sc_hd__fill_1
X_5805_ net147 VGND VGND VPWR VPWR _0213_ sky130_fd_sc_hd__inv_2
XFILLER_13_15 VPWR VGND VPWR VGND sky130_ef_sc_hd__decap_12
X_3997_ _1034_ _1039_ _1911_ VGND VGND VPWR VPWR _1913_ sky130_fd_sc_hd__nand3_1
X_5736_ net149 VGND VGND VPWR VPWR _0144_ sky130_fd_sc_hd__inv_2
X_5667_ net44 VGND VGND VPWR VPWR _0075_ sky130_fd_sc_hd__inv_2
XTAP_TAPCELL_ROW_79_1256 VGND VPWR sky130_fd_sc_hd__tapvpwrvgnd_1
X_4618_ _2494_ VGND VGND VPWR VPWR _2495_ sky130_fd_sc_hd__inv_2
XTAP_TAPCELL_ROW_92_1412 VGND VPWR sky130_fd_sc_hd__tapvpwrvgnd_1
X_5598_ net148 VGND VGND VPWR VPWR _0006_ sky130_fd_sc_hd__inv_2
XFILLER_8_8 VPWR VGND VPWR VGND sky130_ef_sc_hd__decap_12
X_4549_ _1817_ _2364_ _2429_ VGND VGND VPWR VPWR _2430_ sky130_fd_sc_hd__o21ai_1
XFILLER_104_545 VPWR VGND VPWR VGND sky130_ef_sc_hd__decap_12
XFILLER_89_234 VPWR VGND VPWR VGND sky130_ef_sc_hd__decap_12
XFILLER_1_149 VGND VGND VPWR VPWR sky130_fd_sc_hd__decap_4
XFILLER_1_127 VGND VGND VPWR VPWR sky130_fd_sc_hd__decap_3
XFILLER_104_589 VPWR VGND VPWR VGND sky130_ef_sc_hd__decap_12
XFILLER_89_278 VGND VGND VPWR VPWR sky130_fd_sc_hd__fill_2
X_6219_ clknet_leaf_2_clk _0627_ _0152_ VGND VGND VPWR VPWR reg_file_inst.registry\[10\]\[12\]
+ sky130_fd_sc_hd__dfrtp_1
XFILLER_85_473 VGND VGND VPWR VPWR sky130_fd_sc_hd__decap_8
XFILLER_57_186 VPWR VGND VPWR VGND sky130_ef_sc_hd__decap_12
XFILLER_57_164 VGND VGND VPWR VPWR sky130_fd_sc_hd__decap_4
XFILLER_45_337 VGND VGND VPWR VPWR sky130_fd_sc_hd__decap_3
XFILLER_60_318 VGND VGND VPWR VPWR sky130_fd_sc_hd__decap_6
XFILLER_13_201 VPWR VGND VPWR VGND sky130_ef_sc_hd__decap_12
XFILLER_41_510 VPWR VGND VPWR VGND sky130_ef_sc_hd__decap_12
XTAP_TAPCELL_ROW_101_1530 VGND VPWR sky130_fd_sc_hd__tapvpwrvgnd_1
XFILLER_110_83 VGND VGND VPWR VPWR sky130_fd_sc_hd__fill_1
XTAP_TAPCELL_ROW_11_402 VGND VPWR sky130_fd_sc_hd__tapvpwrvgnd_1
Xclkload19 clknet_leaf_13_clk VGND VGND VPWR VPWR clkload19/Y sky130_fd_sc_hd__inv_6
XFILLER_119_81 VPWR VGND VPWR VGND sky130_ef_sc_hd__decap_12
XFILLER_114_309 VPWR VGND VPWR VGND sky130_ef_sc_hd__decap_12
XFILLER_107_361 VPWR VGND VPWR VGND sky130_ef_sc_hd__decap_12
XFILLER_5_477 VGND VGND VPWR VPWR sky130_fd_sc_hd__decap_8
XFILLER_79_85 VGND VGND VPWR VPWR sky130_fd_sc_hd__decap_8
XTAP_TAPCELL_ROW_112_1670 VGND VPWR sky130_fd_sc_hd__tapvpwrvgnd_1
XFILLER_95_237 VPWR VGND VPWR VGND sky130_ef_sc_hd__decap_12
XFILLER_49_643 VGND VGND VPWR VPWR sky130_fd_sc_hd__decap_3
XFILLER_95_259 VGND VGND VPWR VPWR sky130_fd_sc_hd__fill_1
XFILLER_0_193 VGND VGND VPWR VPWR sky130_fd_sc_hd__decap_3
XTAP_TAPCELL_ROW_19_502 VGND VPWR sky130_fd_sc_hd__tapvpwrvgnd_1
XFILLER_48_186 VGND VGND VPWR VPWR sky130_fd_sc_hd__decap_6
XTAP_TAPCELL_ROW_47_855 VGND VPWR sky130_fd_sc_hd__tapvpwrvgnd_1
XFILLER_63_167 VGND VGND VPWR VPWR sky130_fd_sc_hd__fill_1
X_3920_ reg_file_inst.registry\[9\]\[0\] _1078_ _1088_ _1093_ reg_file_inst.registry\[15\]\[0\]
+ VGND VGND VPWR VPWR _1837_ sky130_fd_sc_hd__a32o_1
XTAP_TAPCELL_ROW_63_1057 VGND VPWR sky130_fd_sc_hd__tapvpwrvgnd_1
XTAP_TAPCELL_ROW_63_1046 VGND VPWR sky130_fd_sc_hd__tapvpwrvgnd_1
X_3851_ reg_file_inst.registry\[4\]\[3\] _1114_ _1132_ VGND VGND VPWR VPWR _1771_
+ sky130_fd_sc_hd__and3_1
XFILLER_20_705 VGND VGND VPWR VPWR sky130_fd_sc_hd__fill_1
XFILLER_81_3 VPWR VGND VPWR VGND sky130_ef_sc_hd__decap_12
XFILLER_32_587 VGND VGND VPWR VPWR sky130_fd_sc_hd__fill_1
X_3782_ reg_file_inst.registry\[7\]\[4\] _1086_ _1699_ _1701_ _1075_ VGND VGND VPWR
+ VPWR _1704_ sky130_fd_sc_hd__a2111o_1
X_5521_ reg_file_inst.registry\[6\]\[13\] _2922_ _3001_ VGND VGND VPWR VPWR _0544_
+ sky130_fd_sc_hd__mux2_1
XFILLER_118_637 VGND VGND VPWR VPWR sky130_fd_sc_hd__decap_6
XFILLER_117_125 VPWR VGND VPWR VGND sky130_ef_sc_hd__decap_12
X_5452_ reg_file_inst.registry\[5\]\[24\] _2787_ _2999_ VGND VGND VPWR VPWR _0611_
+ sky130_fd_sc_hd__mux2_1
XFILLER_117_169 VPWR VGND VPWR VGND sky130_ef_sc_hd__decap_12
X_4403_ _1652_ _1667_ _2290_ VGND VGND VPWR VPWR _2291_ sky130_fd_sc_hd__o21ai_1
X_5383_ MEMOFF\[6\] _2375_ _2996_ VGND VGND VPWR VPWR _0677_ sky130_fd_sc_hd__mux2_1
X_4334_ _1840_ _2221_ VGND VGND VPWR VPWR _2222_ sky130_fd_sc_hd__nor2_1
XTAP_TAPCELL_ROW_74_1186 VGND VPWR sky130_fd_sc_hd__tapvpwrvgnd_1
XFILLER_115_39 VPWR VGND VPWR VGND sky130_ef_sc_hd__decap_12
X_6004_ net147 VGND VGND VPWR VPWR _0412_ sky130_fd_sc_hd__inv_2
X_4265_ _1778_ _2151_ VGND VGND VPWR VPWR _2153_ sky130_fd_sc_hd__or2_1
XFILLER_101_559 VGND VGND VPWR VPWR sky130_fd_sc_hd__fill_1
X_3216_ reg_file_inst.registry\[7\]\[26\] _1086_ _1095_ JMPOFF\[26\] VGND VGND VPWR
+ VPWR _1159_ sky130_fd_sc_hd__a22o_1
X_4196_ _2095_ net104 net130 VGND VGND VPWR VPWR _0933_ sky130_fd_sc_hd__mux2_1
XFILLER_67_495 VGND VGND VPWR VPWR sky130_fd_sc_hd__decap_8
XFILLER_54_101 VGND VGND VPWR VPWR sky130_fd_sc_hd__decap_3
XFILLER_39_153 VPWR VGND VPWR VGND sky130_ef_sc_hd__decap_12
X_3147_ _1082_ _1085_ VGND VGND VPWR VPWR _1091_ sky130_fd_sc_hd__and2_4
XFILLER_94_292 VGND VGND VPWR VPWR sky130_fd_sc_hd__decap_8
XFILLER_27_337 VGND VGND VPWR VPWR sky130_fd_sc_hd__decap_4
X_3078_ _1001_ _1021_ _1000_ VGND VGND VPWR VPWR _1022_ sky130_fd_sc_hd__o21ai_2
XFILLER_82_498 VGND VGND VPWR VPWR sky130_fd_sc_hd__fill_1
XFILLER_23_532 VGND VGND VPWR VPWR sky130_fd_sc_hd__decap_4
XFILLER_42_329 VGND VGND VPWR VPWR sky130_fd_sc_hd__decap_6
XFILLER_109_615 VGND VGND VPWR VPWR sky130_fd_sc_hd__fill_1
XFILLER_10_248 VGND VGND VPWR VPWR sky130_fd_sc_hd__decap_4
XFILLER_7_709 VPWR VGND VPWR VGND sky130_ef_sc_hd__decap_12
X_5719_ net44 VGND VGND VPWR VPWR _0127_ sky130_fd_sc_hd__inv_2
XFILLER_78_705 VGND VGND VPWR VPWR sky130_fd_sc_hd__fill_1
XFILLER_49_66 VGND VGND VPWR VPWR sky130_fd_sc_hd__decap_4
XFILLER_85_281 VGND VGND VPWR VPWR sky130_fd_sc_hd__decap_4
XFILLER_65_87 VPWR VGND VPWR VGND sky130_ef_sc_hd__decap_12
XTAP_TAPCELL_ROW_44_814 VGND VPWR sky130_fd_sc_hd__tapvpwrvgnd_1
XFILLER_45_167 VGND VGND VPWR VPWR sky130_fd_sc_hd__fill_1
XFILLER_121_93 VPWR VGND VPWR VGND sky130_ef_sc_hd__decap_12
XFILLER_14_565 VPWR VGND VPWR VGND sky130_ef_sc_hd__decap_12
XTAP_TAPCELL_ROW_24_560 VGND VPWR sky130_fd_sc_hd__tapvpwrvgnd_1
XFILLER_41_384 VGND VGND VPWR VPWR sky130_fd_sc_hd__decap_8
XFILLER_81_97 VPWR VGND VPWR VGND sky130_ef_sc_hd__decap_12
XFILLER_115_629 VPWR VGND VPWR VGND sky130_ef_sc_hd__decap_12
XFILLER_108_681 VPWR VGND VPWR VGND sky130_ef_sc_hd__decap_12
XFILLER_114_139 VGND VGND VPWR VPWR sky130_fd_sc_hd__fill_1
XFILLER_110_301 VGND VGND VPWR VPWR sky130_fd_sc_hd__decap_6
XFILLER_110_345 VPWR VGND VPWR VGND sky130_ef_sc_hd__decap_12
X_4050_ _1961_ _1963_ _1947_ VGND VGND VPWR VPWR _1966_ sky130_fd_sc_hd__o21a_1
XFILLER_110_389 VPWR VGND VPWR VGND sky130_ef_sc_hd__decap_12
Xinput6 DataMemoryRead[14] VGND VGND VPWR VPWR net6 sky130_fd_sc_hd__clkbuf_2
XFILLER_64_421 VPWR VGND VPWR VGND sky130_ef_sc_hd__decap_12
XFILLER_37_635 VGND VGND VPWR VPWR sky130_fd_sc_hd__decap_8
XFILLER_24_307 VGND VGND VPWR VPWR sky130_fd_sc_hd__fill_1
XFILLER_64_498 VPWR VGND VPWR VGND sky130_ef_sc_hd__decap_12
X_4952_ _2711_ _2800_ _2801_ _2275_ _2799_ VGND VGND VPWR VPWR _2803_ sky130_fd_sc_hd__a221o_1
X_4883_ _1765_ _2729_ _2739_ _2277_ VGND VGND VPWR VPWR _2740_ sky130_fd_sc_hd__o211a_1
X_3903_ reg_file_inst.registry\[10\]\[1\] _1126_ _1136_ reg_file_inst.registry\[8\]\[1\]
+ VGND VGND VPWR VPWR _1821_ sky130_fd_sc_hd__a22o_1
X_3834_ reg_file_inst.registry\[1\]\[3\] _1078_ _1082_ VGND VGND VPWR VPWR _1754_
+ sky130_fd_sc_hd__and3_1
XFILLER_118_401 VPWR VGND VPWR VGND sky130_ef_sc_hd__decap_12
X_3765_ reg_file_inst.registry\[8\]\[6\] _1136_ _1684_ _1686_ _1687_ VGND VGND VPWR
+ VPWR _1688_ sky130_fd_sc_hd__a2111o_1
XFILLER_118_445 VPWR VGND VPWR VGND sky130_ef_sc_hd__decap_12
X_6484_ clknet_leaf_24_clk _0892_ _0417_ VGND VGND VPWR VPWR reg_file_inst.registry\[7\]\[17\]
+ sky130_fd_sc_hd__dfrtp_1
XTAP_TAPCELL_ROW_76_1215 VGND VPWR sky130_fd_sc_hd__tapvpwrvgnd_1
X_5504_ JMPOFF\[1\] _2528_ _3000_ VGND VGND VPWR VPWR _0560_ sky130_fd_sc_hd__mux2_1
X_3696_ MEMOFF\[8\] net99 _1113_ VGND VGND VPWR VPWR _1620_ sky130_fd_sc_hd__mux2_4
XFILLER_118_489 VPWR VGND VPWR VGND sky130_ef_sc_hd__decap_12
X_5435_ _2934_ reg_file_inst.registry\[10\]\[12\] _2998_ VGND VGND VPWR VPWR _0627_
+ sky130_fd_sc_hd__mux2_1
XFILLER_10_27 VGND VGND VPWR VPWR sky130_fd_sc_hd__fill_1
XFILLER_120_109 VPWR VGND VPWR VGND sky130_ef_sc_hd__decap_12
X_5366_ MEMOFF\[23\] _2806_ _2996_ VGND VGND VPWR VPWR _0694_ sky130_fd_sc_hd__mux2_1
XFILLER_113_161 VGND VGND VPWR VPWR sky130_fd_sc_hd__decap_6
XFILLER_101_301 VPWR VGND VPWR VGND sky130_ef_sc_hd__decap_12
X_5297_ _2419_ reg_file_inst.registry\[2\]\[5\] _2993_ VGND VGND VPWR VPWR _0760_
+ sky130_fd_sc_hd__mux2_1
X_4317_ _1320_ _2190_ VGND VGND VPWR VPWR _2205_ sky130_fd_sc_hd__and2_1
XFILLER_19_47 VGND VGND VPWR VPWR sky130_fd_sc_hd__decap_8
X_4248_ _1667_ _2134_ VGND VGND VPWR VPWR _2136_ sky130_fd_sc_hd__nor2_1
XFILLER_19_69 VPWR VGND VPWR VGND sky130_ef_sc_hd__decap_12
XFILLER_67_281 VGND VGND VPWR VPWR sky130_fd_sc_hd__decap_4
X_4179_ _1921_ _2082_ _1926_ VGND VGND VPWR VPWR _2084_ sky130_fd_sc_hd__o21ai_2
XTAP_TAPCELL_ROW_87_1355 VGND VPWR sky130_fd_sc_hd__tapvpwrvgnd_1
XFILLER_82_251 VGND VGND VPWR VPWR sky130_fd_sc_hd__fill_1
XTAP_TAPCELL_ROW_2_288 VGND VPWR sky130_fd_sc_hd__tapvpwrvgnd_1
XFILLER_27_167 VGND VGND VPWR VPWR sky130_fd_sc_hd__fill_1
XFILLER_43_605 VGND VGND VPWR VPWR sky130_fd_sc_hd__decap_8
XFILLER_27_178 VGND VGND VPWR VPWR sky130_fd_sc_hd__fill_1
XFILLER_35_46 VGND VGND VPWR VPWR sky130_fd_sc_hd__decap_3
XFILLER_43_638 VGND VGND VPWR VPWR sky130_fd_sc_hd__decap_6
XFILLER_42_137 VGND VGND VPWR VPWR sky130_fd_sc_hd__decap_3
XFILLER_51_12 VGND VGND VPWR VPWR sky130_fd_sc_hd__fill_1
Xclkbuf_3_3__f_clk clknet_0_clk VGND VGND VPWR VPWR clknet_3_3__leaf_clk sky130_fd_sc_hd__clkbuf_16
XFILLER_51_34 VGND VGND VPWR VPWR sky130_fd_sc_hd__fill_1
XFILLER_11_546 VPWR VGND VPWR VGND sky130_ef_sc_hd__decap_12
XPHY_EDGE_ROW_14_Right_14 VGND VGND VPWR VPWR sky130_fd_sc_hd__decap_3
XTAP_TAPCELL_ROW_21_530 VGND VPWR sky130_fd_sc_hd__tapvpwrvgnd_1
XFILLER_51_67 VGND VGND VPWR VPWR sky130_fd_sc_hd__decap_3
XFILLER_7_517 VPWR VGND VPWR VGND sky130_ef_sc_hd__decap_12
XFILLER_51_89 VPWR VGND VPWR VGND sky130_ef_sc_hd__decap_12
XTAP_TAPCELL_ROW_98_1495 VGND VPWR sky130_fd_sc_hd__tapvpwrvgnd_1
XTAP_TAPCELL_ROW_98_1484 VGND VPWR sky130_fd_sc_hd__tapvpwrvgnd_1
XFILLER_2_211 VGND VGND VPWR VPWR sky130_fd_sc_hd__decap_3
XFILLER_105_673 VPWR VGND VPWR VGND sky130_ef_sc_hd__decap_12
XFILLER_104_172 VGND VGND VPWR VPWR sky130_fd_sc_hd__fill_1
XFILLER_78_513 VPWR VGND VPWR VGND sky130_ef_sc_hd__decap_12
XPHY_EDGE_ROW_23_Right_23 VGND VGND VPWR VPWR sky130_fd_sc_hd__decap_3
XFILLER_120_643 VGND VGND VPWR VPWR sky130_fd_sc_hd__fill_1
XTAP_TAPCELL_ROW_29_630 VGND VPWR sky130_fd_sc_hd__tapvpwrvgnd_1
XFILLER_46_421 VPWR VGND VPWR VGND sky130_ef_sc_hd__decap_12
XFILLER_61_402 VGND VGND VPWR VPWR sky130_fd_sc_hd__decap_8
XTAP_TAPCELL_ROW_57_972 VGND VPWR sky130_fd_sc_hd__tapvpwrvgnd_1
XFILLER_92_85 VPWR VGND VPWR VGND sky130_ef_sc_hd__decap_12
XPHY_EDGE_ROW_1_Left_124 VGND VGND VPWR VPWR sky130_fd_sc_hd__decap_3
XPHY_EDGE_ROW_32_Right_32 VGND VGND VPWR VPWR sky130_fd_sc_hd__decap_3
XTAP_TAPCELL_ROW_60_1016 VGND VPWR sky130_fd_sc_hd__tapvpwrvgnd_1
XFILLER_14_373 VGND VGND VPWR VPWR sky130_fd_sc_hd__fill_1
XFILLER_25_90 VGND VGND VPWR VPWR sky130_fd_sc_hd__decap_8
XFILLER_41_181 VPWR VGND VPWR VGND sky130_ef_sc_hd__decap_12
X_3550_ reg_file_inst.registry\[0\]\[15\] net138 _1473_ _1479_ VGND VGND VPWR VPWR
+ _1480_ sky130_fd_sc_hd__o22ai_4
X_5220_ _2806_ reg_file_inst.registry\[1\]\[23\] _2990_ VGND VGND VPWR VPWR _0834_
+ sky130_fd_sc_hd__mux2_1
X_3481_ reg_file_inst.registry\[14\]\[17\] _1138_ _1408_ _1409_ _1410_ VGND VGND VPWR
+ VPWR _1414_ sky130_fd_sc_hd__a2111o_1
XFILLER_102_109 VPWR VGND VPWR VGND sky130_ef_sc_hd__decap_12
XPHY_EDGE_ROW_41_Right_41 VGND VGND VPWR VPWR sky130_fd_sc_hd__decap_3
X_5151_ _2972_ _2973_ _2963_ VGND VGND VPWR VPWR net72 sky130_fd_sc_hd__or3b_2
XFILLER_111_665 VGND VGND VPWR VPWR sky130_fd_sc_hd__decap_6
XFILLER_96_332 VGND VGND VPWR VPWR sky130_fd_sc_hd__decap_6
XTAP_TAPCELL_ROW_71_1156 VGND VPWR sky130_fd_sc_hd__tapvpwrvgnd_1
X_4102_ _2016_ _2017_ VGND VGND VPWR VPWR _2018_ sky130_fd_sc_hd__or2_1
X_5082_ _1469_ _2282_ VGND VGND VPWR VPWR _2913_ sky130_fd_sc_hd__nor2_1
XFILLER_110_153 VPWR VGND VPWR VGND sky130_ef_sc_hd__decap_12
XFILLER_96_365 VGND VGND VPWR VPWR sky130_fd_sc_hd__decap_8
X_4033_ _1948_ VGND VGND VPWR VPWR _1949_ sky130_fd_sc_hd__inv_2
XFILLER_110_197 VPWR VGND VPWR VGND sky130_ef_sc_hd__decap_12
XFILLER_2_83 VGND VGND VPWR VPWR sky130_fd_sc_hd__fill_1
XFILLER_2_94 VGND VGND VPWR VPWR sky130_fd_sc_hd__fill_2
XFILLER_112_29 VPWR VGND VPWR VGND sky130_ef_sc_hd__decap_12
XFILLER_112_18 VGND VGND VPWR VPWR sky130_fd_sc_hd__decap_8
XFILLER_37_465 VGND VGND VPWR VPWR sky130_fd_sc_hd__decap_8
XFILLER_64_284 VGND VGND VPWR VPWR sky130_fd_sc_hd__decap_3
XFILLER_64_273 VGND VGND VPWR VPWR sky130_fd_sc_hd__decap_4
XFILLER_52_424 VGND VGND VPWR VPWR sky130_fd_sc_hd__fill_2
XPHY_EDGE_ROW_50_Right_50 VGND VGND VPWR VPWR sky130_fd_sc_hd__decap_3
XFILLER_24_115 VPWR VGND VPWR VGND sky130_ef_sc_hd__decap_12
X_5984_ net149 VGND VGND VPWR VPWR _0392_ sky130_fd_sc_hd__inv_2
XPHY_EDGE_ROW_56_Left_179 VGND VGND VPWR VPWR sky130_fd_sc_hd__decap_3
XFILLER_52_457 VGND VGND VPWR VPWR sky130_fd_sc_hd__fill_1
X_4935_ net17 net101 net61 _2308_ VGND VGND VPWR VPWR _2787_ sky130_fd_sc_hd__a22o_4
XFILLER_33_671 VGND VGND VPWR VPWR sky130_fd_sc_hd__fill_1
XTAP_TAPCELL_ROW_35_699 VGND VPWR sky130_fd_sc_hd__tapvpwrvgnd_1
XANTENNA_22 net90 VGND VGND VPWR VPWR sky130_fd_sc_hd__diode_2
XTAP_TAPCELL_ROW_82_1285 VGND VPWR sky130_fd_sc_hd__tapvpwrvgnd_1
X_4866_ _2329_ _2331_ VGND VGND VPWR VPWR _2723_ sky130_fd_sc_hd__nor2_1
XANTENNA_11 _2126_ VGND VGND VPWR VPWR sky130_fd_sc_hd__diode_2
XFILLER_119_721 VGND VGND VPWR VPWR sky130_fd_sc_hd__decap_4
X_3817_ MEMOFF\[5\] _1129_ _1130_ JMPOFF\[5\] VGND VGND VPWR VPWR _1738_ sky130_fd_sc_hd__a22o_1
X_4797_ _2653_ _2655_ VGND VGND VPWR VPWR _2656_ sky130_fd_sc_hd__nor2_1
XFILLER_20_365 VGND VGND VPWR VPWR sky130_fd_sc_hd__decap_8
X_6536_ clknet_leaf_39_clk _0944_ _0469_ VGND VGND VPWR VPWR net116 sky130_fd_sc_hd__dfrtp_1
XFILLER_21_15 VPWR VGND VPWR VGND sky130_ef_sc_hd__decap_12
X_3748_ reg_file_inst.registry\[14\]\[6\] _1081_ _1087_ reg_file_inst.registry\[1\]\[6\]
+ _1670_ VGND VGND VPWR VPWR _1671_ sky130_fd_sc_hd__a221o_1
XFILLER_118_253 VPWR VGND VPWR VGND sky130_ef_sc_hd__decap_12
XPHY_EDGE_ROW_65_Left_188 VGND VGND VPWR VPWR sky130_fd_sc_hd__decap_3
X_3679_ reg_file_inst.registry\[9\]\[8\] _1089_ _1598_ _1599_ _1075_ VGND VGND VPWR
+ VPWR _1604_ sky130_fd_sc_hd__a2111o_1
X_6467_ clknet_leaf_47_clk _0875_ _0400_ VGND VGND VPWR VPWR reg_file_inst.registry\[7\]\[0\]
+ sky130_fd_sc_hd__dfrtp_1
X_6398_ clknet_leaf_32_clk _0806_ _0331_ VGND VGND VPWR VPWR reg_file_inst.registry\[14\]\[23\]
+ sky130_fd_sc_hd__dfrtp_1
X_5418_ reg_file_inst.registry\[4\]\[0\] _2550_ _2997_ VGND VGND VPWR VPWR _0643_
+ sky130_fd_sc_hd__mux2_1
XFILLER_121_429 VPWR VGND VPWR VGND sky130_ef_sc_hd__decap_12
XTAP_TAPCELL_ROW_7_347 VGND VPWR sky130_fd_sc_hd__tapvpwrvgnd_1
XFILLER_0_715 VGND VGND VPWR VPWR sky130_fd_sc_hd__fill_1
X_5349_ _2948_ reg_file_inst.registry\[3\]\[11\] _2995_ VGND VGND VPWR VPWR _0710_
+ sky130_fd_sc_hd__mux2_1
XFILLER_102_643 VGND VGND VPWR VPWR sky130_fd_sc_hd__fill_1
XFILLER_101_131 VPWR VGND VPWR VGND sky130_ef_sc_hd__decap_12
XFILLER_75_505 VPWR VGND VPWR VGND sky130_ef_sc_hd__decap_12
XFILLER_28_421 VGND VGND VPWR VPWR sky130_fd_sc_hd__decap_8
XFILLER_46_23 VGND VGND VPWR VPWR sky130_fd_sc_hd__decap_4
XPHY_EDGE_ROW_74_Left_197 VGND VGND VPWR VPWR sky130_fd_sc_hd__decap_3
XFILLER_71_700 VGND VGND VPWR VPWR sky130_fd_sc_hd__decap_6
XFILLER_28_443 VGND VGND VPWR VPWR sky130_fd_sc_hd__decap_4
XFILLER_28_465 VGND VGND VPWR VPWR sky130_fd_sc_hd__decap_8
XFILLER_55_262 VGND VGND VPWR VPWR sky130_fd_sc_hd__decap_8
XFILLER_15_126 VPWR VGND VPWR VGND sky130_ef_sc_hd__decap_12
XFILLER_16_638 VGND VGND VPWR VPWR sky130_fd_sc_hd__fill_2
XTAP_TAPCELL_ROW_54_942 VGND VPWR sky130_fd_sc_hd__tapvpwrvgnd_1
Xclkbuf_leaf_50_clk clknet_3_5__leaf_clk VGND VGND VPWR VPWR clknet_leaf_50_clk sky130_fd_sc_hd__clkbuf_8
XFILLER_7_39 VPWR VGND VPWR VGND sky130_ef_sc_hd__decap_12
XFILLER_11_81 VPWR VGND VPWR VGND sky130_ef_sc_hd__decap_12
XFILLER_3_553 VGND VGND VPWR VPWR sky130_fd_sc_hd__decap_6
XFILLER_3_597 VPWR VGND VPWR VGND sky130_ef_sc_hd__decap_12
XFILLER_78_332 VPWR VGND VPWR VGND sky130_ef_sc_hd__decap_12
XFILLER_78_365 VGND VGND VPWR VPWR sky130_fd_sc_hd__fill_2
XTAP_TAPCELL_ROW_109_1631 VGND VPWR sky130_fd_sc_hd__tapvpwrvgnd_1
XFILLER_93_324 VPWR VGND VPWR VGND sky130_ef_sc_hd__decap_12
XFILLER_46_251 VGND VGND VPWR VPWR sky130_fd_sc_hd__fill_1
XFILLER_19_476 VGND VGND VPWR VPWR sky130_fd_sc_hd__fill_1
Xclkbuf_leaf_41_clk clknet_3_7__leaf_clk VGND VGND VPWR VPWR clknet_leaf_41_clk sky130_fd_sc_hd__clkbuf_8
X_4720_ _1242_ _2578_ VGND VGND VPWR VPWR _2579_ sky130_fd_sc_hd__nand2_1
X_4651_ _1708_ _2192_ _2517_ VGND VGND VPWR VPWR _2526_ sky130_fd_sc_hd__or3_1
XFILLER_30_674 VGND VGND VPWR VPWR sky130_fd_sc_hd__fill_2
XTAP_TAPCELL_ROW_32_658 VGND VPWR sky130_fd_sc_hd__tapvpwrvgnd_1
XTAP_TAPCELL_ROW_32_669 VGND VPWR sky130_fd_sc_hd__tapvpwrvgnd_1
Xinput31 instr[11] VGND VGND VPWR VPWR net31 sky130_fd_sc_hd__clkbuf_4
Xinput20 DataMemoryRead[27] VGND VGND VPWR VPWR net20 sky130_fd_sc_hd__dlymetal6s2s_1
X_3602_ reg_file_inst.registry\[9\]\[11\] net143 _1127_ VGND VGND VPWR VPWR _1530_
+ sky130_fd_sc_hd__and3_1
XFILLER_116_713 VPWR VGND VPWR VGND sky130_ef_sc_hd__decap_12
Xinput42 instr[8] VGND VGND VPWR VPWR net42 sky130_fd_sc_hd__buf_4
X_4582_ _2262_ _2266_ VGND VGND VPWR VPWR _2461_ sky130_fd_sc_hd__nor2_1
XFILLER_115_223 VGND VGND VPWR VPWR sky130_fd_sc_hd__fill_1
X_6321_ clknet_leaf_62_clk _0729_ _0254_ VGND VGND VPWR VPWR reg_file_inst.registry\[8\]\[2\]
+ sky130_fd_sc_hd__dfrtp_1
X_3533_ reg_file_inst.registry\[15\]\[13\] _1122_ _1130_ JMPOFF\[13\] _1463_ VGND
+ VGND VPWR VPWR _1464_ sky130_fd_sc_hd__a221o_1
XFILLER_89_608 VGND VGND VPWR VPWR sky130_fd_sc_hd__decap_8
X_3464_ reg_file_inst.registry\[7\]\[17\] _1086_ _1396_ net139 VGND VGND VPWR VPWR
+ _1397_ sky130_fd_sc_hd__a211o_1
X_6252_ clknet_leaf_8_clk _0660_ _0185_ VGND VGND VPWR VPWR reg_file_inst.registry\[4\]\[17\]
+ sky130_fd_sc_hd__dfrtp_1
XFILLER_88_129 VGND VGND VPWR VPWR sky130_fd_sc_hd__decap_8
X_6183_ clknet_leaf_50_clk _0591_ _0116_ VGND VGND VPWR VPWR reg_file_inst.registry\[5\]\[4\]
+ sky130_fd_sc_hd__dfrtp_1
X_5203_ _2501_ reg_file_inst.registry\[0\]\[2\] _2988_ VGND VGND VPWR VPWR _0849_
+ sky130_fd_sc_hd__mux2_1
XFILLER_97_641 VPWR VGND VPWR VGND sky130_ef_sc_hd__decap_12
X_3395_ reg_file_inst.registry\[1\]\[19\] _1087_ _1090_ reg_file_inst.registry\[8\]\[19\]
+ VGND VGND VPWR VPWR _1331_ sky130_fd_sc_hd__a22o_1
XFILLER_69_332 VGND VGND VPWR VPWR sky130_fd_sc_hd__fill_1
X_5134_ _2249_ _2719_ _2952_ _2192_ _2255_ VGND VGND VPWR VPWR _2959_ sky130_fd_sc_hd__o221a_1
XFILLER_111_473 VPWR VGND VPWR VGND sky130_ef_sc_hd__decap_12
XFILLER_97_685 VPWR VGND VPWR VGND sky130_ef_sc_hd__decap_12
XTAP_TAPCELL_ROW_4_317 VGND VPWR sky130_fd_sc_hd__tapvpwrvgnd_1
XFILLER_84_346 VPWR VGND VPWR VGND sky130_ef_sc_hd__decap_12
XFILLER_84_324 VGND VGND VPWR VPWR sky130_fd_sc_hd__fill_2
X_5065_ _2644_ _2884_ VGND VGND VPWR VPWR _2898_ sky130_fd_sc_hd__xnor2_1
X_4016_ _1023_ _1931_ VGND VGND VPWR VPWR _1932_ sky130_fd_sc_hd__nor2_1
XTAP_TAPCELL_ROW_84_1314 VGND VPWR sky130_fd_sc_hd__tapvpwrvgnd_1
XFILLER_16_26 VGND VGND VPWR VPWR sky130_fd_sc_hd__fill_2
XFILLER_25_424 VGND VGND VPWR VPWR sky130_fd_sc_hd__decap_6
XFILLER_16_37 VGND VGND VPWR VPWR sky130_fd_sc_hd__decap_3
XFILLER_80_574 VGND VGND VPWR VPWR sky130_fd_sc_hd__decap_4
XTAP_TAPCELL_ROW_51_901 VGND VPWR sky130_fd_sc_hd__tapvpwrvgnd_1
X_5967_ net149 VGND VGND VPWR VPWR _0375_ sky130_fd_sc_hd__inv_2
Xclkbuf_leaf_32_clk clknet_3_6__leaf_clk VGND VGND VPWR VPWR clknet_leaf_32_clk sky130_fd_sc_hd__clkbuf_8
X_4918_ _2128_ _2769_ VGND VGND VPWR VPWR _2771_ sky130_fd_sc_hd__nand2_1
X_5898_ net147 VGND VGND VPWR VPWR _0306_ sky130_fd_sc_hd__inv_2
X_4849_ _2199_ _2209_ VGND VGND VPWR VPWR _2708_ sky130_fd_sc_hd__nor2_1
XFILLER_21_685 VPWR VGND VPWR VGND sky130_ef_sc_hd__decap_12
XFILLER_119_573 VPWR VGND VPWR VGND sky130_ef_sc_hd__decap_12
XFILLER_20_195 VGND VGND VPWR VPWR sky130_fd_sc_hd__fill_1
XTAP_TAPCELL_ROW_95_1454 VGND VPWR sky130_fd_sc_hd__tapvpwrvgnd_1
X_6519_ clknet_leaf_52_clk _0927_ _0452_ VGND VGND VPWR VPWR net125 sky130_fd_sc_hd__dfrtp_1
XFILLER_106_245 VGND VGND VPWR VPWR sky130_fd_sc_hd__decap_6
XFILLER_106_289 VPWR VGND VPWR VGND sky130_ef_sc_hd__decap_12
XFILLER_121_237 VPWR VGND VPWR VGND sky130_ef_sc_hd__decap_12
XFILLER_88_641 VGND VGND VPWR VPWR sky130_fd_sc_hd__decap_3
XFILLER_0_545 VGND VGND VPWR VPWR sky130_fd_sc_hd__decap_8
XFILLER_75_302 VGND VGND VPWR VPWR sky130_fd_sc_hd__decap_6
XFILLER_0_589 VGND VGND VPWR VPWR sky130_fd_sc_hd__decap_4
XPHY_EDGE_ROW_82_Left_205 VGND VGND VPWR VPWR sky130_fd_sc_hd__decap_3
XFILLER_75_368 VGND VGND VPWR VPWR sky130_fd_sc_hd__fill_1
XFILLER_16_402 VGND VGND VPWR VPWR sky130_fd_sc_hd__fill_1
XFILLER_28_251 VGND VGND VPWR VPWR sky130_fd_sc_hd__fill_1
XFILLER_28_273 VGND VGND VPWR VPWR sky130_fd_sc_hd__decap_3
XTAP_TAPCELL_ROW_104_1561 VGND VPWR sky130_fd_sc_hd__tapvpwrvgnd_1
XFILLER_31_405 VPWR VGND VPWR VGND sky130_ef_sc_hd__decap_12
Xclkbuf_leaf_23_clk clknet_3_3__leaf_clk VGND VGND VPWR VPWR clknet_leaf_23_clk sky130_fd_sc_hd__clkbuf_8
XFILLER_31_449 VGND VGND VPWR VPWR sky130_fd_sc_hd__decap_6
XFILLER_8_601 VPWR VGND VPWR VGND sky130_ef_sc_hd__decap_12
XPHY_EDGE_ROW_91_Left_214 VGND VGND VPWR VPWR sky130_fd_sc_hd__decap_3
XFILLER_8_645 VPWR VGND VPWR VGND sky130_ef_sc_hd__decap_12
XFILLER_7_111 VGND VGND VPWR VPWR sky130_fd_sc_hd__fill_1
XFILLER_7_166 VGND VGND VPWR VPWR sky130_fd_sc_hd__fill_2
XFILLER_79_685 VPWR VGND VPWR VGND sky130_ef_sc_hd__decap_12
X_3180_ _0955_ net35 VGND VGND VPWR VPWR _1124_ sky130_fd_sc_hd__nand2_4
XFILLER_94_622 VPWR VGND VPWR VGND sky130_ef_sc_hd__decap_12
XFILLER_39_538 VGND VGND VPWR VPWR sky130_fd_sc_hd__fill_2
XFILLER_94_699 VGND VGND VPWR VPWR sky130_fd_sc_hd__fill_1
XFILLER_93_176 VGND VGND VPWR VPWR sky130_fd_sc_hd__decap_4
XFILLER_19_273 VGND VGND VPWR VPWR sky130_fd_sc_hd__decap_6
XTAP_TAPCELL_ROW_37_728 VGND VPWR sky130_fd_sc_hd__tapvpwrvgnd_1
X_5821_ net146 VGND VGND VPWR VPWR _0229_ sky130_fd_sc_hd__inv_2
XFILLER_22_416 VGND VGND VPWR VPWR sky130_fd_sc_hd__decap_4
X_5752_ net146 VGND VGND VPWR VPWR _0160_ sky130_fd_sc_hd__inv_2
XTAP_TAPCELL_ROW_66_1088 VGND VPWR sky130_fd_sc_hd__tapvpwrvgnd_1
XTAP_TAPCELL_ROW_17_474 VGND VPWR sky130_fd_sc_hd__tapvpwrvgnd_1
Xclkbuf_leaf_14_clk clknet_3_2__leaf_clk VGND VGND VPWR VPWR clknet_leaf_14_clk sky130_fd_sc_hd__clkbuf_8
X_4703_ _1358_ _2560_ _2126_ VGND VGND VPWR VPWR _2562_ sky130_fd_sc_hd__a21o_2
X_5683_ net146 VGND VGND VPWR VPWR _0091_ sky130_fd_sc_hd__inv_2
X_4634_ _1854_ _2287_ VGND VGND VPWR VPWR _2509_ sky130_fd_sc_hd__nor2_1
X_4565_ _2170_ _2176_ _2435_ _2445_ VGND VGND VPWR VPWR _2446_ sky130_fd_sc_hd__a31o_1
X_3516_ _1433_ _1446_ VGND VGND VPWR VPWR _1447_ sky130_fd_sc_hd__xnor2_1
X_6304_ clknet_leaf_1_clk _0712_ _0237_ VGND VGND VPWR VPWR reg_file_inst.registry\[3\]\[13\]
+ sky130_fd_sc_hd__dfrtp_1
XFILLER_116_587 VGND VGND VPWR VPWR sky130_fd_sc_hd__fill_1
XPHY_EDGE_ROW_4_Right_4 VGND VGND VPWR VPWR sky130_fd_sc_hd__decap_3
X_4496_ _2200_ _2212_ net134 VGND VGND VPWR VPWR _2379_ sky130_fd_sc_hd__mux2_1
XFILLER_1_309 VGND VGND VPWR VPWR sky130_fd_sc_hd__fill_1
X_3447_ _1377_ _1378_ _1380_ VGND VGND VPWR VPWR _1381_ sky130_fd_sc_hd__or3_1
X_6235_ clknet_leaf_50_clk _0643_ _0168_ VGND VGND VPWR VPWR reg_file_inst.registry\[4\]\[0\]
+ sky130_fd_sc_hd__dfrtp_1
XTAP_TAPCELL_ROW_90_1384 VGND VPWR sky130_fd_sc_hd__tapvpwrvgnd_1
X_6166_ clknet_leaf_10_clk _0574_ _0099_ VGND VGND VPWR VPWR JMPOFF\[15\] sky130_fd_sc_hd__dfrtp_4
X_3378_ reg_file_inst.registry\[15\]\[20\] _1122_ _1142_ reg_file_inst.registry\[1\]\[20\]
+ _1117_ VGND VGND VPWR VPWR _1315_ sky130_fd_sc_hd__a221o_1
XFILLER_111_281 VPWR VGND VPWR VGND sky130_ef_sc_hd__decap_12
XTAP_TAPCELL_ROW_90_1395 VGND VPWR sky130_fd_sc_hd__tapvpwrvgnd_1
XFILLER_57_313 VGND VGND VPWR VPWR sky130_fd_sc_hd__decap_3
X_5117_ _1765_ _2295_ _2456_ _2930_ VGND VGND VPWR VPWR _2944_ sky130_fd_sc_hd__a31oi_1
X_6097_ clknet_leaf_0_clk _0505_ _0030_ VGND VGND VPWR VPWR reg_file_inst.registry\[9\]\[2\]
+ sky130_fd_sc_hd__dfrtp_1
X_5048_ reg_file_inst.registry\[7\]\[16\] _2883_ _2553_ VGND VGND VPWR VPWR _0891_
+ sky130_fd_sc_hd__mux2_1
XFILLER_26_722 VGND VGND VPWR VPWR sky130_fd_sc_hd__decap_4
XFILLER_41_725 VGND VGND VPWR VPWR sky130_fd_sc_hd__fill_1
XFILLER_13_449 VGND VGND VPWR VPWR sky130_fd_sc_hd__decap_4
XFILLER_25_298 VGND VGND VPWR VPWR sky130_fd_sc_hd__decap_3
XFILLER_43_57 VGND VGND VPWR VPWR sky130_fd_sc_hd__fill_1
XFILLER_111_3 VPWR VGND VPWR VGND sky130_ef_sc_hd__decap_12
XFILLER_5_615 VGND VGND VPWR VPWR sky130_fd_sc_hd__fill_1
XFILLER_4_103 VPWR VGND VPWR VGND sky130_ef_sc_hd__decap_12
XFILLER_4_29 VPWR VGND VPWR VGND sky130_ef_sc_hd__decap_12
XFILLER_4_18 VGND VGND VPWR VPWR sky130_fd_sc_hd__decap_8
XFILLER_122_557 VGND VGND VPWR VPWR sky130_fd_sc_hd__decap_3
XFILLER_108_83 VGND VGND VPWR VPWR sky130_fd_sc_hd__fill_1
XFILLER_68_21 VGND VGND VPWR VPWR sky130_fd_sc_hd__decap_6
XFILLER_110_719 VGND VGND VPWR VPWR sky130_fd_sc_hd__fill_1
XFILLER_0_331 VGND VGND VPWR VPWR sky130_fd_sc_hd__fill_2
XFILLER_75_110 VGND VGND VPWR VPWR sky130_fd_sc_hd__fill_2
XFILLER_68_98 VGND VGND VPWR VPWR sky130_fd_sc_hd__decap_8
XFILLER_0_397 VGND VGND VPWR VPWR sky130_fd_sc_hd__fill_1
XFILLER_84_20 VGND VGND VPWR VPWR sky130_fd_sc_hd__decap_4
XFILLER_75_165 VGND VGND VPWR VPWR sky130_fd_sc_hd__decap_3
XFILLER_63_327 VGND VGND VPWR VPWR sky130_fd_sc_hd__decap_8
XFILLER_16_265 VGND VGND VPWR VPWR sky130_fd_sc_hd__decap_4
XFILLER_32_725 VGND VGND VPWR VPWR sky130_fd_sc_hd__fill_1
XFILLER_71_393 VGND VGND VPWR VPWR sky130_fd_sc_hd__decap_8
XTAP_TAPCELL_ROW_14_433 VGND VPWR sky130_fd_sc_hd__tapvpwrvgnd_1
XTAP_TAPCELL_ROW_14_444 VGND VPWR sky130_fd_sc_hd__tapvpwrvgnd_1
XFILLER_83_7 VGND VGND VPWR VPWR sky130_fd_sc_hd__fill_1
XFILLER_8_431 VGND VGND VPWR VPWR sky130_fd_sc_hd__decap_6
XTAP_TAPCELL_ROW_42_786 VGND VPWR sky130_fd_sc_hd__tapvpwrvgnd_1
XTAP_TAPCELL_ROW_117_1730 VGND VPWR sky130_fd_sc_hd__tapvpwrvgnd_1
XFILLER_117_329 VGND VGND VPWR VPWR sky130_fd_sc_hd__decap_6
XFILLER_8_475 VGND VGND VPWR VPWR sky130_fd_sc_hd__fill_1
X_4350_ _1217_ _1840_ _2190_ VGND VGND VPWR VPWR _2238_ sky130_fd_sc_hd__and3_1
XFILLER_99_725 VGND VGND VPWR VPWR sky130_fd_sc_hd__fill_1
X_3301_ reg_file_inst.registry\[7\]\[23\] _1133_ _1235_ _1239_ _1240_ VGND VGND VPWR
+ VPWR _1241_ sky130_fd_sc_hd__a2111o_1
XFILLER_4_681 VPWR VGND VPWR VGND sky130_ef_sc_hd__decap_12
X_4281_ _1722_ _2148_ VGND VGND VPWR VPWR _2169_ sky130_fd_sc_hd__xnor2_1
X_6020_ net149 VGND VGND VPWR VPWR _0428_ sky130_fd_sc_hd__inv_2
X_3232_ _1162_ _1171_ VGND VGND VPWR VPWR _1174_ sky130_fd_sc_hd__xnor2_1
Xclkbuf_leaf_3_clk clknet_3_0__leaf_clk VGND VGND VPWR VPWR clknet_leaf_3_clk sky130_fd_sc_hd__clkbuf_8
X_3163_ _1102_ _1104_ _1106_ VGND VGND VPWR VPWR _1107_ sky130_fd_sc_hd__or3_1
XFILLER_79_482 VGND VGND VPWR VPWR sky130_fd_sc_hd__fill_1
XFILLER_94_441 VPWR VGND VPWR VGND sky130_ef_sc_hd__decap_12
XFILLER_27_508 VGND VGND VPWR VPWR sky130_fd_sc_hd__decap_4
XFILLER_82_625 VPWR VGND VPWR VGND sky130_ef_sc_hd__decap_12
XTAP_TAPCELL_ROW_68_1117 VGND VPWR sky130_fd_sc_hd__tapvpwrvgnd_1
XFILLER_39_379 VGND VGND VPWR VPWR sky130_fd_sc_hd__decap_8
X_3094_ JMPOFF\[11\] net141 net41 VGND VGND VPWR VPWR _1038_ sky130_fd_sc_hd__a21o_1
XFILLER_82_669 VPWR VGND VPWR VGND sky130_ef_sc_hd__decap_12
XFILLER_120_29 VPWR VGND VPWR VGND sky130_ef_sc_hd__decap_12
XFILLER_50_500 VGND VGND VPWR VPWR sky130_fd_sc_hd__decap_8
X_5804_ net147 VGND VGND VPWR VPWR _0212_ sky130_fd_sc_hd__inv_2
XFILLER_50_533 VPWR VGND VPWR VGND sky130_ef_sc_hd__decap_12
X_3996_ _1034_ _1911_ _1039_ VGND VGND VPWR VPWR _1912_ sky130_fd_sc_hd__a21o_1
X_5735_ net149 VGND VGND VPWR VPWR _0143_ sky130_fd_sc_hd__inv_2
XFILLER_10_419 VGND VGND VPWR VPWR sky130_fd_sc_hd__fill_1
XFILLER_13_27 VPWR VGND VPWR VGND sky130_ef_sc_hd__decap_12
XFILLER_108_307 VGND VGND VPWR VPWR sky130_fd_sc_hd__fill_1
X_5666_ net147 VGND VGND VPWR VPWR _0074_ sky130_fd_sc_hd__inv_2
XTAP_TAPCELL_ROW_79_1257 VGND VPWR sky130_fd_sc_hd__tapvpwrvgnd_1
XTAP_TAPCELL_ROW_79_1246 VGND VPWR sky130_fd_sc_hd__tapvpwrvgnd_1
X_4617_ net136 _2318_ VGND VGND VPWR VPWR _2494_ sky130_fd_sc_hd__nand2_1
X_5597_ net149 VGND VGND VPWR VPWR _0005_ sky130_fd_sc_hd__inv_2
XTAP_TAPCELL_ROW_92_1413 VGND VPWR sky130_fd_sc_hd__tapvpwrvgnd_1
X_4548_ _1817_ _2355_ VGND VGND VPWR VPWR _2429_ sky130_fd_sc_hd__nand2_1
XFILLER_104_557 VPWR VGND VPWR VGND sky130_ef_sc_hd__decap_12
XFILLER_89_246 VPWR VGND VPWR VGND sky130_ef_sc_hd__decap_12
X_4479_ _1840_ _2305_ _2363_ VGND VGND VPWR VPWR _2364_ sky130_fd_sc_hd__a21oi_2
X_6218_ clknet_leaf_0_clk _0626_ _0151_ VGND VGND VPWR VPWR reg_file_inst.registry\[10\]\[11\]
+ sky130_fd_sc_hd__dfrtp_1
XFILLER_57_110 VGND VGND VPWR VPWR sky130_fd_sc_hd__fill_2
X_6149_ clknet_leaf_21_clk _0557_ _0082_ VGND VGND VPWR VPWR reg_file_inst.registry\[6\]\[26\]
+ sky130_fd_sc_hd__dfrtp_1
XFILLER_85_452 VGND VGND VPWR VPWR sky130_fd_sc_hd__decap_8
XFILLER_73_603 VPWR VGND VPWR VGND sky130_ef_sc_hd__decap_12
XPHY_EDGE_ROW_79_Right_79 VGND VGND VPWR VPWR sky130_fd_sc_hd__decap_3
XFILLER_57_198 VGND VGND VPWR VPWR sky130_fd_sc_hd__decap_6
XFILLER_26_530 VGND VGND VPWR VPWR sky130_fd_sc_hd__fill_2
XFILLER_26_541 VGND VGND VPWR VPWR sky130_fd_sc_hd__fill_2
XFILLER_72_157 VGND VGND VPWR VPWR sky130_fd_sc_hd__fill_2
XFILLER_14_714 VPWR VGND VPWR VGND sky130_ef_sc_hd__decap_12
XFILLER_26_563 VGND VGND VPWR VPWR sky130_fd_sc_hd__fill_2
XFILLER_53_393 VPWR VGND VPWR VGND sky130_ef_sc_hd__decap_12
XFILLER_13_213 VGND VGND VPWR VPWR sky130_fd_sc_hd__decap_8
XFILLER_41_522 VPWR VGND VPWR VGND sky130_ef_sc_hd__decap_12
XTAP_TAPCELL_ROW_101_1531 VGND VPWR sky130_fd_sc_hd__tapvpwrvgnd_1
XFILLER_9_206 VGND VGND VPWR VPWR sky130_fd_sc_hd__decap_4
XFILLER_13_246 VPWR VGND VPWR VGND sky130_ef_sc_hd__decap_12
XFILLER_70_11 VGND VGND VPWR VPWR sky130_fd_sc_hd__fill_1
XTAP_TAPCELL_ROW_11_403 VGND VPWR sky130_fd_sc_hd__tapvpwrvgnd_1
XFILLER_70_77 VGND VGND VPWR VPWR sky130_fd_sc_hd__decap_6
XFILLER_21_290 VGND VGND VPWR VPWR sky130_fd_sc_hd__decap_8
XPHY_EDGE_ROW_88_Right_88 VGND VGND VPWR VPWR sky130_fd_sc_hd__decap_3
XFILLER_119_93 VPWR VGND VPWR VGND sky130_ef_sc_hd__decap_12
XFILLER_107_373 VPWR VGND VPWR VGND sky130_ef_sc_hd__decap_12
XFILLER_79_53 VGND VGND VPWR VPWR sky130_fd_sc_hd__decap_3
XFILLER_122_321 VPWR VGND VPWR VGND sky130_ef_sc_hd__decap_12
XFILLER_79_75 VGND VGND VPWR VPWR sky130_fd_sc_hd__decap_4
XTAP_TAPCELL_ROW_112_1660 VGND VPWR sky130_fd_sc_hd__tapvpwrvgnd_1
XFILLER_68_408 VGND VGND VPWR VPWR sky130_fd_sc_hd__decap_3
XFILLER_95_216 VGND VGND VPWR VPWR sky130_fd_sc_hd__decap_8
XFILLER_1_673 VPWR VGND VPWR VGND sky130_ef_sc_hd__decap_12
XPHY_EDGE_ROW_97_Right_97 VGND VGND VPWR VPWR sky130_fd_sc_hd__decap_3
XFILLER_95_249 VGND VGND VPWR VPWR sky130_fd_sc_hd__fill_1
XTAP_TAPCELL_ROW_19_503 VGND VPWR sky130_fd_sc_hd__tapvpwrvgnd_1
XFILLER_63_113 VPWR VGND VPWR VGND sky130_ef_sc_hd__decap_12
XFILLER_17_530 VPWR VGND VPWR VGND sky130_ef_sc_hd__decap_12
XTAP_TAPCELL_ROW_47_856 VGND VPWR sky130_fd_sc_hd__tapvpwrvgnd_1
XFILLER_91_488 VPWR VGND VPWR VGND sky130_ef_sc_hd__decap_12
XFILLER_51_319 VPWR VGND VPWR VGND sky130_ef_sc_hd__decap_12
XFILLER_72_691 VGND VGND VPWR VPWR sky130_fd_sc_hd__decap_8
XTAP_TAPCELL_ROW_63_1047 VGND VPWR sky130_fd_sc_hd__tapvpwrvgnd_1
X_3850_ reg_file_inst.registry\[5\]\[3\] _1127_ _1132_ VGND VGND VPWR VPWR _1770_
+ sky130_fd_sc_hd__and3_1
X_3781_ reg_file_inst.registry\[1\]\[4\] _1087_ _1091_ reg_file_inst.registry\[3\]\[4\]
+ _1702_ VGND VGND VPWR VPWR _1703_ sky130_fd_sc_hd__a221o_1
XFILLER_74_3 VPWR VGND VPWR VGND sky130_ef_sc_hd__decap_12
X_5520_ reg_file_inst.registry\[6\]\[14\] _2909_ _3001_ VGND VGND VPWR VPWR _0545_
+ sky130_fd_sc_hd__mux2_1
XFILLER_117_137 VPWR VGND VPWR VGND sky130_ef_sc_hd__decap_12
X_5451_ reg_file_inst.registry\[5\]\[25\] _2767_ _2999_ VGND VGND VPWR VPWR _0612_
+ sky130_fd_sc_hd__mux2_1
X_5382_ MEMOFF\[7\] _2311_ _2996_ VGND VGND VPWR VPWR _0678_ sky130_fd_sc_hd__mux2_1
X_4402_ _1652_ _2123_ _2286_ _1668_ _2288_ VGND VGND VPWR VPWR _2290_ sky130_fd_sc_hd__a221o_1
X_4333_ _1594_ _2190_ VGND VGND VPWR VPWR _2221_ sky130_fd_sc_hd__and2_1
XFILLER_101_505 VGND VGND VPWR VPWR sky130_fd_sc_hd__decap_3
XTAP_TAPCELL_ROW_74_1187 VGND VPWR sky130_fd_sc_hd__tapvpwrvgnd_1
X_4264_ _1778_ _2151_ VGND VGND VPWR VPWR _2152_ sky130_fd_sc_hd__and2_1
X_3215_ reg_file_inst.registry\[4\]\[26\] _1092_ _1094_ reg_file_inst.registry\[6\]\[26\]
+ _1157_ VGND VGND VPWR VPWR _1158_ sky130_fd_sc_hd__a221o_1
X_6003_ net147 VGND VGND VPWR VPWR _0411_ sky130_fd_sc_hd__inv_2
X_4195_ _1920_ _2082_ VGND VGND VPWR VPWR _2095_ sky130_fd_sc_hd__xnor2_1
XFILLER_27_305 VPWR VGND VPWR VGND sky130_ef_sc_hd__decap_12
XFILLER_39_165 VGND VGND VPWR VPWR sky130_fd_sc_hd__decap_3
X_3146_ _1074_ _1088_ VGND VGND VPWR VPWR _1090_ sky130_fd_sc_hd__and2_4
X_3077_ _1002_ _1018_ _1020_ VGND VGND VPWR VPWR _1021_ sky130_fd_sc_hd__o21ba_1
XFILLER_35_393 VGND VGND VPWR VPWR sky130_fd_sc_hd__decap_3
X_5718_ net147 VGND VGND VPWR VPWR _0126_ sky130_fd_sc_hd__inv_2
XFILLER_10_227 VGND VGND VPWR VPWR sky130_fd_sc_hd__fill_1
X_3979_ _1047_ _1056_ _1887_ _1894_ VGND VGND VPWR VPWR _1895_ sky130_fd_sc_hd__a31o_1
X_5649_ net149 VGND VGND VPWR VPWR _0057_ sky130_fd_sc_hd__inv_2
XFILLER_40_58 VGND VGND VPWR VPWR sky130_fd_sc_hd__fill_1
XFILLER_117_671 VGND VGND VPWR VPWR sky130_fd_sc_hd__fill_1
XFILLER_104_321 VPWR VGND VPWR VGND sky130_ef_sc_hd__decap_12
XFILLER_104_365 VPWR VGND VPWR VGND sky130_ef_sc_hd__decap_12
XFILLER_105_51 VGND VGND VPWR VPWR sky130_fd_sc_hd__decap_4
XFILLER_93_709 VGND VGND VPWR VPWR sky130_fd_sc_hd__decap_6
XFILLER_58_430 VPWR VGND VPWR VGND sky130_ef_sc_hd__decap_12
XFILLER_85_271 VGND VGND VPWR VPWR sky130_fd_sc_hd__decap_8
XFILLER_18_316 VPWR VGND VPWR VGND sky130_ef_sc_hd__decap_12
XFILLER_46_614 VPWR VGND VPWR VGND sky130_ef_sc_hd__decap_12
XFILLER_45_113 VPWR VGND VPWR VGND sky130_ef_sc_hd__decap_12
XFILLER_33_308 VGND VGND VPWR VPWR sky130_fd_sc_hd__fill_1
XTAP_TAPCELL_ROW_44_815 VGND VPWR sky130_fd_sc_hd__tapvpwrvgnd_1
XFILLER_45_157 VGND VGND VPWR VPWR sky130_fd_sc_hd__decap_3
XFILLER_26_360 VGND VGND VPWR VPWR sky130_fd_sc_hd__decap_4
XFILLER_14_533 VGND VGND VPWR VPWR sky130_fd_sc_hd__decap_8
XFILLER_14_544 VGND VGND VPWR VPWR sky130_fd_sc_hd__decap_6
XFILLER_14_577 VGND VGND VPWR VPWR sky130_fd_sc_hd__decap_8
XTAP_TAPCELL_ROW_24_561 VGND VPWR sky130_fd_sc_hd__tapvpwrvgnd_1
XFILLER_108_693 VGND VGND VPWR VPWR sky130_fd_sc_hd__decap_6
XFILLER_107_181 VPWR VGND VPWR VGND sky130_ef_sc_hd__decap_12
XFILLER_1_470 VGND VGND VPWR VPWR sky130_fd_sc_hd__decap_4
XFILLER_110_357 VGND VGND VPWR VPWR sky130_fd_sc_hd__decap_6
Xinput7 DataMemoryRead[15] VGND VGND VPWR VPWR net7 sky130_fd_sc_hd__clkbuf_2
XFILLER_64_444 VPWR VGND VPWR VGND sky130_ef_sc_hd__decap_12
XFILLER_64_433 VGND VGND VPWR VPWR sky130_fd_sc_hd__decap_8
XFILLER_36_124 VGND VGND VPWR VPWR sky130_fd_sc_hd__fill_1
XFILLER_64_477 VGND VGND VPWR VPWR sky130_fd_sc_hd__decap_8
XFILLER_52_639 VGND VGND VPWR VPWR sky130_fd_sc_hd__decap_4
X_4951_ _1765_ _2684_ VGND VGND VPWR VPWR _2802_ sky130_fd_sc_hd__nand2_1
X_4882_ _1790_ _2734_ _2738_ _1764_ VGND VGND VPWR VPWR _2739_ sky130_fd_sc_hd__a211o_1
XFILLER_17_393 VGND VGND VPWR VPWR sky130_fd_sc_hd__decap_4
X_3902_ reg_file_inst.registry\[7\]\[1\] _1133_ _1139_ reg_file_inst.registry\[5\]\[1\]
+ VGND VGND VPWR VPWR _1820_ sky130_fd_sc_hd__a22o_1
X_3833_ _1735_ _1751_ VGND VGND VPWR VPWR _1753_ sky130_fd_sc_hd__xnor2_2
XFILLER_20_536 VPWR VGND VPWR VGND sky130_ef_sc_hd__decap_12
XFILLER_118_413 VGND VGND VPWR VPWR sky130_fd_sc_hd__decap_6
X_3764_ reg_file_inst.registry\[1\]\[6\] net145 _1127_ VGND VGND VPWR VPWR _1687_
+ sky130_fd_sc_hd__and3_1
XFILLER_118_457 VPWR VGND VPWR VGND sky130_ef_sc_hd__decap_12
X_6483_ clknet_leaf_17_clk _0891_ _0416_ VGND VGND VPWR VPWR reg_file_inst.registry\[7\]\[16\]
+ sky130_fd_sc_hd__dfrtp_1
X_5503_ JMPOFF\[2\] _2501_ _3000_ VGND VGND VPWR VPWR _0561_ sky130_fd_sc_hd__mux2_1
X_3695_ reg_file_inst.registry\[0\]\[8\] _1118_ _1610_ _1619_ VGND VGND VPWR VPWR
+ net99 sky130_fd_sc_hd__o22a_2
XTAP_TAPCELL_ROW_76_1216 VGND VPWR sky130_fd_sc_hd__tapvpwrvgnd_1
X_5434_ _2922_ reg_file_inst.registry\[10\]\[13\] _2998_ VGND VGND VPWR VPWR _0628_
+ sky130_fd_sc_hd__mux2_1
X_5365_ MEMOFF\[24\] _2787_ _2996_ VGND VGND VPWR VPWR _0695_ sky130_fd_sc_hd__mux2_1
XFILLER_101_313 VPWR VGND VPWR VGND sky130_ef_sc_hd__decap_12
XFILLER_99_385 VGND VGND VPWR VPWR sky130_fd_sc_hd__decap_6
X_4316_ _1840_ _2202_ _2203_ _1294_ VGND VGND VPWR VPWR _2204_ sky130_fd_sc_hd__a22o_1
X_5296_ _2375_ reg_file_inst.registry\[2\]\[6\] _2993_ VGND VGND VPWR VPWR _0761_
+ sky130_fd_sc_hd__mux2_1
XFILLER_87_569 VGND VGND VPWR VPWR sky130_fd_sc_hd__fill_1
XFILLER_75_709 VPWR VGND VPWR VGND sky130_ef_sc_hd__decap_12
XFILLER_19_15 VPWR VGND VPWR VGND sky130_ef_sc_hd__decap_12
X_4247_ _1667_ _2134_ VGND VGND VPWR VPWR _2135_ sky130_fd_sc_hd__and2_1
X_4178_ _1987_ _1989_ VGND VGND VPWR VPWR _2083_ sky130_fd_sc_hd__nand2_1
XFILLER_27_113 VGND VGND VPWR VPWR sky130_fd_sc_hd__decap_8
XFILLER_27_124 VGND VGND VPWR VPWR sky130_fd_sc_hd__decap_4
XFILLER_27_135 VGND VGND VPWR VPWR sky130_fd_sc_hd__decap_4
XFILLER_28_636 VGND VGND VPWR VPWR sky130_fd_sc_hd__decap_8
XTAP_TAPCELL_ROW_87_1356 VGND VPWR sky130_fd_sc_hd__tapvpwrvgnd_1
X_3129_ _0971_ _1072_ _0970_ VGND VGND VPWR VPWR _1073_ sky130_fd_sc_hd__a21oi_1
XTAP_TAPCELL_ROW_2_289 VGND VPWR sky130_fd_sc_hd__tapvpwrvgnd_1
XFILLER_82_296 VGND VGND VPWR VPWR sky130_fd_sc_hd__decap_4
XFILLER_55_488 VPWR VGND VPWR VGND sky130_ef_sc_hd__decap_12
XFILLER_23_341 VGND VGND VPWR VPWR sky130_fd_sc_hd__fill_1
XFILLER_51_661 VGND VGND VPWR VPWR sky130_fd_sc_hd__decap_4
XFILLER_23_363 VPWR VGND VPWR VGND sky130_ef_sc_hd__decap_12
XFILLER_11_558 VGND VGND VPWR VPWR sky130_fd_sc_hd__fill_2
XFILLER_51_57 VGND VGND VPWR VPWR sky130_fd_sc_hd__decap_3
XFILLER_7_529 VPWR VGND VPWR VGND sky130_ef_sc_hd__decap_12
XTAP_TAPCELL_ROW_21_531 VGND VPWR sky130_fd_sc_hd__tapvpwrvgnd_1
XTAP_TAPCELL_ROW_98_1485 VGND VPWR sky130_fd_sc_hd__tapvpwrvgnd_1
XFILLER_105_641 VPWR VGND VPWR VGND sky130_ef_sc_hd__decap_12
XFILLER_105_685 VPWR VGND VPWR VGND sky130_ef_sc_hd__decap_12
XFILLER_78_525 VGND VGND VPWR VPWR sky130_fd_sc_hd__decap_6
XFILLER_116_83 VGND VGND VPWR VPWR sky130_fd_sc_hd__fill_1
XFILLER_120_699 VGND VGND VPWR VPWR sky130_fd_sc_hd__fill_1
XFILLER_76_76 VGND VGND VPWR VPWR sky130_fd_sc_hd__fill_1
XFILLER_93_539 VGND VGND VPWR VPWR sky130_fd_sc_hd__fill_1
XFILLER_18_113 VGND VGND VPWR VPWR sky130_fd_sc_hd__fill_1
XFILLER_46_433 VPWR VGND VPWR VGND sky130_ef_sc_hd__decap_12
XTAP_TAPCELL_ROW_57_973 VGND VPWR sky130_fd_sc_hd__tapvpwrvgnd_1
XTAP_TAPCELL_ROW_29_631 VGND VPWR sky130_fd_sc_hd__tapvpwrvgnd_1
XFILLER_46_477 VGND VGND VPWR VPWR sky130_fd_sc_hd__decap_4
XFILLER_34_639 VGND VGND VPWR VPWR sky130_fd_sc_hd__decap_4
XFILLER_92_97 VPWR VGND VPWR VGND sky130_ef_sc_hd__decap_12
XFILLER_61_447 VGND VGND VPWR VPWR sky130_fd_sc_hd__fill_1
XFILLER_26_190 VGND VGND VPWR VPWR sky130_fd_sc_hd__decap_6
XFILLER_14_363 VGND VGND VPWR VPWR sky130_fd_sc_hd__fill_1
XTAP_TAPCELL_ROW_120_1770 VGND VPWR sky130_fd_sc_hd__tapvpwrvgnd_1
XTAP_TAPCELL_ROW_60_1017 VGND VPWR sky130_fd_sc_hd__tapvpwrvgnd_1
XFILLER_41_160 VGND VGND VPWR VPWR sky130_fd_sc_hd__decap_8
XFILLER_41_193 VGND VGND VPWR VPWR sky130_fd_sc_hd__fill_1
XFILLER_115_405 VPWR VGND VPWR VGND sky130_ef_sc_hd__decap_12
X_3480_ reg_file_inst.registry\[4\]\[17\] _1134_ _1136_ reg_file_inst.registry\[8\]\[17\]
+ VGND VGND VPWR VPWR _1413_ sky130_fd_sc_hd__a22o_1
XFILLER_115_449 VPWR VGND VPWR VGND sky130_ef_sc_hd__decap_12
XPHY_EDGE_ROW_102_Left_225 VGND VGND VPWR VPWR sky130_fd_sc_hd__decap_3
X_5150_ _2249_ _2750_ _2965_ _2192_ _2255_ VGND VGND VPWR VPWR _2973_ sky130_fd_sc_hd__o221a_1
XFILLER_37_3 VGND VGND VPWR VPWR sky130_fd_sc_hd__fill_2
XFILLER_110_121 VPWR VGND VPWR VGND sky130_ef_sc_hd__decap_12
XTAP_TAPCELL_ROW_71_1157 VGND VPWR sky130_fd_sc_hd__tapvpwrvgnd_1
XTAP_TAPCELL_ROW_71_1146 VGND VPWR sky130_fd_sc_hd__tapvpwrvgnd_1
X_4101_ _2012_ _2015_ VGND VGND VPWR VPWR _2017_ sky130_fd_sc_hd__nand2_1
X_5081_ _2382_ _2392_ _1764_ VGND VGND VPWR VPWR _2912_ sky130_fd_sc_hd__mux2_1
XFILLER_110_165 VPWR VGND VPWR VGND sky130_ef_sc_hd__decap_12
X_4032_ _1878_ _1946_ net124 VGND VGND VPWR VPWR _1948_ sky130_fd_sc_hd__a21o_1
XFILLER_80_701 VPWR VGND VPWR VGND sky130_ef_sc_hd__decap_12
XFILLER_37_455 VGND VGND VPWR VPWR sky130_fd_sc_hd__fill_1
X_5983_ net147 VGND VGND VPWR VPWR _0391_ sky130_fd_sc_hd__inv_2
XFILLER_25_617 VGND VGND VPWR VPWR sky130_fd_sc_hd__decap_8
XPHY_EDGE_ROW_111_Left_234 VGND VGND VPWR VPWR sky130_fd_sc_hd__decap_3
X_4934_ _2176_ _2675_ _2768_ _2786_ VGND VGND VPWR VPWR net61 sky130_fd_sc_hd__a31o_1
XFILLER_24_127 VPWR VGND VPWR VGND sky130_ef_sc_hd__decap_12
XTAP_TAPCELL_ROW_82_1286 VGND VPWR sky130_fd_sc_hd__tapvpwrvgnd_1
XANTENNA_12 _2455_ VGND VGND VPWR VPWR sky130_fd_sc_hd__diode_2
X_4865_ _2128_ _2718_ _2720_ VGND VGND VPWR VPWR _2722_ sky130_fd_sc_hd__a21oi_1
XANTENNA_23 net95 VGND VGND VPWR VPWR sky130_fd_sc_hd__diode_2
X_3816_ reg_file_inst.registry\[15\]\[5\] _1122_ _1139_ reg_file_inst.registry\[5\]\[5\]
+ _1117_ VGND VGND VPWR VPWR _1737_ sky130_fd_sc_hd__a221o_1
X_4796_ _1392_ _2654_ VGND VGND VPWR VPWR _2655_ sky130_fd_sc_hd__xnor2_1
XFILLER_118_221 VPWR VGND VPWR VGND sky130_ef_sc_hd__decap_12
X_6535_ clknet_leaf_39_clk _0943_ _0468_ VGND VGND VPWR VPWR net115 sky130_fd_sc_hd__dfrtp_1
XFILLER_21_27 VGND VGND VPWR VPWR sky130_fd_sc_hd__fill_1
X_3747_ reg_file_inst.registry\[6\]\[6\] _1080_ _1084_ _1093_ reg_file_inst.registry\[15\]\[6\]
+ VGND VGND VPWR VPWR _1670_ sky130_fd_sc_hd__a32o_1
XFILLER_118_265 VPWR VGND VPWR VGND sky130_ef_sc_hd__decap_12
X_6466_ clknet_leaf_19_clk _0874_ _0399_ VGND VGND VPWR VPWR reg_file_inst.registry\[0\]\[27\]
+ sky130_fd_sc_hd__dfrtp_1
X_3678_ reg_file_inst.registry\[14\]\[8\] _1081_ _1086_ reg_file_inst.registry\[7\]\[8\]
+ _1602_ VGND VGND VPWR VPWR _1603_ sky130_fd_sc_hd__a221o_1
Xoutput130 net130 VGND VGND VPWR VPWR halt sky130_fd_sc_hd__buf_1
XPHY_EDGE_ROW_120_Left_243 VGND VGND VPWR VPWR sky130_fd_sc_hd__decap_3
X_6397_ clknet_leaf_37_clk _0805_ _0330_ VGND VGND VPWR VPWR reg_file_inst.registry\[14\]\[22\]
+ sky130_fd_sc_hd__dfrtp_1
X_5417_ reg_file_inst.registry\[4\]\[1\] _2528_ _2997_ VGND VGND VPWR VPWR _0644_
+ sky130_fd_sc_hd__mux2_1
XFILLER_99_160 VGND VGND VPWR VPWR sky130_fd_sc_hd__decap_8
X_5348_ _2934_ reg_file_inst.registry\[3\]\[12\] _2995_ VGND VGND VPWR VPWR _0711_
+ sky130_fd_sc_hd__mux2_1
XTAP_TAPCELL_ROW_7_348 VGND VPWR sky130_fd_sc_hd__tapvpwrvgnd_1
XFILLER_101_143 VPWR VGND VPWR VGND sky130_ef_sc_hd__decap_12
X_5279_ _2806_ reg_file_inst.registry\[2\]\[23\] _2993_ VGND VGND VPWR VPWR _0778_
+ sky130_fd_sc_hd__mux2_1
XFILLER_87_388 VGND VGND VPWR VPWR sky130_fd_sc_hd__decap_4
XFILLER_75_517 VGND VGND VPWR VPWR sky130_fd_sc_hd__fill_2
XFILLER_102_699 VGND VGND VPWR VPWR sky130_fd_sc_hd__fill_1
XFILLER_102_41 VPWR VGND VPWR VGND sky130_ef_sc_hd__decap_12
XTAP_TAPCELL_ROW_54_943 VGND VPWR sky130_fd_sc_hd__tapvpwrvgnd_1
XFILLER_15_138 VPWR VGND VPWR VGND sky130_ef_sc_hd__decap_12
XFILLER_43_447 VGND VGND VPWR VPWR sky130_fd_sc_hd__fill_1
XFILLER_102_85 VPWR VGND VPWR VGND sky130_ef_sc_hd__decap_12
XFILLER_62_67 VPWR VGND VPWR VGND sky130_ef_sc_hd__decap_12
XFILLER_7_304 VPWR VGND VPWR VGND sky130_ef_sc_hd__decap_12
XFILLER_7_337 VGND VGND VPWR VPWR sky130_fd_sc_hd__decap_4
XFILLER_11_93 VGND VGND VPWR VPWR sky130_fd_sc_hd__decap_3
XFILLER_112_419 VGND VGND VPWR VPWR sky130_fd_sc_hd__fill_1
XFILLER_78_344 VGND VGND VPWR VPWR sky130_fd_sc_hd__decap_8
XTAP_TAPCELL_ROW_109_1621 VGND VPWR sky130_fd_sc_hd__tapvpwrvgnd_1
XTAP_TAPCELL_ROW_109_1632 VGND VPWR sky130_fd_sc_hd__tapvpwrvgnd_1
XFILLER_62_701 VGND VGND VPWR VPWR sky130_fd_sc_hd__decap_4
XFILLER_19_455 VGND VGND VPWR VPWR sky130_fd_sc_hd__fill_1
XFILLER_46_285 VGND VGND VPWR VPWR sky130_fd_sc_hd__decap_3
XFILLER_61_266 VPWR VGND VPWR VGND sky130_ef_sc_hd__decap_12
XFILLER_15_661 VGND VGND VPWR VPWR sky130_fd_sc_hd__fill_2
X_4650_ _2249_ _2524_ VGND VGND VPWR VPWR _2525_ sky130_fd_sc_hd__or2_1
XFILLER_30_642 VGND VGND VPWR VPWR sky130_fd_sc_hd__fill_2
XTAP_TAPCELL_ROW_32_659 VGND VPWR sky130_fd_sc_hd__tapvpwrvgnd_1
Xinput21 DataMemoryRead[2] VGND VGND VPWR VPWR net21 sky130_fd_sc_hd__buf_1
Xinput10 DataMemoryRead[18] VGND VGND VPWR VPWR net10 sky130_fd_sc_hd__clkbuf_2
X_3601_ reg_file_inst.registry\[0\]\[11\] net138 _1523_ _1528_ VGND VGND VPWR VPWR
+ _1529_ sky130_fd_sc_hd__o22ai_4
Xinput32 instr[12] VGND VGND VPWR VPWR net32 sky130_fd_sc_hd__clkbuf_4
Xinput43 instr[9] VGND VGND VPWR VPWR net43 sky130_fd_sc_hd__buf_6
X_4581_ _2201_ _2218_ _1791_ VGND VGND VPWR VPWR _2460_ sky130_fd_sc_hd__mux2_1
X_6320_ clknet_leaf_58_clk _0728_ _0253_ VGND VGND VPWR VPWR reg_file_inst.registry\[8\]\[1\]
+ sky130_fd_sc_hd__dfrtp_1
XFILLER_116_725 VGND VGND VPWR VPWR sky130_fd_sc_hd__fill_1
X_3532_ MEMOFF\[13\] _1129_ _1140_ reg_file_inst.registry\[3\]\[13\] _1117_ VGND VGND
+ VPWR VPWR _1463_ sky130_fd_sc_hd__a221o_1
X_6251_ clknet_leaf_17_clk _0659_ _0184_ VGND VGND VPWR VPWR reg_file_inst.registry\[4\]\[16\]
+ sky130_fd_sc_hd__dfrtp_1
X_3463_ reg_file_inst.registry\[3\]\[17\] _1091_ _1094_ reg_file_inst.registry\[6\]\[17\]
+ VGND VGND VPWR VPWR _1396_ sky130_fd_sc_hd__a22o_1
XFILLER_6_392 VGND VGND VPWR VPWR sky130_fd_sc_hd__decap_3
XFILLER_115_279 VGND VGND VPWR VPWR sky130_fd_sc_hd__fill_1
X_6182_ clknet_leaf_5_clk _0590_ _0115_ VGND VGND VPWR VPWR reg_file_inst.registry\[5\]\[3\]
+ sky130_fd_sc_hd__dfrtp_1
X_5202_ _2478_ reg_file_inst.registry\[0\]\[3\] _2988_ VGND VGND VPWR VPWR _0850_
+ sky130_fd_sc_hd__mux2_1
XFILLER_97_653 VPWR VGND VPWR VGND sky130_ef_sc_hd__decap_12
X_3394_ reg_file_inst.registry\[14\]\[19\] _1081_ _1083_ reg_file_inst.registry\[2\]\[19\]
+ VGND VGND VPWR VPWR _1330_ sky130_fd_sc_hd__a22o_1
X_5133_ _2952_ _2953_ _2957_ VGND VGND VPWR VPWR _2958_ sky130_fd_sc_hd__a21o_1
XFILLER_111_441 VGND VGND VPWR VPWR sky130_fd_sc_hd__decap_6
XFILLER_96_141 VGND VGND VPWR VPWR sky130_fd_sc_hd__decap_3
XTAP_TAPCELL_ROW_4_318 VGND VPWR sky130_fd_sc_hd__tapvpwrvgnd_1
XFILLER_111_485 VPWR VGND VPWR VGND sky130_ef_sc_hd__decap_12
XFILLER_97_697 VPWR VGND VPWR VGND sky130_ef_sc_hd__decap_12
X_5064_ reg_file_inst.registry\[7\]\[15\] _2897_ _2553_ VGND VGND VPWR VPWR _0890_
+ sky130_fd_sc_hd__mux2_1
XFILLER_29_219 VGND VGND VPWR VPWR sky130_fd_sc_hd__decap_4
XFILLER_84_358 VGND VGND VPWR VPWR sky130_fd_sc_hd__decap_6
X_4015_ _0997_ _0999_ _1022_ VGND VGND VPWR VPWR _1931_ sky130_fd_sc_hd__and3_1
XTAP_TAPCELL_ROW_84_1315 VGND VPWR sky130_fd_sc_hd__tapvpwrvgnd_1
XFILLER_80_531 VGND VGND VPWR VPWR sky130_fd_sc_hd__fill_1
XFILLER_25_447 VGND VGND VPWR VPWR sky130_fd_sc_hd__fill_1
XTAP_TAPCELL_ROW_51_902 VGND VPWR sky130_fd_sc_hd__tapvpwrvgnd_1
X_5966_ net147 VGND VGND VPWR VPWR _0374_ sky130_fd_sc_hd__inv_2
X_5897_ net148 VGND VGND VPWR VPWR _0305_ sky130_fd_sc_hd__inv_2
X_4917_ _2769_ VGND VGND VPWR VPWR _2770_ sky130_fd_sc_hd__inv_2
X_4848_ _2211_ _2214_ VGND VGND VPWR VPWR _2707_ sky130_fd_sc_hd__nor2_1
XFILLER_20_141 VGND VGND VPWR VPWR sky130_fd_sc_hd__fill_2
XFILLER_21_642 VPWR VGND VPWR VGND sky130_ef_sc_hd__decap_12
XFILLER_32_26 VGND VGND VPWR VPWR sky130_fd_sc_hd__fill_2
XFILLER_21_697 VPWR VGND VPWR VGND sky130_ef_sc_hd__decap_12
XFILLER_120_8 VPWR VGND VPWR VGND sky130_ef_sc_hd__decap_12
XFILLER_119_541 VPWR VGND VPWR VGND sky130_ef_sc_hd__decap_12
X_4779_ _2635_ _2636_ VGND VGND VPWR VPWR _2638_ sky130_fd_sc_hd__nor2_1
XFILLER_119_585 VPWR VGND VPWR VGND sky130_ef_sc_hd__decap_12
XFILLER_107_725 VGND VGND VPWR VPWR sky130_fd_sc_hd__fill_1
XTAP_TAPCELL_ROW_95_1455 VGND VPWR sky130_fd_sc_hd__tapvpwrvgnd_1
X_6518_ clknet_leaf_52_clk _0926_ _0451_ VGND VGND VPWR VPWR net124 sky130_fd_sc_hd__dfrtp_1
X_6449_ clknet_leaf_27_clk _0857_ _0382_ VGND VGND VPWR VPWR reg_file_inst.registry\[0\]\[10\]
+ sky130_fd_sc_hd__dfrtp_1
XFILLER_121_205 VPWR VGND VPWR VGND sky130_ef_sc_hd__decap_12
XFILLER_121_249 VPWR VGND VPWR VGND sky130_ef_sc_hd__decap_12
XFILLER_102_441 VPWR VGND VPWR VGND sky130_ef_sc_hd__decap_12
XFILLER_57_23 VGND VGND VPWR VPWR sky130_fd_sc_hd__fill_2
XFILLER_0_579 VGND VGND VPWR VPWR sky130_fd_sc_hd__fill_1
XFILLER_102_485 VGND VGND VPWR VPWR sky130_fd_sc_hd__decap_3
XFILLER_75_314 VGND VGND VPWR VPWR sky130_fd_sc_hd__decap_4
XFILLER_57_45 VGND VGND VPWR VPWR sky130_fd_sc_hd__decap_8
XFILLER_57_89 VGND VGND VPWR VPWR sky130_fd_sc_hd__fill_1
XFILLER_113_51 VGND VGND VPWR VPWR sky130_fd_sc_hd__decap_4
XFILLER_73_11 VGND VGND VPWR VPWR sky130_fd_sc_hd__fill_1
XFILLER_44_701 VPWR VGND VPWR VGND sky130_ef_sc_hd__decap_12
XFILLER_43_211 VGND VGND VPWR VPWR sky130_fd_sc_hd__fill_1
XFILLER_73_66 VGND VGND VPWR VPWR sky130_fd_sc_hd__decap_4
XFILLER_16_469 VGND VGND VPWR VPWR sky130_fd_sc_hd__decap_6
XFILLER_31_417 VGND VGND VPWR VPWR sky130_fd_sc_hd__decap_8
XTAP_TAPCELL_ROW_104_1562 VGND VPWR sky130_fd_sc_hd__tapvpwrvgnd_1
XFILLER_12_631 VGND VGND VPWR VPWR sky130_fd_sc_hd__fill_2
XFILLER_8_613 VPWR VGND VPWR VGND sky130_ef_sc_hd__decap_12
XFILLER_8_657 VPWR VGND VPWR VGND sky130_ef_sc_hd__decap_12
XFILLER_7_145 VGND VGND VPWR VPWR sky130_fd_sc_hd__fill_1
XFILLER_98_41 VPWR VGND VPWR VGND sky130_ef_sc_hd__decap_12
XFILLER_98_85 VPWR VGND VPWR VGND sky130_ef_sc_hd__decap_12
XFILLER_3_373 VGND VGND VPWR VPWR sky130_fd_sc_hd__decap_8
XFILLER_78_141 VPWR VGND VPWR VGND sky130_ef_sc_hd__decap_12
XFILLER_94_645 VPWR VGND VPWR VGND sky130_ef_sc_hd__decap_12
XFILLER_94_634 VGND VGND VPWR VPWR sky130_fd_sc_hd__decap_8
XFILLER_79_697 VPWR VGND VPWR VGND sky130_ef_sc_hd__decap_12
XFILLER_93_188 VPWR VGND VPWR VGND sky130_ef_sc_hd__decap_12
XFILLER_19_263 VGND VGND VPWR VPWR sky130_fd_sc_hd__fill_1
XTAP_TAPCELL_ROW_37_729 VGND VPWR sky130_fd_sc_hd__tapvpwrvgnd_1
XFILLER_47_561 VGND VGND VPWR VPWR sky130_fd_sc_hd__decap_8
XFILLER_19_285 VGND VGND VPWR VPWR sky130_fd_sc_hd__fill_1
X_5820_ net149 VGND VGND VPWR VPWR _0228_ sky130_fd_sc_hd__inv_2
X_5751_ net44 VGND VGND VPWR VPWR _0159_ sky130_fd_sc_hd__inv_2
XTAP_TAPCELL_ROW_66_1089 VGND VPWR sky130_fd_sc_hd__tapvpwrvgnd_1
XTAP_TAPCELL_ROW_17_475 VGND VPWR sky130_fd_sc_hd__tapvpwrvgnd_1
X_4702_ _2126_ _2560_ VGND VGND VPWR VPWR _2561_ sky130_fd_sc_hd__or2_1
X_5682_ net149 VGND VGND VPWR VPWR _0090_ sky130_fd_sc_hd__inv_2
XFILLER_8_94 VGND VGND VPWR VPWR sky130_fd_sc_hd__fill_1
X_4633_ _1816_ _2437_ _2506_ _1826_ _2507_ VGND VGND VPWR VPWR _2508_ sky130_fd_sc_hd__a221o_1
XFILLER_118_29 VPWR VGND VPWR VGND sky130_ef_sc_hd__decap_12
X_4564_ _2428_ _2434_ _2444_ VGND VGND VPWR VPWR _2445_ sky130_fd_sc_hd__o21ai_1
XFILLER_116_533 VPWR VGND VPWR VGND sky130_ef_sc_hd__decap_12
X_6303_ clknet_leaf_10_clk _0711_ _0236_ VGND VGND VPWR VPWR reg_file_inst.registry\[3\]\[12\]
+ sky130_fd_sc_hd__dfrtp_1
X_3515_ MEMOFF\[12\] net76 _1113_ VGND VGND VPWR VPWR _1446_ sky130_fd_sc_hd__mux2_4
X_6234_ clknet_leaf_20_clk _0642_ _0167_ VGND VGND VPWR VPWR reg_file_inst.registry\[10\]\[27\]
+ sky130_fd_sc_hd__dfrtp_1
X_4495_ _2217_ _2223_ net133 VGND VGND VPWR VPWR _2378_ sky130_fd_sc_hd__mux2_1
X_3446_ reg_file_inst.registry\[15\]\[16\] _1093_ _1095_ JMPOFF\[16\] _1379_ VGND
+ VGND VPWR VPWR _1380_ sky130_fd_sc_hd__a221o_1
XFILLER_97_461 VGND VGND VPWR VPWR sky130_fd_sc_hd__decap_3
XTAP_TAPCELL_ROW_90_1385 VGND VPWR sky130_fd_sc_hd__tapvpwrvgnd_1
X_3377_ reg_file_inst.registry\[10\]\[20\] _1126_ _1140_ reg_file_inst.registry\[3\]\[20\]
+ VGND VGND VPWR VPWR _1314_ sky130_fd_sc_hd__a22o_1
X_6165_ clknet_leaf_10_clk _0573_ _0098_ VGND VGND VPWR VPWR JMPOFF\[14\] sky130_fd_sc_hd__dfrtp_4
X_5116_ _2192_ _2255_ _2277_ _2690_ _2942_ VGND VGND VPWR VPWR _2943_ sky130_fd_sc_hd__a221o_1
X_6096_ clknet_leaf_58_clk _0504_ _0029_ VGND VGND VPWR VPWR reg_file_inst.registry\[9\]\[1\]
+ sky130_fd_sc_hd__dfrtp_1
XFILLER_111_293 VPWR VGND VPWR VGND sky130_ef_sc_hd__decap_12
X_5047_ net8 net101 net52 _2308_ VGND VGND VPWR VPWR _2883_ sky130_fd_sc_hd__a22o_4
XFILLER_27_15 VGND VGND VPWR VPWR sky130_fd_sc_hd__decap_6
XFILLER_26_701 VPWR VGND VPWR VGND sky130_ef_sc_hd__decap_12
XFILLER_53_520 VPWR VGND VPWR VGND sky130_ef_sc_hd__decap_12
X_5949_ net146 VGND VGND VPWR VPWR _0357_ sky130_fd_sc_hd__inv_2
XFILLER_21_472 VGND VGND VPWR VPWR sky130_fd_sc_hd__decap_8
XFILLER_4_115 VGND VGND VPWR VPWR sky130_fd_sc_hd__decap_8
XFILLER_119_393 VPWR VGND VPWR VGND sky130_ef_sc_hd__decap_12
XFILLER_102_293 VGND VGND VPWR VPWR sky130_fd_sc_hd__fill_1
XFILLER_75_133 VGND VGND VPWR VPWR sky130_fd_sc_hd__fill_1
XFILLER_75_155 VGND VGND VPWR VPWR sky130_fd_sc_hd__fill_1
XFILLER_44_520 VPWR VGND VPWR VGND sky130_ef_sc_hd__decap_12
XFILLER_31_225 VPWR VGND VPWR VGND sky130_ef_sc_hd__decap_12
XTAP_TAPCELL_ROW_14_434 VGND VPWR sky130_fd_sc_hd__tapvpwrvgnd_1
XTAP_TAPCELL_ROW_14_445 VGND VPWR sky130_fd_sc_hd__tapvpwrvgnd_1
XFILLER_8_421 VGND VGND VPWR VPWR sky130_fd_sc_hd__fill_1
XTAP_TAPCELL_ROW_42_787 VGND VPWR sky130_fd_sc_hd__tapvpwrvgnd_1
XTAP_TAPCELL_ROW_117_1731 VGND VPWR sky130_fd_sc_hd__tapvpwrvgnd_1
XFILLER_8_498 VPWR VGND VPWR VGND sky130_ef_sc_hd__decap_12
XFILLER_113_503 VGND VGND VPWR VPWR sky130_fd_sc_hd__fill_1
X_3300_ reg_file_inst.registry\[4\]\[23\] _1134_ _1137_ reg_file_inst.registry\[2\]\[23\]
+ VGND VGND VPWR VPWR _1240_ sky130_fd_sc_hd__a22o_1
XFILLER_4_693 VGND VGND VPWR VPWR sky130_fd_sc_hd__decap_6
X_4280_ _2153_ _2166_ _2152_ VGND VGND VPWR VPWR _2168_ sky130_fd_sc_hd__a21o_1
XFILLER_101_709 VPWR VGND VPWR VGND sky130_ef_sc_hd__decap_12
X_3231_ _1162_ _1172_ VGND VGND VPWR VPWR _1173_ sky130_fd_sc_hd__or2_1
X_3162_ reg_file_inst.registry\[1\]\[27\] _1087_ _1096_ reg_file_inst.registry\[11\]\[27\]
+ _1105_ VGND VGND VPWR VPWR _1106_ sky130_fd_sc_hd__a221o_1
XFILLER_94_453 VPWR VGND VPWR VGND sky130_ef_sc_hd__decap_12
XFILLER_94_431 VGND VGND VPWR VPWR sky130_fd_sc_hd__fill_2
XFILLER_39_358 VGND VGND VPWR VPWR sky130_fd_sc_hd__fill_1
XFILLER_82_637 VGND VGND VPWR VPWR sky130_fd_sc_hd__decap_6
XTAP_TAPCELL_ROW_68_1118 VGND VPWR sky130_fd_sc_hd__tapvpwrvgnd_1
X_3093_ JMPOFF\[11\] _0967_ VGND VGND VPWR VPWR _1037_ sky130_fd_sc_hd__nand2_1
XFILLER_81_169 VPWR VGND VPWR VGND sky130_ef_sc_hd__decap_12
XFILLER_90_681 VPWR VGND VPWR VGND sky130_ef_sc_hd__decap_12
X_5803_ net147 VGND VGND VPWR VPWR _0211_ sky130_fd_sc_hd__inv_2
X_3995_ _1033_ _1054_ _1036_ VGND VGND VPWR VPWR _1911_ sky130_fd_sc_hd__a21o_1
XFILLER_50_545 VGND VGND VPWR VPWR sky130_fd_sc_hd__decap_4
XFILLER_13_39 VPWR VGND VPWR VGND sky130_ef_sc_hd__decap_12
X_5734_ net147 VGND VGND VPWR VPWR _0142_ sky130_fd_sc_hd__inv_2
X_5665_ net147 VGND VGND VPWR VPWR _0073_ sky130_fd_sc_hd__inv_2
XTAP_TAPCELL_ROW_79_1247 VGND VPWR sky130_fd_sc_hd__tapvpwrvgnd_1
X_4616_ _2165_ _2489_ _2490_ _2492_ VGND VGND VPWR VPWR _2493_ sky130_fd_sc_hd__a211o_1
XPHY_EDGE_ROW_111_Right_111 VGND VGND VPWR VPWR sky130_fd_sc_hd__decap_3
X_5596_ net149 VGND VGND VPWR VPWR _0004_ sky130_fd_sc_hd__inv_2
XFILLER_116_363 VGND VGND VPWR VPWR sky130_fd_sc_hd__fill_1
XTAP_TAPCELL_ROW_92_1414 VGND VPWR sky130_fd_sc_hd__tapvpwrvgnd_1
XFILLER_1_107 VGND VGND VPWR VPWR sky130_fd_sc_hd__decap_4
X_4547_ _1708_ _2427_ VGND VGND VPWR VPWR _2428_ sky130_fd_sc_hd__nor2_1
Xmax_cap140 _1075_ VGND VGND VPWR VPWR net140 sky130_fd_sc_hd__buf_6
X_4478_ _1171_ _2190_ _1840_ VGND VGND VPWR VPWR _2363_ sky130_fd_sc_hd__a21oi_1
XFILLER_104_569 VPWR VGND VPWR VGND sky130_ef_sc_hd__decap_12
XFILLER_89_258 VPWR VGND VPWR VGND sky130_ef_sc_hd__decap_12
X_6217_ clknet_leaf_26_clk _0625_ _0150_ VGND VGND VPWR VPWR reg_file_inst.registry\[10\]\[10\]
+ sky130_fd_sc_hd__dfrtp_1
X_3429_ reg_file_inst.registry\[15\]\[18\] _1122_ _1129_ MEMOFF\[18\] _1363_ VGND
+ VGND VPWR VPWR _1364_ sky130_fd_sc_hd__a221o_1
X_6148_ clknet_leaf_32_clk _0556_ _0081_ VGND VGND VPWR VPWR reg_file_inst.registry\[6\]\[25\]
+ sky130_fd_sc_hd__dfrtp_1
XFILLER_58_645 VGND VGND VPWR VPWR sky130_fd_sc_hd__decap_3
XFILLER_73_626 VGND VGND VPWR VPWR sky130_fd_sc_hd__decap_8
XFILLER_73_615 VGND VGND VPWR VPWR sky130_fd_sc_hd__fill_1
XFILLER_58_689 VGND VGND VPWR VPWR sky130_fd_sc_hd__fill_1
X_6079_ clknet_leaf_2_clk _0487_ _0012_ VGND VGND VPWR VPWR reg_file_inst.registry\[15\]\[12\]
+ sky130_fd_sc_hd__dfrtp_1
XFILLER_13_225 VGND VGND VPWR VPWR sky130_fd_sc_hd__decap_8
XFILLER_41_534 VGND VGND VPWR VPWR sky130_fd_sc_hd__decap_6
XFILLER_110_41 VPWR VGND VPWR VGND sky130_ef_sc_hd__decap_12
XTAP_TAPCELL_ROW_101_1532 VGND VPWR sky130_fd_sc_hd__tapvpwrvgnd_1
XTAP_TAPCELL_ROW_101_1521 VGND VPWR sky130_fd_sc_hd__tapvpwrvgnd_1
XFILLER_13_258 VPWR VGND VPWR VGND sky130_ef_sc_hd__decap_12
XFILLER_110_85 VPWR VGND VPWR VGND sky130_ef_sc_hd__decap_12
XTAP_TAPCELL_ROW_11_404 VGND VPWR sky130_fd_sc_hd__tapvpwrvgnd_1
XFILLER_5_468 VGND VGND VPWR VPWR sky130_fd_sc_hd__fill_1
XFILLER_122_333 VGND VGND VPWR VPWR sky130_fd_sc_hd__decap_3
XFILLER_107_385 VGND VGND VPWR VPWR sky130_fd_sc_hd__decap_6
XTAP_TAPCELL_ROW_112_1661 VGND VPWR sky130_fd_sc_hd__tapvpwrvgnd_1
XFILLER_95_206 VGND VGND VPWR VPWR sky130_fd_sc_hd__fill_1
XFILLER_1_641 VPWR VGND VPWR VGND sky130_ef_sc_hd__decap_12
XFILLER_1_685 VPWR VGND VPWR VGND sky130_ef_sc_hd__decap_12
XFILLER_48_100 VPWR VGND VPWR VGND sky130_ef_sc_hd__decap_12
XFILLER_49_656 VPWR VGND VPWR VGND sky130_ef_sc_hd__decap_12
XFILLER_64_626 VPWR VGND VPWR VGND sky130_ef_sc_hd__decap_12
XTAP_TAPCELL_ROW_19_504 VGND VPWR sky130_fd_sc_hd__tapvpwrvgnd_1
XFILLER_63_125 VGND VGND VPWR VPWR sky130_fd_sc_hd__decap_3
XTAP_TAPCELL_ROW_47_846 VGND VPWR sky130_fd_sc_hd__tapvpwrvgnd_1
XTAP_TAPCELL_ROW_47_857 VGND VPWR sky130_fd_sc_hd__tapvpwrvgnd_1
XFILLER_63_169 VPWR VGND VPWR VGND sky130_ef_sc_hd__decap_12
XFILLER_17_542 VPWR VGND VPWR VGND sky130_ef_sc_hd__decap_12
XFILLER_72_681 VGND VGND VPWR VPWR sky130_fd_sc_hd__decap_3
XFILLER_44_361 VGND VGND VPWR VPWR sky130_fd_sc_hd__decap_3
XTAP_TAPCELL_ROW_63_1048 VGND VPWR sky130_fd_sc_hd__tapvpwrvgnd_1
XFILLER_32_567 VGND VGND VPWR VPWR sky130_fd_sc_hd__decap_4
X_3780_ reg_file_inst.registry\[9\]\[4\] _1089_ _1093_ reg_file_inst.registry\[15\]\[4\]
+ VGND VGND VPWR VPWR _1702_ sky130_fd_sc_hd__a22o_1
XFILLER_117_105 VGND VGND VPWR VPWR sky130_fd_sc_hd__decap_6
X_5450_ reg_file_inst.registry\[5\]\[26\] _2747_ _2999_ VGND VGND VPWR VPWR _0613_
+ sky130_fd_sc_hd__mux2_1
XFILLER_8_273 VGND VGND VPWR VPWR sky130_fd_sc_hd__fill_1
XFILLER_8_251 VGND VGND VPWR VPWR sky130_fd_sc_hd__fill_1
XFILLER_117_149 VPWR VGND VPWR VGND sky130_ef_sc_hd__decap_12
XFILLER_67_3 VPWR VGND VPWR VGND sky130_ef_sc_hd__decap_12
X_4401_ net30 net43 _2125_ _2251_ VGND VGND VPWR VPWR _2289_ sky130_fd_sc_hd__or4_4
X_5381_ MEMOFF\[8\] _2986_ _2996_ VGND VGND VPWR VPWR _0679_ sky130_fd_sc_hd__mux2_1
XFILLER_5_73 VPWR VGND VPWR VGND sky130_ef_sc_hd__decap_12
XFILLER_5_51 VGND VGND VPWR VPWR sky130_fd_sc_hd__decap_4
X_4332_ net132 _2219_ VGND VGND VPWR VPWR _2220_ sky130_fd_sc_hd__nor2_1
XTAP_TAPCELL_ROW_74_1188 VGND VPWR sky130_fd_sc_hd__tapvpwrvgnd_1
X_4263_ _1765_ _2150_ VGND VGND VPWR VPWR _2151_ sky130_fd_sc_hd__xnor2_1
XFILLER_101_517 VPWR VGND VPWR VGND sky130_ef_sc_hd__decap_12
X_3214_ reg_file_inst.registry\[9\]\[26\] _1089_ _1091_ reg_file_inst.registry\[3\]\[26\]
+ VGND VGND VPWR VPWR _1157_ sky130_fd_sc_hd__a22o_1
X_6002_ net149 VGND VGND VPWR VPWR _0410_ sky130_fd_sc_hd__inv_2
X_4194_ _2094_ net105 net130 VGND VGND VPWR VPWR _0934_ sky130_fd_sc_hd__mux2_1
X_3145_ _1078_ _1088_ VGND VGND VPWR VPWR _1089_ sky130_fd_sc_hd__and2_4
XFILLER_55_615 VGND VGND VPWR VPWR sky130_fd_sc_hd__fill_1
XFILLER_27_317 VGND VGND VPWR VPWR sky130_fd_sc_hd__decap_4
XFILLER_54_136 VGND VGND VPWR VPWR sky130_fd_sc_hd__decap_4
XFILLER_54_125 VGND VGND VPWR VPWR sky130_fd_sc_hd__decap_4
X_3076_ _1001_ _1019_ VGND VGND VPWR VPWR _1020_ sky130_fd_sc_hd__nand2b_1
XFILLER_42_309 VGND VGND VPWR VPWR sky130_fd_sc_hd__decap_4
XFILLER_35_361 VPWR VGND VPWR VGND sky130_ef_sc_hd__decap_12
X_3978_ net131 _1888_ VGND VGND VPWR VPWR _1894_ sky130_fd_sc_hd__nand2_1
XFILLER_50_353 VGND VGND VPWR VPWR sky130_fd_sc_hd__decap_8
XFILLER_10_239 VGND VGND VPWR VPWR sky130_fd_sc_hd__decap_4
X_5717_ net147 VGND VGND VPWR VPWR _0125_ sky130_fd_sc_hd__inv_2
XFILLER_109_617 VPWR VGND VPWR VGND sky130_ef_sc_hd__decap_12
XFILLER_40_26 VGND VGND VPWR VPWR sky130_fd_sc_hd__fill_2
X_5648_ net149 VGND VGND VPWR VPWR _0056_ sky130_fd_sc_hd__inv_2
X_5579_ reg_file_inst.registry\[15\]\[13\] _2922_ _3003_ VGND VGND VPWR VPWR _0488_
+ sky130_fd_sc_hd__mux2_1
XFILLER_104_333 VPWR VGND VPWR VGND sky130_ef_sc_hd__decap_12
XFILLER_46_626 VGND VGND VPWR VPWR sky130_fd_sc_hd__fill_2
XFILLER_73_445 VGND VGND VPWR VPWR sky130_fd_sc_hd__decap_3
XFILLER_73_434 VGND VGND VPWR VPWR sky130_fd_sc_hd__fill_2
XFILLER_58_486 VGND VGND VPWR VPWR sky130_fd_sc_hd__decap_8
XFILLER_18_328 VGND VGND VPWR VPWR sky130_fd_sc_hd__fill_1
XFILLER_45_125 VPWR VGND VPWR VGND sky130_ef_sc_hd__decap_12
XFILLER_45_169 VPWR VGND VPWR VGND sky130_ef_sc_hd__decap_12
XFILLER_121_51 VGND VGND VPWR VPWR sky130_fd_sc_hd__decap_4
XFILLER_54_670 VPWR VGND VPWR VGND sky130_ef_sc_hd__decap_12
XTAP_TAPCELL_ROW_44_816 VGND VPWR sky130_fd_sc_hd__tapvpwrvgnd_1
XFILLER_60_139 VGND VGND VPWR VPWR sky130_fd_sc_hd__fill_1
XFILLER_53_191 VPWR VGND VPWR VGND sky130_ef_sc_hd__decap_12
XFILLER_41_331 VGND VGND VPWR VPWR sky130_fd_sc_hd__decap_4
XFILLER_81_55 VGND VGND VPWR VPWR sky130_fd_sc_hd__fill_1
XFILLER_14_589 VPWR VGND VPWR VGND sky130_ef_sc_hd__decap_12
XTAP_TAPCELL_ROW_24_562 VGND VPWR sky130_fd_sc_hd__tapvpwrvgnd_1
XFILLER_14_82 VGND VGND VPWR VPWR sky130_fd_sc_hd__fill_2
XFILLER_115_609 VGND VGND VPWR VPWR sky130_fd_sc_hd__decap_6
XFILLER_122_141 VPWR VGND VPWR VGND sky130_ef_sc_hd__decap_12
XFILLER_107_193 VPWR VGND VPWR VGND sky130_ef_sc_hd__decap_12
XFILLER_96_504 VGND VGND VPWR VPWR sky130_fd_sc_hd__decap_3
XFILLER_83_209 VPWR VGND VPWR VGND sky130_ef_sc_hd__decap_12
Xinput8 DataMemoryRead[16] VGND VGND VPWR VPWR net8 sky130_fd_sc_hd__clkbuf_2
XFILLER_37_615 VGND VGND VPWR VPWR sky130_fd_sc_hd__fill_1
XFILLER_64_456 VGND VGND VPWR VPWR sky130_fd_sc_hd__decap_8
XFILLER_24_309 VGND VGND VPWR VPWR sky130_fd_sc_hd__decap_6
XFILLER_51_128 VGND VGND VPWR VPWR sky130_fd_sc_hd__decap_3
XFILLER_17_361 VPWR VGND VPWR VGND sky130_ef_sc_hd__decap_12
X_4950_ _1765_ _2684_ VGND VGND VPWR VPWR _2801_ sky130_fd_sc_hd__and2_2
XFILLER_51_139 VPWR VGND VPWR VGND sky130_ef_sc_hd__decap_12
X_4881_ _1817_ _2731_ _2730_ net136 VGND VGND VPWR VPWR _2738_ sky130_fd_sc_hd__o211a_1
X_3901_ reg_file_inst.registry\[4\]\[1\] _1134_ _1135_ reg_file_inst.registry\[6\]\[1\]
+ VGND VGND VPWR VPWR _1819_ sky130_fd_sc_hd__a22o_1
XFILLER_32_342 VGND VGND VPWR VPWR sky130_fd_sc_hd__fill_1
X_3832_ _1751_ VGND VGND VPWR VPWR _1752_ sky130_fd_sc_hd__inv_2
X_5502_ JMPOFF\[3\] _2478_ _3000_ VGND VGND VPWR VPWR _0562_ sky130_fd_sc_hd__mux2_1
XFILLER_20_559 VGND VGND VPWR VPWR sky130_fd_sc_hd__decap_4
X_3763_ reg_file_inst.registry\[11\]\[6\] _1119_ net143 VGND VGND VPWR VPWR _1686_
+ sky130_fd_sc_hd__and3_1
X_6482_ clknet_leaf_12_clk _0890_ _0415_ VGND VGND VPWR VPWR reg_file_inst.registry\[7\]\[15\]
+ sky130_fd_sc_hd__dfrtp_1
X_3694_ _1612_ _1613_ _1614_ _1618_ VGND VGND VPWR VPWR _1619_ sky130_fd_sc_hd__or4_1
XFILLER_118_469 VGND VGND VPWR VPWR sky130_fd_sc_hd__decap_6
XTAP_TAPCELL_ROW_76_1217 VGND VPWR sky130_fd_sc_hd__tapvpwrvgnd_1
X_5433_ _2909_ reg_file_inst.registry\[10\]\[14\] _2998_ VGND VGND VPWR VPWR _0629_
+ sky130_fd_sc_hd__mux2_1
X_5364_ MEMOFF\[25\] _2767_ _2996_ VGND VGND VPWR VPWR _0696_ sky130_fd_sc_hd__mux2_1
XFILLER_10_29 VPWR VGND VPWR VGND sky130_ef_sc_hd__decap_12
X_4315_ _1841_ _2190_ VGND VGND VPWR VPWR _2203_ sky130_fd_sc_hd__and2_4
X_5295_ _2311_ reg_file_inst.registry\[2\]\[7\] _2993_ VGND VGND VPWR VPWR _0762_
+ sky130_fd_sc_hd__mux2_1
XFILLER_101_325 VGND VGND VPWR VPWR sky130_fd_sc_hd__decap_8
XFILLER_19_27 VGND VGND VPWR VPWR sky130_fd_sc_hd__decap_8
X_4246_ _1652_ _2133_ VGND VGND VPWR VPWR _2134_ sky130_fd_sc_hd__xnor2_1
X_4177_ _1987_ _1989_ VGND VGND VPWR VPWR _2082_ sky130_fd_sc_hd__and2_1
X_3128_ _0980_ _1069_ _1071_ VGND VGND VPWR VPWR _1072_ sky130_fd_sc_hd__a21o_1
XFILLER_28_626 VGND VGND VPWR VPWR sky130_fd_sc_hd__decap_3
XTAP_TAPCELL_ROW_87_1357 VGND VPWR sky130_fd_sc_hd__tapvpwrvgnd_1
XTAP_TAPCELL_ROW_87_1346 VGND VPWR sky130_fd_sc_hd__tapvpwrvgnd_1
XFILLER_82_231 VPWR VGND VPWR VGND sky130_ef_sc_hd__decap_12
XFILLER_55_445 VGND VGND VPWR VPWR sky130_fd_sc_hd__decap_3
XFILLER_27_147 VPWR VGND VPWR VGND sky130_ef_sc_hd__decap_12
XFILLER_82_286 VGND VGND VPWR VPWR sky130_fd_sc_hd__decap_6
XFILLER_70_415 VGND VGND VPWR VPWR sky130_fd_sc_hd__decap_4
X_3059_ JMPOFF\[3\] _0966_ net37 VGND VGND VPWR VPWR _1003_ sky130_fd_sc_hd__a21o_1
XFILLER_70_448 VGND VGND VPWR VPWR sky130_fd_sc_hd__fill_1
XFILLER_51_673 VGND VGND VPWR VPWR sky130_fd_sc_hd__decap_6
XFILLER_23_353 VGND VGND VPWR VPWR sky130_fd_sc_hd__fill_1
XFILLER_23_375 VPWR VGND VPWR VGND sky130_ef_sc_hd__decap_12
XTAP_TAPCELL_ROW_21_521 VGND VPWR sky130_fd_sc_hd__tapvpwrvgnd_1
XFILLER_50_183 VPWR VGND VPWR VGND sky130_ef_sc_hd__decap_12
XTAP_TAPCELL_ROW_21_532 VGND VPWR sky130_fd_sc_hd__tapvpwrvgnd_1
XFILLER_109_447 VGND VGND VPWR VPWR sky130_fd_sc_hd__fill_1
XTAP_TAPCELL_ROW_98_1486 VGND VPWR sky130_fd_sc_hd__tapvpwrvgnd_1
XFILLER_3_725 VGND VGND VPWR VPWR sky130_fd_sc_hd__fill_1
XFILLER_105_653 VPWR VGND VPWR VGND sky130_ef_sc_hd__decap_12
XFILLER_120_601 VPWR VGND VPWR VGND sky130_ef_sc_hd__decap_12
XFILLER_105_697 VPWR VGND VPWR VGND sky130_ef_sc_hd__decap_12
XFILLER_120_645 VPWR VGND VPWR VGND sky130_ef_sc_hd__decap_12
XFILLER_78_548 VPWR VGND VPWR VGND sky130_ef_sc_hd__decap_12
XFILLER_58_250 VGND VGND VPWR VPWR sky130_fd_sc_hd__fill_2
XFILLER_58_283 VGND VGND VPWR VPWR sky130_fd_sc_hd__decap_8
XFILLER_58_272 VGND VGND VPWR VPWR sky130_fd_sc_hd__decap_6
XFILLER_58_261 VGND VGND VPWR VPWR sky130_fd_sc_hd__fill_2
XTAP_TAPCELL_ROW_29_621 VGND VPWR sky130_fd_sc_hd__tapvpwrvgnd_1
XTAP_TAPCELL_ROW_29_632 VGND VPWR sky130_fd_sc_hd__tapvpwrvgnd_1
XFILLER_46_445 VGND VGND VPWR VPWR sky130_fd_sc_hd__decap_8
XTAP_TAPCELL_ROW_57_974 VGND VPWR sky130_fd_sc_hd__tapvpwrvgnd_1
XFILLER_18_169 VGND VGND VPWR VPWR sky130_fd_sc_hd__fill_1
XFILLER_27_681 VGND VGND VPWR VPWR sky130_fd_sc_hd__decap_3
XFILLER_33_106 VGND VGND VPWR VPWR sky130_fd_sc_hd__decap_6
XFILLER_14_331 VPWR VGND VPWR VGND sky130_ef_sc_hd__decap_12
XTAP_TAPCELL_ROW_120_1760 VGND VPWR sky130_fd_sc_hd__tapvpwrvgnd_1
XTAP_TAPCELL_ROW_60_1018 VGND VPWR sky130_fd_sc_hd__tapvpwrvgnd_1
XFILLER_14_397 VGND VGND VPWR VPWR sky130_fd_sc_hd__fill_1
XFILLER_10_581 VGND VGND VPWR VPWR sky130_fd_sc_hd__decap_6
XFILLER_115_417 VPWR VGND VPWR VGND sky130_ef_sc_hd__decap_12
XFILLER_51_6 VGND VGND VPWR VPWR sky130_fd_sc_hd__decap_6
XTAP_TAPCELL_ROW_71_1147 VGND VPWR sky130_fd_sc_hd__tapvpwrvgnd_1
X_4100_ _2009_ _2013_ VGND VGND VPWR VPWR _2016_ sky130_fd_sc_hd__nand2b_1
X_5080_ _2630_ _2633_ _2648_ VGND VGND VPWR VPWR _2911_ sky130_fd_sc_hd__a21o_1
XFILLER_110_133 VGND VGND VPWR VPWR sky130_fd_sc_hd__decap_6
XFILLER_56_209 VGND VGND VPWR VPWR sky130_fd_sc_hd__decap_3
XFILLER_2_41 VPWR VGND VPWR VGND sky130_ef_sc_hd__decap_12
X_4031_ net124 _1878_ _1946_ VGND VGND VPWR VPWR _1947_ sky130_fd_sc_hd__nand3_1
XFILLER_110_177 VPWR VGND VPWR VGND sky130_ef_sc_hd__decap_12
XFILLER_2_85 VGND VGND VPWR VPWR sky130_fd_sc_hd__decap_3
XFILLER_37_423 VGND VGND VPWR VPWR sky130_fd_sc_hd__fill_1
XFILLER_92_540 VGND VGND VPWR VPWR sky130_fd_sc_hd__decap_4
XFILLER_80_713 VGND VGND VPWR VPWR sky130_fd_sc_hd__decap_4
X_5982_ net147 VGND VGND VPWR VPWR _0390_ sky130_fd_sc_hd__inv_2
X_4933_ _2721_ _2771_ _2785_ _2684_ _2782_ VGND VGND VPWR VPWR _2786_ sky130_fd_sc_hd__a221o_1
XFILLER_24_139 VGND VGND VPWR VPWR sky130_fd_sc_hd__fill_1
XFILLER_33_673 VGND VGND VPWR VPWR sky130_fd_sc_hd__decap_8
XTAP_TAPCELL_ROW_82_1287 VGND VPWR sky130_fd_sc_hd__tapvpwrvgnd_1
X_4864_ _2720_ VGND VGND VPWR VPWR _2721_ sky130_fd_sc_hd__clkinv_4
XANTENNA_13 _2995_ VGND VGND VPWR VPWR sky130_fd_sc_hd__diode_2
X_4795_ _1383_ _2558_ VGND VGND VPWR VPWR _2654_ sky130_fd_sc_hd__xnor2_2
XANTENNA_24 net96 VGND VGND VPWR VPWR sky130_fd_sc_hd__diode_2
X_3815_ _1735_ VGND VGND VPWR VPWR _1736_ sky130_fd_sc_hd__inv_2
X_6534_ clknet_leaf_40_clk _0942_ _0467_ VGND VGND VPWR VPWR net114 sky130_fd_sc_hd__dfrtp_1
X_3746_ _1653_ _1667_ VGND VGND VPWR VPWR _1669_ sky130_fd_sc_hd__xnor2_1
XFILLER_118_233 VPWR VGND VPWR VGND sky130_ef_sc_hd__decap_12
X_6465_ clknet_leaf_23_clk _0873_ _0398_ VGND VGND VPWR VPWR reg_file_inst.registry\[0\]\[26\]
+ sky130_fd_sc_hd__dfrtp_1
XFILLER_9_390 VGND VGND VPWR VPWR sky130_fd_sc_hd__fill_2
XFILLER_118_277 VPWR VGND VPWR VGND sky130_ef_sc_hd__decap_12
X_3677_ reg_file_inst.registry\[8\]\[8\] _1074_ _1088_ _1093_ reg_file_inst.registry\[15\]\[8\]
+ VGND VGND VPWR VPWR _1602_ sky130_fd_sc_hd__a32o_1
X_5416_ reg_file_inst.registry\[4\]\[2\] _2501_ _2997_ VGND VGND VPWR VPWR _0645_
+ sky130_fd_sc_hd__mux2_1
X_6396_ clknet_leaf_37_clk _0804_ _0329_ VGND VGND VPWR VPWR reg_file_inst.registry\[14\]\[21\]
+ sky130_fd_sc_hd__dfrtp_1
Xoutput120 net120 VGND VGND VPWR VPWR IC[26] sky130_fd_sc_hd__buf_1
XFILLER_102_601 VPWR VGND VPWR VGND sky130_ef_sc_hd__decap_12
X_5347_ _2922_ reg_file_inst.registry\[3\]\[13\] _2995_ VGND VGND VPWR VPWR _0712_
+ sky130_fd_sc_hd__mux2_1
XFILLER_102_645 VPWR VGND VPWR VGND sky130_ef_sc_hd__decap_12
X_5278_ _2787_ reg_file_inst.registry\[2\]\[24\] _2993_ VGND VGND VPWR VPWR _0779_
+ sky130_fd_sc_hd__mux2_1
XTAP_TAPCELL_ROW_7_349 VGND VPWR sky130_fd_sc_hd__tapvpwrvgnd_1
XFILLER_101_155 VPWR VGND VPWR VGND sky130_ef_sc_hd__decap_12
XFILLER_87_356 VGND VGND VPWR VPWR sky130_fd_sc_hd__decap_6
X_4229_ net43 _2115_ _2116_ VGND VGND VPWR VPWR _2117_ sky130_fd_sc_hd__a21o_4
XFILLER_101_177 VGND VGND VPWR VPWR sky130_fd_sc_hd__fill_1
XFILLER_46_36 VGND VGND VPWR VPWR sky130_fd_sc_hd__decap_8
XFILLER_83_573 VGND VGND VPWR VPWR sky130_fd_sc_hd__fill_2
XFILLER_102_53 VPWR VGND VPWR VGND sky130_ef_sc_hd__decap_12
XTAP_TAPCELL_ROW_54_944 VGND VPWR sky130_fd_sc_hd__tapvpwrvgnd_1
XTAP_TAPCELL_ROW_54_933 VGND VPWR sky130_fd_sc_hd__tapvpwrvgnd_1
XFILLER_102_97 VPWR VGND VPWR VGND sky130_ef_sc_hd__decap_12
XFILLER_70_267 VGND VGND VPWR VPWR sky130_fd_sc_hd__decap_4
XFILLER_62_79 VGND VGND VPWR VPWR sky130_fd_sc_hd__decap_4
XTAP_TAPCELL_ROW_34_690 VGND VPWR sky130_fd_sc_hd__tapvpwrvgnd_1
XFILLER_11_389 VGND VGND VPWR VPWR sky130_fd_sc_hd__decap_3
XFILLER_7_316 VPWR VGND VPWR VGND sky130_ef_sc_hd__decap_12
XFILLER_105_461 VPWR VGND VPWR VGND sky130_ef_sc_hd__decap_12
XFILLER_87_54 VGND VGND VPWR VPWR sky130_fd_sc_hd__fill_2
XFILLER_87_87 VPWR VGND VPWR VGND sky130_ef_sc_hd__decap_12
XFILLER_66_507 VGND VGND VPWR VPWR sky130_fd_sc_hd__decap_4
XFILLER_38_209 VPWR VGND VPWR VGND sky130_ef_sc_hd__decap_12
XFILLER_120_475 VGND VGND VPWR VPWR sky130_fd_sc_hd__fill_1
XTAP_TAPCELL_ROW_109_1622 VGND VPWR sky130_fd_sc_hd__tapvpwrvgnd_1
XFILLER_59_581 VGND VGND VPWR VPWR sky130_fd_sc_hd__fill_2
XFILLER_19_423 VGND VGND VPWR VPWR sky130_fd_sc_hd__fill_1
XFILLER_19_489 VGND VGND VPWR VPWR sky130_fd_sc_hd__fill_1
XFILLER_46_253 VGND VGND VPWR VPWR sky130_fd_sc_hd__decap_8
XTAP_TAPCELL_ROW_122_1800 VGND VPWR sky130_fd_sc_hd__tapvpwrvgnd_1
XFILLER_34_459 VGND VGND VPWR VPWR sky130_fd_sc_hd__fill_2
XFILLER_61_278 VGND VGND VPWR VPWR sky130_fd_sc_hd__fill_2
XFILLER_15_673 VGND VGND VPWR VPWR sky130_fd_sc_hd__decap_3
XFILLER_61_289 VPWR VGND VPWR VGND sky130_ef_sc_hd__decap_12
Xinput22 DataMemoryRead[3] VGND VGND VPWR VPWR net22 sky130_fd_sc_hd__buf_1
Xinput11 DataMemoryRead[19] VGND VGND VPWR VPWR net11 sky130_fd_sc_hd__clkbuf_2
X_4580_ _2233_ _2244_ _1790_ VGND VGND VPWR VPWR _2459_ sky130_fd_sc_hd__mux2_1
X_3600_ _1525_ _1527_ VGND VGND VPWR VPWR _1528_ sky130_fd_sc_hd__or2_1
Xinput44 reset VGND VGND VPWR VPWR net44 sky130_fd_sc_hd__buf_12
Xinput33 instr[13] VGND VGND VPWR VPWR net33 sky130_fd_sc_hd__clkbuf_4
X_3531_ reg_file_inst.registry\[4\]\[13\] _1134_ _1139_ reg_file_inst.registry\[5\]\[13\]
+ VGND VGND VPWR VPWR _1462_ sky130_fd_sc_hd__a22o_1
XFILLER_115_225 VPWR VGND VPWR VGND sky130_ef_sc_hd__decap_12
X_6250_ clknet_leaf_13_clk _0658_ _0183_ VGND VGND VPWR VPWR reg_file_inst.registry\[4\]\[15\]
+ sky130_fd_sc_hd__dfrtp_1
X_3462_ reg_file_inst.registry\[11\]\[17\] _1096_ _1097_ reg_file_inst.registry\[5\]\[17\]
+ _1394_ VGND VGND VPWR VPWR _1395_ sky130_fd_sc_hd__a221o_1
X_3393_ reg_file_inst.registry\[6\]\[19\] _1094_ _1096_ reg_file_inst.registry\[11\]\[19\]
+ VGND VGND VPWR VPWR _1329_ sky130_fd_sc_hd__a22o_1
X_5201_ _2455_ reg_file_inst.registry\[0\]\[4\] _2988_ VGND VGND VPWR VPWR _0851_
+ sky130_fd_sc_hd__mux2_1
X_6181_ clknet_leaf_0_clk _0589_ _0114_ VGND VGND VPWR VPWR reg_file_inst.registry\[5\]\[2\]
+ sky130_fd_sc_hd__dfrtp_1
X_5132_ _2277_ _2746_ _2956_ VGND VGND VPWR VPWR _2957_ sky130_fd_sc_hd__a21o_1
XFILLER_97_665 VGND VGND VPWR VPWR sky130_fd_sc_hd__decap_6
XFILLER_69_356 VPWR VGND VPWR VGND sky130_ef_sc_hd__decap_12
XTAP_TAPCELL_ROW_4_319 VGND VPWR sky130_fd_sc_hd__tapvpwrvgnd_1
XTAP_TAPCELL_ROW_4_308 VGND VPWR sky130_fd_sc_hd__tapvpwrvgnd_1
XFILLER_29_209 VGND VGND VPWR VPWR sky130_fd_sc_hd__fill_1
XFILLER_111_497 VGND VGND VPWR VPWR sky130_fd_sc_hd__decap_6
XFILLER_96_197 VGND VGND VPWR VPWR sky130_fd_sc_hd__fill_1
X_5063_ net7 net101 net51 _2308_ VGND VGND VPWR VPWR _2897_ sky130_fd_sc_hd__a22o_4
X_4014_ _1878_ _1928_ net128 VGND VGND VPWR VPWR _1930_ sky130_fd_sc_hd__a21o_1
XTAP_TAPCELL_ROW_84_1316 VGND VPWR sky130_fd_sc_hd__tapvpwrvgnd_1
XFILLER_25_415 VGND VGND VPWR VPWR sky130_fd_sc_hd__fill_1
XTAP_TAPCELL_ROW_51_903 VGND VPWR sky130_fd_sc_hd__tapvpwrvgnd_1
XFILLER_25_459 VPWR VGND VPWR VGND sky130_ef_sc_hd__decap_12
X_5965_ net149 VGND VGND VPWR VPWR _0373_ sky130_fd_sc_hd__inv_2
X_5896_ net149 VGND VGND VPWR VPWR _0304_ sky130_fd_sc_hd__inv_2
XFILLER_80_587 VGND VGND VPWR VPWR sky130_fd_sc_hd__fill_1
X_4916_ _1765_ _2545_ _2236_ VGND VGND VPWR VPWR _2769_ sky130_fd_sc_hd__a21o_1
X_4847_ _2704_ _2705_ net133 VGND VGND VPWR VPWR _2706_ sky130_fd_sc_hd__mux2_1
XFILLER_20_120 VPWR VGND VPWR VGND sky130_ef_sc_hd__decap_12
XFILLER_21_654 VPWR VGND VPWR VGND sky130_ef_sc_hd__decap_12
XFILLER_119_553 VGND VGND VPWR VPWR sky130_fd_sc_hd__decap_6
X_4778_ _2636_ VGND VGND VPWR VPWR _2637_ sky130_fd_sc_hd__inv_2
XFILLER_119_597 VPWR VGND VPWR VGND sky130_ef_sc_hd__decap_12
X_6517_ clknet_leaf_53_clk _0925_ _0450_ VGND VGND VPWR VPWR net123 sky130_fd_sc_hd__dfrtp_1
X_3729_ _1652_ VGND VGND VPWR VPWR _1653_ sky130_fd_sc_hd__inv_2
XTAP_TAPCELL_ROW_95_1456 VGND VPWR sky130_fd_sc_hd__tapvpwrvgnd_1
X_6448_ clknet_leaf_4_clk _0856_ _0381_ VGND VGND VPWR VPWR reg_file_inst.registry\[0\]\[9\]
+ sky130_fd_sc_hd__dfrtp_1
XFILLER_121_217 VGND VGND VPWR VPWR sky130_fd_sc_hd__decap_6
XFILLER_0_503 VGND VGND VPWR VPWR sky130_fd_sc_hd__fill_1
X_6379_ clknet_leaf_54_clk _0787_ _0312_ VGND VGND VPWR VPWR reg_file_inst.registry\[14\]\[4\]
+ sky130_fd_sc_hd__dfrtp_1
XFILLER_0_514 VGND VGND VPWR VPWR sky130_fd_sc_hd__fill_1
XFILLER_102_453 VPWR VGND VPWR VGND sky130_ef_sc_hd__decap_12
XFILLER_0_558 VGND VGND VPWR VPWR sky130_fd_sc_hd__fill_2
XFILLER_48_507 VGND VGND VPWR VPWR sky130_fd_sc_hd__fill_1
XFILLER_102_497 VGND VGND VPWR VPWR sky130_fd_sc_hd__decap_6
XFILLER_75_337 VGND VGND VPWR VPWR sky130_fd_sc_hd__fill_2
XFILLER_57_57 VPWR VGND VPWR VGND sky130_ef_sc_hd__decap_12
XFILLER_75_348 VGND VGND VPWR VPWR sky130_fd_sc_hd__decap_8
XFILLER_90_318 VPWR VGND VPWR VGND sky130_ef_sc_hd__decap_12
XFILLER_28_253 VGND VGND VPWR VPWR sky130_fd_sc_hd__decap_4
XFILLER_44_713 VPWR VGND VPWR VGND sky130_ef_sc_hd__decap_12
XFILLER_71_532 VGND VGND VPWR VPWR sky130_fd_sc_hd__fill_1
XFILLER_28_297 VGND VGND VPWR VPWR sky130_fd_sc_hd__fill_1
XFILLER_43_223 VGND VGND VPWR VPWR sky130_fd_sc_hd__fill_1
XTAP_TAPCELL_ROW_104_1563 VGND VPWR sky130_fd_sc_hd__tapvpwrvgnd_1
XFILLER_8_625 VPWR VGND VPWR VGND sky130_ef_sc_hd__decap_12
XFILLER_7_113 VPWR VGND VPWR VGND sky130_ef_sc_hd__decap_12
XFILLER_8_669 VPWR VGND VPWR VGND sky130_ef_sc_hd__decap_12
XFILLER_22_82 VGND VGND VPWR VPWR sky130_fd_sc_hd__fill_2
XFILLER_98_53 VGND VGND VPWR VPWR sky130_fd_sc_hd__decap_8
XFILLER_3_352 VPWR VGND VPWR VGND sky130_ef_sc_hd__decap_12
XFILLER_98_97 VPWR VGND VPWR VGND sky130_ef_sc_hd__decap_12
XFILLER_78_153 VPWR VGND VPWR VGND sky130_ef_sc_hd__decap_12
XFILLER_94_657 VPWR VGND VPWR VGND sky130_ef_sc_hd__decap_12
XFILLER_93_167 VGND VGND VPWR VPWR sky130_fd_sc_hd__fill_1
XFILLER_34_245 VGND VGND VPWR VPWR sky130_fd_sc_hd__fill_1
XFILLER_34_267 VGND VGND VPWR VPWR sky130_fd_sc_hd__decap_8
XFILLER_97_3 VPWR VGND VPWR VGND sky130_ef_sc_hd__decap_12
X_5750_ net147 VGND VGND VPWR VPWR _0158_ sky130_fd_sc_hd__inv_2
XFILLER_62_587 VGND VGND VPWR VPWR sky130_fd_sc_hd__fill_1
XFILLER_15_481 VGND VGND VPWR VPWR sky130_fd_sc_hd__fill_1
XTAP_TAPCELL_ROW_17_476 VGND VPWR sky130_fd_sc_hd__tapvpwrvgnd_1
X_4701_ _2183_ _2185_ _2186_ _2555_ VGND VGND VPWR VPWR _2560_ sky130_fd_sc_hd__and4b_1
X_5681_ net146 VGND VGND VPWR VPWR _0089_ sky130_fd_sc_hd__inv_2
XPHY_EDGE_ROW_7_Left_130 VGND VGND VPWR VPWR sky130_fd_sc_hd__decap_3
X_4632_ _1826_ _2282_ VGND VGND VPWR VPWR _2507_ sky130_fd_sc_hd__nor2_1
XFILLER_116_501 VPWR VGND VPWR VGND sky130_ef_sc_hd__decap_12
X_4563_ _1764_ _2278_ _2442_ _2439_ VGND VGND VPWR VPWR _2444_ sky130_fd_sc_hd__o31a_1
XFILLER_116_545 VPWR VGND VPWR VGND sky130_ef_sc_hd__decap_12
X_3514_ _1439_ _1441_ _1445_ _1435_ VGND VGND VPWR VPWR net76 sky130_fd_sc_hd__o31a_1
X_6302_ clknet_leaf_61_clk _0710_ _0235_ VGND VGND VPWR VPWR reg_file_inst.registry\[3\]\[11\]
+ sky130_fd_sc_hd__dfrtp_1
X_4494_ _2226_ _2376_ net133 VGND VGND VPWR VPWR _2377_ sky130_fd_sc_hd__mux2_1
XFILLER_116_589 VPWR VGND VPWR VGND sky130_ef_sc_hd__decap_12
X_6233_ clknet_leaf_21_clk _0641_ _0166_ VGND VGND VPWR VPWR reg_file_inst.registry\[10\]\[26\]
+ sky130_fd_sc_hd__dfrtp_1
X_3445_ reg_file_inst.registry\[1\]\[16\] _1087_ _1091_ reg_file_inst.registry\[3\]\[16\]
+ VGND VGND VPWR VPWR _1379_ sky130_fd_sc_hd__a22o_1
XFILLER_97_440 VGND VGND VPWR VPWR sky130_fd_sc_hd__decap_8
X_3376_ reg_file_inst.registry\[6\]\[20\] _1123_ _1132_ VGND VGND VPWR VPWR _1313_
+ sky130_fd_sc_hd__and3_1
X_6164_ clknet_leaf_2_clk _0572_ _0097_ VGND VGND VPWR VPWR JMPOFF\[13\] sky130_fd_sc_hd__dfrtp_4
XFILLER_111_261 VPWR VGND VPWR VGND sky130_ef_sc_hd__decap_12
XTAP_TAPCELL_ROW_90_1386 VGND VPWR sky130_fd_sc_hd__tapvpwrvgnd_1
X_5115_ _1541_ _2283_ _2939_ _2941_ VGND VGND VPWR VPWR _2942_ sky130_fd_sc_hd__a211o_1
X_6095_ clknet_leaf_46_clk _0503_ _0028_ VGND VGND VPWR VPWR reg_file_inst.registry\[9\]\[0\]
+ sky130_fd_sc_hd__dfrtp_1
X_5046_ _2177_ _2656_ _2874_ _2882_ VGND VGND VPWR VPWR net52 sky130_fd_sc_hd__o31ai_2
XFILLER_26_713 VGND VGND VPWR VPWR sky130_fd_sc_hd__decap_6
XFILLER_53_532 VGND VGND VPWR VPWR sky130_fd_sc_hd__fill_1
XFILLER_25_212 VGND VGND VPWR VPWR sky130_fd_sc_hd__decap_8
XFILLER_25_245 VPWR VGND VPWR VGND sky130_ef_sc_hd__decap_12
XFILLER_25_267 VGND VGND VPWR VPWR sky130_fd_sc_hd__fill_1
XFILLER_80_362 VGND VGND VPWR VPWR sky130_fd_sc_hd__fill_2
X_5948_ net146 VGND VGND VPWR VPWR _0356_ sky130_fd_sc_hd__inv_2
XFILLER_43_15 VGND VGND VPWR VPWR sky130_fd_sc_hd__decap_8
X_5879_ net146 VGND VGND VPWR VPWR _0287_ sky130_fd_sc_hd__inv_2
XFILLER_119_361 VPWR VGND VPWR VGND sky130_ef_sc_hd__decap_12
XFILLER_5_617 VPWR VGND VPWR VGND sky130_ef_sc_hd__decap_12
XFILLER_4_149 VGND VGND VPWR VPWR sky130_fd_sc_hd__fill_2
XFILLER_108_41 VPWR VGND VPWR VGND sky130_ef_sc_hd__decap_12
XFILLER_108_85 VPWR VGND VPWR VGND sky130_ef_sc_hd__decap_12
XFILLER_102_250 VGND VGND VPWR VPWR sky130_fd_sc_hd__fill_2
XFILLER_0_377 VGND VGND VPWR VPWR sky130_fd_sc_hd__decap_8
XFILLER_0_388 VGND VGND VPWR VPWR sky130_fd_sc_hd__decap_4
XFILLER_91_605 VGND VGND VPWR VPWR sky130_fd_sc_hd__decap_8
XFILLER_90_137 VGND VGND VPWR VPWR sky130_fd_sc_hd__decap_3
XFILLER_16_201 VGND VGND VPWR VPWR sky130_fd_sc_hd__fill_1
XFILLER_90_148 VGND VGND VPWR VPWR sky130_fd_sc_hd__decap_4
XFILLER_71_373 VPWR VGND VPWR VGND sky130_ef_sc_hd__decap_12
XFILLER_31_204 VGND VGND VPWR VPWR sky130_fd_sc_hd__decap_8
XTAP_TAPCELL_ROW_14_435 VGND VPWR sky130_fd_sc_hd__tapvpwrvgnd_1
XFILLER_31_237 VPWR VGND VPWR VGND sky130_ef_sc_hd__decap_12
XTAP_TAPCELL_ROW_42_788 VGND VPWR sky130_fd_sc_hd__tapvpwrvgnd_1
XFILLER_33_81 VGND VGND VPWR VPWR sky130_fd_sc_hd__decap_8
XTAP_TAPCELL_ROW_117_1732 VGND VPWR sky130_fd_sc_hd__tapvpwrvgnd_1
XTAP_TAPCELL_ROW_117_1721 VGND VPWR sky130_fd_sc_hd__tapvpwrvgnd_1
XFILLER_8_477 VGND VGND VPWR VPWR sky130_fd_sc_hd__decap_8
XFILLER_113_559 VGND VGND VPWR VPWR sky130_fd_sc_hd__fill_1
X_3230_ _1171_ VGND VGND VPWR VPWR _1172_ sky130_fd_sc_hd__inv_2
XFILLER_94_410 VGND VGND VPWR VPWR sky130_fd_sc_hd__decap_8
X_3161_ reg_file_inst.registry\[7\]\[27\] _1086_ _1098_ reg_file_inst.registry\[10\]\[27\]
+ VGND VGND VPWR VPWR _1105_ sky130_fd_sc_hd__a22o_1
XFILLER_94_421 VGND VGND VPWR VPWR sky130_fd_sc_hd__decap_3
XFILLER_67_657 VPWR VGND VPWR VGND sky130_ef_sc_hd__decap_12
XFILLER_39_337 VGND VGND VPWR VPWR sky130_fd_sc_hd__decap_8
XFILLER_94_465 VGND VGND VPWR VPWR sky130_fd_sc_hd__decap_8
XTAP_TAPCELL_ROW_68_1119 VGND VPWR sky130_fd_sc_hd__tapvpwrvgnd_1
XTAP_TAPCELL_ROW_68_1108 VGND VPWR sky130_fd_sc_hd__tapvpwrvgnd_1
XFILLER_66_167 VGND VGND VPWR VPWR sky130_fd_sc_hd__decap_6
XFILLER_54_307 VGND VGND VPWR VPWR sky130_fd_sc_hd__fill_1
X_3092_ _1034_ _1035_ VGND VGND VPWR VPWR _1036_ sky130_fd_sc_hd__nand2_1
XFILLER_94_498 VGND VGND VPWR VPWR sky130_fd_sc_hd__decap_6
XFILLER_54_329 VGND VGND VPWR VPWR sky130_fd_sc_hd__fill_2
XFILLER_35_532 VGND VGND VPWR VPWR sky130_fd_sc_hd__fill_2
XFILLER_90_693 VGND VGND VPWR VPWR sky130_fd_sc_hd__decap_6
XFILLER_62_362 VGND VGND VPWR VPWR sky130_fd_sc_hd__fill_2
X_5802_ net147 VGND VGND VPWR VPWR _0210_ sky130_fd_sc_hd__inv_2
X_3994_ _1893_ _1897_ _1903_ _1908_ VGND VGND VPWR VPWR _1910_ sky130_fd_sc_hd__or4_1
X_5733_ net149 VGND VGND VPWR VPWR _0141_ sky130_fd_sc_hd__inv_2
X_5664_ net44 VGND VGND VPWR VPWR _0072_ sky130_fd_sc_hd__inv_2
XFILLER_30_281 VPWR VGND VPWR VGND sky130_ef_sc_hd__decap_12
XFILLER_108_309 VPWR VGND VPWR VGND sky130_ef_sc_hd__decap_12
XTAP_TAPCELL_ROW_79_1248 VGND VPWR sky130_fd_sc_hd__tapvpwrvgnd_1
X_4615_ _1803_ _2286_ _2491_ _1790_ VGND VGND VPWR VPWR _2492_ sky130_fd_sc_hd__a22o_1
X_5595_ net149 VGND VGND VPWR VPWR _0003_ sky130_fd_sc_hd__inv_2
X_4546_ _2424_ _2426_ net137 VGND VGND VPWR VPWR _2427_ sky130_fd_sc_hd__mux2_1
XTAP_TAPCELL_ROW_92_1415 VGND VPWR sky130_fd_sc_hd__tapvpwrvgnd_1
X_4477_ _1790_ _2360_ VGND VGND VPWR VPWR _2362_ sky130_fd_sc_hd__nor2_1
X_3428_ JMPOFF\[18\] _1130_ _1136_ reg_file_inst.registry\[8\]\[18\] _1117_ VGND VGND
+ VPWR VPWR _1363_ sky130_fd_sc_hd__a221o_1
X_6216_ clknet_leaf_6_clk _0624_ _0149_ VGND VGND VPWR VPWR reg_file_inst.registry\[10\]\[9\]
+ sky130_fd_sc_hd__dfrtp_1
X_6147_ clknet_leaf_32_clk _0555_ _0080_ VGND VGND VPWR VPWR reg_file_inst.registry\[6\]\[24\]
+ sky130_fd_sc_hd__dfrtp_1
X_3359_ _1281_ _1294_ VGND VGND VPWR VPWR _1296_ sky130_fd_sc_hd__xnor2_1
XFILLER_38_15 VGND VGND VPWR VPWR sky130_fd_sc_hd__fill_2
XFILLER_112_581 VGND VGND VPWR VPWR sky130_fd_sc_hd__decap_6
XFILLER_97_281 VPWR VGND VPWR VGND sky130_ef_sc_hd__decap_12
XFILLER_85_421 VGND VGND VPWR VPWR sky130_fd_sc_hd__decap_6
X_6078_ clknet_leaf_62_clk _0486_ _0011_ VGND VGND VPWR VPWR reg_file_inst.registry\[15\]\[11\]
+ sky130_fd_sc_hd__dfrtp_1
XFILLER_85_498 VGND VGND VPWR VPWR sky130_fd_sc_hd__decap_6
XFILLER_26_510 VPWR VGND VPWR VGND sky130_ef_sc_hd__decap_12
X_5029_ _1417_ _2282_ _2285_ _1418_ _2867_ VGND VGND VPWR VPWR _2868_ sky130_fd_sc_hd__o221ai_4
XFILLER_81_671 VGND VGND VPWR VPWR sky130_fd_sc_hd__fill_1
XFILLER_80_170 VGND VGND VPWR VPWR sky130_fd_sc_hd__decap_3
XFILLER_26_587 VGND VGND VPWR VPWR sky130_fd_sc_hd__fill_1
XFILLER_41_502 VGND VGND VPWR VPWR sky130_fd_sc_hd__fill_2
XFILLER_110_53 VPWR VGND VPWR VGND sky130_ef_sc_hd__decap_12
XTAP_TAPCELL_ROW_101_1522 VGND VPWR sky130_fd_sc_hd__tapvpwrvgnd_1
XTAP_TAPCELL_ROW_11_405 VGND VPWR sky130_fd_sc_hd__tapvpwrvgnd_1
XFILLER_110_97 VPWR VGND VPWR VGND sky130_ef_sc_hd__decap_12
XFILLER_70_68 VGND VGND VPWR VPWR sky130_fd_sc_hd__fill_2
XFILLER_21_270 VGND VGND VPWR VPWR sky130_fd_sc_hd__decap_8
XFILLER_119_51 VGND VGND VPWR VPWR sky130_fd_sc_hd__decap_4
XFILLER_5_447 VGND VGND VPWR VPWR sky130_fd_sc_hd__fill_1
XFILLER_79_66 VGND VGND VPWR VPWR sky130_fd_sc_hd__fill_2
XPHY_EDGE_ROW_79_Left_202 VGND VGND VPWR VPWR sky130_fd_sc_hd__decap_3
XTAP_TAPCELL_ROW_112_1662 VGND VPWR sky130_fd_sc_hd__tapvpwrvgnd_1
XFILLER_1_653 VPWR VGND VPWR VGND sky130_ef_sc_hd__decap_12
XFILLER_122_389 VGND VGND VPWR VPWR sky130_fd_sc_hd__decap_3
XFILLER_0_163 VGND VGND VPWR VPWR sky130_fd_sc_hd__fill_1
XFILLER_49_602 VPWR VGND VPWR VGND sky130_ef_sc_hd__decap_12
XFILLER_1_697 VPWR VGND VPWR VGND sky130_ef_sc_hd__decap_12
XFILLER_48_112 VPWR VGND VPWR VGND sky130_ef_sc_hd__decap_12
XFILLER_64_605 VGND VGND VPWR VPWR sky130_fd_sc_hd__fill_1
XTAP_TAPCELL_ROW_19_505 VGND VPWR sky130_fd_sc_hd__tapvpwrvgnd_1
XFILLER_49_668 VGND VGND VPWR VPWR sky130_fd_sc_hd__decap_4
XFILLER_64_638 VGND VGND VPWR VPWR sky130_fd_sc_hd__decap_6
XFILLER_63_137 VPWR VGND VPWR VGND sky130_ef_sc_hd__decap_12
XFILLER_29_381 VGND VGND VPWR VPWR sky130_fd_sc_hd__decap_8
XTAP_TAPCELL_ROW_47_847 VGND VPWR sky130_fd_sc_hd__tapvpwrvgnd_1
XFILLER_91_468 VPWR VGND VPWR VGND sky130_ef_sc_hd__decap_12
XFILLER_91_457 VGND VGND VPWR VPWR sky130_fd_sc_hd__fill_2
XPHY_EDGE_ROW_88_Left_211 VGND VGND VPWR VPWR sky130_fd_sc_hd__decap_3
XFILLER_17_554 VGND VGND VPWR VPWR sky130_fd_sc_hd__decap_6
XFILLER_17_598 VGND VGND VPWR VPWR sky130_fd_sc_hd__fill_1
XFILLER_71_181 VGND VGND VPWR VPWR sky130_fd_sc_hd__decap_8
XTAP_TAPCELL_ROW_63_1049 VGND VPWR sky130_fd_sc_hd__tapvpwrvgnd_1
XFILLER_44_395 VPWR VGND VPWR VGND sky130_ef_sc_hd__decap_12
X_4400_ _0960_ _2127_ _2252_ _2281_ VGND VGND VPWR VPWR _2288_ sky130_fd_sc_hd__and4_4
XPHY_EDGE_ROW_97_Left_220 VGND VGND VPWR VPWR sky130_fd_sc_hd__decap_3
X_5380_ MEMOFF\[9\] _2974_ _2996_ VGND VGND VPWR VPWR _0680_ sky130_fd_sc_hd__mux2_1
XFILLER_99_546 VPWR VGND VPWR VGND sky130_ef_sc_hd__decap_12
XFILLER_99_535 VGND VGND VPWR VPWR sky130_fd_sc_hd__fill_2
XFILLER_99_513 VGND VGND VPWR VPWR sky130_fd_sc_hd__fill_2
X_4331_ _1566_ _2190_ VGND VGND VPWR VPWR _2219_ sky130_fd_sc_hd__and2b_1
XTAP_TAPCELL_ROW_74_1189 VGND VPWR sky130_fd_sc_hd__tapvpwrvgnd_1
X_4262_ _2127_ _2130_ VGND VGND VPWR VPWR _2150_ sky130_fd_sc_hd__nand2_1
XFILLER_101_529 VPWR VGND VPWR VGND sky130_ef_sc_hd__decap_12
X_3213_ reg_file_inst.registry\[8\]\[26\] _1090_ _1155_ _1075_ VGND VGND VPWR VPWR
+ _1156_ sky130_fd_sc_hd__a211o_1
X_6001_ net148 VGND VGND VPWR VPWR _0409_ sky130_fd_sc_hd__inv_2
XFILLER_67_421 VGND VGND VPWR VPWR sky130_fd_sc_hd__fill_1
X_4193_ _1916_ _2093_ VGND VGND VPWR VPWR _2094_ sky130_fd_sc_hd__xnor2_1
X_3144_ net34 net40 net41 VGND VGND VPWR VPWR _1088_ sky130_fd_sc_hd__nor3b_4
XFILLER_94_273 VGND VGND VPWR VPWR sky130_fd_sc_hd__fill_1
X_3075_ JMPOFF\[4\] _0966_ net38 VGND VGND VPWR VPWR _1019_ sky130_fd_sc_hd__a21o_1
XFILLER_48_690 VGND VGND VPWR VPWR sky130_fd_sc_hd__fill_1
XFILLER_63_671 VGND VGND VPWR VPWR sky130_fd_sc_hd__fill_1
XFILLER_23_502 VGND VGND VPWR VPWR sky130_fd_sc_hd__fill_2
XFILLER_35_373 VPWR VGND VPWR VGND sky130_ef_sc_hd__decap_12
XFILLER_63_693 VPWR VGND VPWR VGND sky130_ef_sc_hd__decap_12
XFILLER_11_719 VGND VGND VPWR VPWR sky130_fd_sc_hd__decap_6
X_3977_ _1891_ _1892_ VGND VGND VPWR VPWR _1893_ sky130_fd_sc_hd__nand2_1
XFILLER_50_365 VPWR VGND VPWR VGND sky130_ef_sc_hd__decap_12
X_5716_ net148 VGND VGND VPWR VPWR _0124_ sky130_fd_sc_hd__inv_2
XFILLER_109_629 VPWR VGND VPWR VGND sky130_ef_sc_hd__decap_12
XFILLER_108_139 VGND VGND VPWR VPWR sky130_fd_sc_hd__fill_1
X_5647_ net44 VGND VGND VPWR VPWR _0055_ sky130_fd_sc_hd__inv_2
XFILLER_40_38 VPWR VGND VPWR VGND sky130_ef_sc_hd__decap_12
X_5578_ reg_file_inst.registry\[15\]\[14\] _2909_ _3003_ VGND VGND VPWR VPWR _0489_
+ sky130_fd_sc_hd__mux2_1
XFILLER_117_673 VPWR VGND VPWR VGND sky130_ef_sc_hd__decap_12
XFILLER_104_301 VGND VGND VPWR VPWR sky130_fd_sc_hd__decap_6
X_4529_ _1753_ _2287_ _2408_ _2411_ VGND VGND VPWR VPWR _2412_ sky130_fd_sc_hd__o211a_1
XFILLER_104_345 VGND VGND VPWR VPWR sky130_fd_sc_hd__decap_3
XFILLER_49_14 VGND VGND VPWR VPWR sky130_fd_sc_hd__decap_6
XFILLER_73_402 VPWR VGND VPWR VGND sky130_ef_sc_hd__decap_12
XFILLER_18_307 VGND VGND VPWR VPWR sky130_fd_sc_hd__fill_1
XFILLER_65_57 VGND VGND VPWR VPWR sky130_fd_sc_hd__decap_4
XFILLER_46_638 VGND VGND VPWR VPWR sky130_fd_sc_hd__decap_6
XFILLER_65_79 VGND VGND VPWR VPWR sky130_fd_sc_hd__fill_1
XFILLER_45_137 VPWR VGND VPWR VGND sky130_ef_sc_hd__decap_12
XFILLER_54_682 VPWR VGND VPWR VGND sky130_ef_sc_hd__decap_12
XFILLER_54_660 VGND VGND VPWR VPWR sky130_fd_sc_hd__decap_3
XTAP_TAPCELL_ROW_44_817 VGND VPWR sky130_fd_sc_hd__tapvpwrvgnd_1
XFILLER_53_181 VGND VGND VPWR VPWR sky130_fd_sc_hd__fill_2
XTAP_TAPCELL_ROW_24_563 VGND VPWR sky130_fd_sc_hd__tapvpwrvgnd_1
XFILLER_81_89 VGND VGND VPWR VPWR sky130_fd_sc_hd__fill_1
XFILLER_6_701 VPWR VGND VPWR VGND sky130_ef_sc_hd__decap_12
XFILLER_114_109 VPWR VGND VPWR VGND sky130_ef_sc_hd__decap_12
XFILLER_107_161 VGND VGND VPWR VPWR sky130_fd_sc_hd__decap_6
XFILLER_5_277 VGND VGND VPWR VPWR sky130_fd_sc_hd__decap_3
XFILLER_30_71 VPWR VGND VPWR VGND sky130_ef_sc_hd__decap_12
XFILLER_122_153 VPWR VGND VPWR VGND sky130_ef_sc_hd__decap_12
XFILLER_96_516 VPWR VGND VPWR VGND sky130_ef_sc_hd__decap_12
XFILLER_122_197 VPWR VGND VPWR VGND sky130_ef_sc_hd__decap_12
XFILLER_49_421 VPWR VGND VPWR VGND sky130_ef_sc_hd__decap_12
XFILLER_76_251 VGND VGND VPWR VPWR sky130_fd_sc_hd__fill_1
XFILLER_49_476 VGND VGND VPWR VPWR sky130_fd_sc_hd__decap_4
Xinput9 DataMemoryRead[17] VGND VGND VPWR VPWR net9 sky130_fd_sc_hd__clkbuf_2
XFILLER_17_373 VGND VGND VPWR VPWR sky130_fd_sc_hd__decap_4
XFILLER_45_671 VGND VGND VPWR VPWR sky130_fd_sc_hd__fill_1
X_4880_ _1171_ _2282_ _2285_ _1173_ _2736_ VGND VGND VPWR VPWR _2737_ sky130_fd_sc_hd__o221ai_2
X_3900_ reg_file_inst.registry\[14\]\[1\] _1138_ _1140_ reg_file_inst.registry\[3\]\[1\]
+ VGND VGND VPWR VPWR _1818_ sky130_fd_sc_hd__a22o_1
XFILLER_44_192 VGND VGND VPWR VPWR sky130_fd_sc_hd__decap_4
XFILLER_60_663 VPWR VGND VPWR VGND sky130_ef_sc_hd__decap_12
XFILLER_32_365 VPWR VGND VPWR VGND sky130_ef_sc_hd__decap_12
X_3831_ MEMOFF\[5\] net96 _1113_ VGND VGND VPWR VPWR _1751_ sky130_fd_sc_hd__mux2_4
X_3762_ reg_file_inst.registry\[9\]\[6\] _1131_ _1133_ reg_file_inst.registry\[7\]\[6\]
+ VGND VGND VPWR VPWR _1685_ sky130_fd_sc_hd__a22o_1
XFILLER_9_561 VPWR VGND VPWR VGND sky130_ef_sc_hd__decap_12
X_5501_ JMPOFF\[4\] _2455_ _3000_ VGND VGND VPWR VPWR _0563_ sky130_fd_sc_hd__mux2_1
X_6481_ clknet_leaf_12_clk _0889_ _0414_ VGND VGND VPWR VPWR reg_file_inst.registry\[7\]\[14\]
+ sky130_fd_sc_hd__dfrtp_1
X_3693_ reg_file_inst.registry\[4\]\[8\] _1134_ _1615_ _1616_ _1617_ VGND VGND VPWR
+ VPWR _1618_ sky130_fd_sc_hd__a2111o_1
X_5432_ _2897_ reg_file_inst.registry\[10\]\[15\] _2998_ VGND VGND VPWR VPWR _0630_
+ sky130_fd_sc_hd__mux2_1
XTAP_TAPCELL_ROW_76_1218 VGND VPWR sky130_fd_sc_hd__tapvpwrvgnd_1
X_5363_ MEMOFF\[26\] _2747_ _2996_ VGND VGND VPWR VPWR _0697_ sky130_fd_sc_hd__mux2_1
XFILLER_114_643 VGND VGND VPWR VPWR sky130_fd_sc_hd__fill_1
XFILLER_99_332 VGND VGND VPWR VPWR sky130_fd_sc_hd__decap_4
X_4314_ _1267_ _2190_ VGND VGND VPWR VPWR _2202_ sky130_fd_sc_hd__and2_1
X_5294_ _2986_ reg_file_inst.registry\[2\]\[8\] _2993_ VGND VGND VPWR VPWR _0763_
+ sky130_fd_sc_hd__mux2_1
XFILLER_101_337 VGND VGND VPWR VPWR sky130_fd_sc_hd__fill_1
X_4245_ _1679_ _2127_ _2132_ VGND VGND VPWR VPWR _2133_ sky130_fd_sc_hd__a21o_1
X_4176_ _2081_ net110 net130 VGND VGND VPWR VPWR _0939_ sky130_fd_sc_hd__mux2_1
XFILLER_82_210 VGND VGND VPWR VPWR sky130_fd_sc_hd__fill_1
X_3127_ _0971_ _1070_ VGND VGND VPWR VPWR _1071_ sky130_fd_sc_hd__nand2_1
XFILLER_55_413 VGND VGND VPWR VPWR sky130_fd_sc_hd__decap_4
XTAP_TAPCELL_ROW_87_1347 VGND VPWR sky130_fd_sc_hd__tapvpwrvgnd_1
XFILLER_82_243 VGND VGND VPWR VPWR sky130_fd_sc_hd__decap_8
XFILLER_82_265 VGND VGND VPWR VPWR sky130_fd_sc_hd__fill_1
XFILLER_55_479 VGND VGND VPWR VPWR sky130_fd_sc_hd__decap_6
X_3058_ JMPOFF\[3\] net37 _0966_ VGND VGND VPWR VPWR _1002_ sky130_fd_sc_hd__and3_1
XFILLER_35_38 VGND VGND VPWR VPWR sky130_fd_sc_hd__decap_8
XFILLER_36_671 VGND VGND VPWR VPWR sky130_fd_sc_hd__decap_8
Xclkbuf_leaf_62_clk clknet_3_0__leaf_clk VGND VGND VPWR VPWR clknet_leaf_62_clk sky130_fd_sc_hd__clkbuf_8
XFILLER_35_181 VPWR VGND VPWR VGND sky130_ef_sc_hd__decap_12
XFILLER_51_696 VGND VGND VPWR VPWR sky130_fd_sc_hd__fill_1
XFILLER_23_387 VGND VGND VPWR VPWR sky130_fd_sc_hd__decap_4
XFILLER_50_173 VGND VGND VPWR VPWR sky130_fd_sc_hd__fill_1
XTAP_TAPCELL_ROW_21_522 VGND VPWR sky130_fd_sc_hd__tapvpwrvgnd_1
XFILLER_50_195 VGND VGND VPWR VPWR sky130_fd_sc_hd__fill_1
XTAP_TAPCELL_ROW_98_1487 VGND VPWR sky130_fd_sc_hd__tapvpwrvgnd_1
XFILLER_120_613 VPWR VGND VPWR VGND sky130_ef_sc_hd__decap_12
XFILLER_116_41 VPWR VGND VPWR VGND sky130_ef_sc_hd__decap_12
XFILLER_105_665 VGND VGND VPWR VPWR sky130_fd_sc_hd__decap_6
XFILLER_116_85 VPWR VGND VPWR VGND sky130_ef_sc_hd__decap_12
XFILLER_104_197 VPWR VGND VPWR VGND sky130_ef_sc_hd__decap_12
XFILLER_76_23 VGND VGND VPWR VPWR sky130_fd_sc_hd__decap_4
XFILLER_120_657 VPWR VGND VPWR VGND sky130_ef_sc_hd__decap_12
XFILLER_46_402 VGND VGND VPWR VPWR sky130_fd_sc_hd__fill_1
XFILLER_73_221 VGND VGND VPWR VPWR sky130_fd_sc_hd__decap_3
XTAP_TAPCELL_ROW_29_622 VGND VPWR sky130_fd_sc_hd__tapvpwrvgnd_1
XTAP_TAPCELL_ROW_57_975 VGND VPWR sky130_fd_sc_hd__tapvpwrvgnd_1
XFILLER_61_449 VPWR VGND VPWR VGND sky130_ef_sc_hd__decap_12
XFILLER_54_490 VPWR VGND VPWR VGND sky130_ef_sc_hd__decap_12
XTAP_TAPCELL_ROW_1_280 VGND VPWR sky130_fd_sc_hd__tapvpwrvgnd_1
Xclkbuf_leaf_53_clk clknet_3_5__leaf_clk VGND VGND VPWR VPWR clknet_leaf_53_clk sky130_fd_sc_hd__clkbuf_8
XFILLER_14_343 VGND VGND VPWR VPWR sky130_fd_sc_hd__decap_4
XFILLER_14_365 VGND VGND VPWR VPWR sky130_fd_sc_hd__decap_8
XTAP_TAPCELL_ROW_120_1761 VGND VPWR sky130_fd_sc_hd__tapvpwrvgnd_1
XTAP_TAPCELL_ROW_60_1019 VGND VPWR sky130_fd_sc_hd__tapvpwrvgnd_1
XTAP_TAPCELL_ROW_60_1008 VGND VPWR sky130_fd_sc_hd__tapvpwrvgnd_1
XFILLER_6_531 VGND VGND VPWR VPWR sky130_fd_sc_hd__fill_1
XFILLER_41_81 VGND VGND VPWR VPWR sky130_fd_sc_hd__decap_8
XFILLER_115_429 VPWR VGND VPWR VGND sky130_ef_sc_hd__decap_12
XFILLER_44_6 VGND VGND VPWR VPWR sky130_fd_sc_hd__decap_4
XFILLER_69_505 VPWR VGND VPWR VGND sky130_ef_sc_hd__decap_12
XTAP_TAPCELL_ROW_71_1148 VGND VPWR sky130_fd_sc_hd__tapvpwrvgnd_1
XTAP_TAPCELL_ROW_9_380 VGND VPWR sky130_fd_sc_hd__tapvpwrvgnd_1
XPHY_EDGE_ROW_10_Right_10 VGND VGND VPWR VPWR sky130_fd_sc_hd__decap_3
XFILLER_2_53 VPWR VGND VPWR VGND sky130_ef_sc_hd__decap_12
X_4030_ _1018_ _1945_ VGND VGND VPWR VPWR _1946_ sky130_fd_sc_hd__nor2_1
XPHY_EDGE_ROW_16_Left_139 VGND VGND VPWR VPWR sky130_fd_sc_hd__decap_3
XFILLER_110_189 VGND VGND VPWR VPWR sky130_fd_sc_hd__decap_6
XFILLER_49_284 VPWR VGND VPWR VGND sky130_ef_sc_hd__decap_12
X_5981_ net147 VGND VGND VPWR VPWR _0389_ sky130_fd_sc_hd__inv_2
XFILLER_25_608 VGND VGND VPWR VPWR sky130_fd_sc_hd__decap_8
Xclkbuf_leaf_44_clk clknet_3_4__leaf_clk VGND VGND VPWR VPWR clknet_leaf_44_clk sky130_fd_sc_hd__clkbuf_8
XFILLER_17_181 VPWR VGND VPWR VGND sky130_ef_sc_hd__decap_12
X_4932_ _2537_ _2784_ net137 VGND VGND VPWR VPWR _2785_ sky130_fd_sc_hd__mux2_1
XTAP_TAPCELL_ROW_82_1288 VGND VPWR sky130_fd_sc_hd__tapvpwrvgnd_1
XFILLER_60_482 VPWR VGND VPWR VGND sky130_ef_sc_hd__decap_12
X_4863_ _1151_ _2128_ _2253_ VGND VGND VPWR VPWR _2720_ sky130_fd_sc_hd__o21ai_4
XANTENNA_14 net45 VGND VGND VPWR VPWR sky130_fd_sc_hd__diode_2
X_3814_ reg_file_inst.registry\[0\]\[5\] net138 _1729_ _1734_ VGND VGND VPWR VPWR
+ _1735_ sky130_fd_sc_hd__o22a_4
X_4794_ _2633_ _2649_ _2652_ VGND VGND VPWR VPWR _2653_ sky130_fd_sc_hd__o21ba_1
XPHY_EDGE_ROW_25_Left_148 VGND VGND VPWR VPWR sky130_fd_sc_hd__decap_3
XANTENNA_25 net97 VGND VGND VPWR VPWR sky130_fd_sc_hd__diode_2
X_6533_ clknet_leaf_48_clk _0941_ _0466_ VGND VGND VPWR VPWR net112 sky130_fd_sc_hd__dfrtp_1
X_3745_ _1652_ _1667_ VGND VGND VPWR VPWR _1668_ sky130_fd_sc_hd__nand2_1
XFILLER_118_245 VGND VGND VPWR VPWR sky130_fd_sc_hd__decap_6
X_6464_ clknet_leaf_31_clk _0872_ _0397_ VGND VGND VPWR VPWR reg_file_inst.registry\[0\]\[25\]
+ sky130_fd_sc_hd__dfrtp_1
XFILLER_118_289 VPWR VGND VPWR VGND sky130_ef_sc_hd__decap_12
X_5415_ reg_file_inst.registry\[4\]\[3\] _2478_ _2997_ VGND VGND VPWR VPWR _0646_
+ sky130_fd_sc_hd__mux2_1
Xoutput110 net110 VGND VGND VPWR VPWR IC[17] sky130_fd_sc_hd__buf_1
X_3676_ reg_file_inst.registry\[1\]\[8\] _1087_ _1098_ reg_file_inst.registry\[10\]\[8\]
+ VGND VGND VPWR VPWR _1601_ sky130_fd_sc_hd__a22o_1
Xoutput121 net121 VGND VGND VPWR VPWR IC[27] sky130_fd_sc_hd__buf_1
X_6395_ clknet_leaf_42_clk _0803_ _0328_ VGND VGND VPWR VPWR reg_file_inst.registry\[14\]\[20\]
+ sky130_fd_sc_hd__dfrtp_1
XFILLER_102_613 VPWR VGND VPWR VGND sky130_ef_sc_hd__decap_12
XFILLER_87_302 VPWR VGND VPWR VGND sky130_ef_sc_hd__decap_12
X_5346_ _2909_ reg_file_inst.registry\[3\]\[14\] _2995_ VGND VGND VPWR VPWR _0713_
+ sky130_fd_sc_hd__mux2_1
X_5277_ _2767_ reg_file_inst.registry\[2\]\[25\] _2993_ VGND VGND VPWR VPWR _0780_
+ sky130_fd_sc_hd__mux2_1
XFILLER_87_335 VGND VGND VPWR VPWR sky130_fd_sc_hd__fill_1
XPHY_EDGE_ROW_34_Left_157 VGND VGND VPWR VPWR sky130_fd_sc_hd__decap_3
XFILLER_102_657 VPWR VGND VPWR VGND sky130_ef_sc_hd__decap_12
X_4228_ _0960_ _1111_ VGND VGND VPWR VPWR _2116_ sky130_fd_sc_hd__and2_1
XFILLER_101_167 VGND VGND VPWR VPWR sky130_fd_sc_hd__fill_1
XFILLER_68_582 VGND VGND VPWR VPWR sky130_fd_sc_hd__decap_6
XPHY_EDGE_ROW_106_Right_106 VGND VGND VPWR VPWR sky130_fd_sc_hd__decap_3
XFILLER_83_541 VPWR VGND VPWR VGND sky130_ef_sc_hd__decap_12
X_4159_ _2070_ net117 net130 VGND VGND VPWR VPWR _0945_ sky130_fd_sc_hd__mux2_1
XTAP_TAPCELL_ROW_54_945 VGND VPWR sky130_fd_sc_hd__tapvpwrvgnd_1
XTAP_TAPCELL_ROW_54_934 VGND VPWR sky130_fd_sc_hd__tapvpwrvgnd_1
XFILLER_43_449 VPWR VGND VPWR VGND sky130_ef_sc_hd__decap_12
XFILLER_102_65 VPWR VGND VPWR VGND sky130_ef_sc_hd__decap_12
Xclkbuf_leaf_35_clk clknet_3_7__leaf_clk VGND VGND VPWR VPWR clknet_leaf_35_clk sky130_fd_sc_hd__clkbuf_8
XFILLER_62_58 VGND VGND VPWR VPWR sky130_fd_sc_hd__fill_2
XFILLER_23_162 VGND VGND VPWR VPWR sky130_fd_sc_hd__decap_6
XFILLER_24_685 VGND VGND VPWR VPWR sky130_fd_sc_hd__decap_4
XPHY_EDGE_ROW_43_Left_166 VGND VGND VPWR VPWR sky130_fd_sc_hd__decap_3
XFILLER_11_357 VGND VGND VPWR VPWR sky130_fd_sc_hd__fill_2
XFILLER_11_346 VGND VGND VPWR VPWR sky130_fd_sc_hd__fill_1
XFILLER_11_335 VGND VGND VPWR VPWR sky130_fd_sc_hd__fill_1
XTAP_TAPCELL_ROW_34_691 VGND VPWR sky130_fd_sc_hd__tapvpwrvgnd_1
XFILLER_109_223 VGND VGND VPWR VPWR sky130_fd_sc_hd__fill_1
XFILLER_7_328 VGND VGND VPWR VPWR sky130_fd_sc_hd__decap_8
XFILLER_11_51 VGND VGND VPWR VPWR sky130_fd_sc_hd__decap_4
XFILLER_105_440 VGND VGND VPWR VPWR sky130_fd_sc_hd__decap_8
XPHY_EDGE_ROW_52_Left_175 VGND VGND VPWR VPWR sky130_fd_sc_hd__decap_3
XFILLER_120_421 VPWR VGND VPWR VGND sky130_ef_sc_hd__decap_12
XFILLER_105_473 VPWR VGND VPWR VGND sky130_ef_sc_hd__decap_12
XFILLER_87_66 VPWR VGND VPWR VGND sky130_ef_sc_hd__decap_12
XFILLER_87_99 VGND VGND VPWR VPWR sky130_fd_sc_hd__decap_3
XTAP_TAPCELL_ROW_109_1623 VGND VPWR sky130_fd_sc_hd__tapvpwrvgnd_1
XFILLER_74_541 VGND VGND VPWR VPWR sky130_fd_sc_hd__fill_2
XFILLER_74_530 VGND VGND VPWR VPWR sky130_fd_sc_hd__fill_2
XFILLER_61_202 VGND VGND VPWR VPWR sky130_fd_sc_hd__fill_2
XTAP_TAPCELL_ROW_122_1801 VGND VPWR sky130_fd_sc_hd__tapvpwrvgnd_1
XFILLER_34_427 VGND VGND VPWR VPWR sky130_fd_sc_hd__fill_1
Xclkbuf_leaf_26_clk clknet_3_3__leaf_clk VGND VGND VPWR VPWR clknet_leaf_26_clk sky130_fd_sc_hd__clkbuf_8
XPHY_EDGE_ROW_61_Left_184 VGND VGND VPWR VPWR sky130_fd_sc_hd__decap_3
XFILLER_15_641 VGND VGND VPWR VPWR sky130_fd_sc_hd__decap_4
XFILLER_15_685 VPWR VGND VPWR VGND sky130_ef_sc_hd__decap_12
XFILLER_14_195 VGND VGND VPWR VPWR sky130_fd_sc_hd__fill_1
XFILLER_52_80 VGND VGND VPWR VPWR sky130_fd_sc_hd__decap_4
Xinput12 DataMemoryRead[1] VGND VGND VPWR VPWR net12 sky130_fd_sc_hd__buf_1
XFILLER_30_666 VGND VGND VPWR VPWR sky130_fd_sc_hd__decap_8
Xinput34 instr[14] VGND VGND VPWR VPWR net34 sky130_fd_sc_hd__buf_12
X_3530_ reg_file_inst.registry\[6\]\[13\] _1123_ net142 VGND VGND VPWR VPWR _1461_
+ sky130_fd_sc_hd__and3_1
Xinput23 DataMemoryRead[4] VGND VGND VPWR VPWR net23 sky130_fd_sc_hd__buf_1
XFILLER_6_361 VGND VGND VPWR VPWR sky130_fd_sc_hd__decap_3
XFILLER_115_237 VPWR VGND VPWR VGND sky130_ef_sc_hd__decap_12
X_3461_ reg_file_inst.registry\[2\]\[17\] _1083_ _1090_ reg_file_inst.registry\[8\]\[17\]
+ VGND VGND VPWR VPWR _1394_ sky130_fd_sc_hd__a22o_1
XPHY_EDGE_ROW_70_Left_193 VGND VGND VPWR VPWR sky130_fd_sc_hd__decap_3
XFILLER_97_600 VPWR VGND VPWR VGND sky130_ef_sc_hd__decap_12
X_3392_ reg_file_inst.registry\[3\]\[19\] _1091_ _1097_ reg_file_inst.registry\[5\]\[19\]
+ VGND VGND VPWR VPWR _1328_ sky130_fd_sc_hd__a22o_1
X_5200_ _2419_ reg_file_inst.registry\[0\]\[5\] _2988_ VGND VGND VPWR VPWR _0852_
+ sky130_fd_sc_hd__mux2_1
X_6180_ clknet_leaf_58_clk _0588_ _0113_ VGND VGND VPWR VPWR reg_file_inst.registry\[5\]\[1\]
+ sky130_fd_sc_hd__dfrtp_1
X_5131_ _1566_ _2283_ _2284_ _1567_ _2955_ VGND VGND VPWR VPWR _2956_ sky130_fd_sc_hd__a221o_1
XFILLER_69_368 VPWR VGND VPWR VGND sky130_ef_sc_hd__decap_12
XFILLER_69_346 VGND VGND VPWR VPWR sky130_fd_sc_hd__fill_1
XTAP_TAPCELL_ROW_4_309 VGND VPWR sky130_fd_sc_hd__tapvpwrvgnd_1
X_5062_ _2176_ _2886_ _2887_ _2896_ VGND VGND VPWR VPWR net51 sky130_fd_sc_hd__a31o_1
X_4013_ net128 _1878_ _1928_ VGND VGND VPWR VPWR _1929_ sky130_fd_sc_hd__nand3_1
XFILLER_77_390 VGND VGND VPWR VPWR sky130_fd_sc_hd__fill_2
XTAP_TAPCELL_ROW_84_1317 VGND VPWR sky130_fd_sc_hd__tapvpwrvgnd_1
XFILLER_37_276 VGND VGND VPWR VPWR sky130_fd_sc_hd__decap_4
XFILLER_80_533 VGND VGND VPWR VPWR sky130_fd_sc_hd__decap_3
XFILLER_16_18 VGND VGND VPWR VPWR sky130_fd_sc_hd__decap_8
XFILLER_16_29 VGND VGND VPWR VPWR sky130_fd_sc_hd__decap_8
XFILLER_25_449 VGND VGND VPWR VPWR sky130_fd_sc_hd__decap_6
Xclkbuf_leaf_17_clk clknet_3_2__leaf_clk VGND VGND VPWR VPWR clknet_leaf_17_clk sky130_fd_sc_hd__clkbuf_8
XFILLER_52_268 VGND VGND VPWR VPWR sky130_fd_sc_hd__decap_4
XTAP_TAPCELL_ROW_51_904 VGND VPWR sky130_fd_sc_hd__tapvpwrvgnd_1
X_5964_ net149 VGND VGND VPWR VPWR _0372_ sky130_fd_sc_hd__inv_2
X_5895_ net146 VGND VGND VPWR VPWR _0303_ sky130_fd_sc_hd__inv_2
X_4915_ _2598_ _2600_ _2673_ _2596_ _2576_ VGND VGND VPWR VPWR _2768_ sky130_fd_sc_hd__a311o_1
X_4846_ _2193_ _2206_ net132 VGND VGND VPWR VPWR _2705_ sky130_fd_sc_hd__mux2_1
XFILLER_21_666 VGND VGND VPWR VPWR sky130_fd_sc_hd__decap_6
XTAP_TAPCELL_ROW_31_650 VGND VPWR sky130_fd_sc_hd__tapvpwrvgnd_1
X_4777_ _1491_ _2634_ VGND VGND VPWR VPWR _2636_ sky130_fd_sc_hd__nor2_1
X_6516_ clknet_leaf_53_clk _0924_ _0449_ VGND VGND VPWR VPWR net122 sky130_fd_sc_hd__dfrtp_1
XTAP_TAPCELL_ROW_95_1446 VGND VPWR sky130_fd_sc_hd__tapvpwrvgnd_1
X_3728_ reg_file_inst.registry\[0\]\[7\] _1076_ _1645_ _1651_ VGND VGND VPWR VPWR
+ _1652_ sky130_fd_sc_hd__o22a_4
XFILLER_4_309 VPWR VGND VPWR VGND sky130_ef_sc_hd__decap_12
XTAP_TAPCELL_ROW_95_1457 VGND VPWR sky130_fd_sc_hd__tapvpwrvgnd_1
X_3659_ reg_file_inst.registry\[11\]\[9\] _1119_ net143 VGND VGND VPWR VPWR _1585_
+ sky130_fd_sc_hd__and3_1
X_6447_ clknet_leaf_54_clk _0855_ _0380_ VGND VGND VPWR VPWR reg_file_inst.registry\[0\]\[8\]
+ sky130_fd_sc_hd__dfrtp_1
X_6378_ clknet_leaf_59_clk _0786_ _0311_ VGND VGND VPWR VPWR reg_file_inst.registry\[14\]\[3\]
+ sky130_fd_sc_hd__dfrtp_1
XFILLER_88_633 VGND VGND VPWR VPWR sky130_fd_sc_hd__decap_8
X_5329_ _2501_ reg_file_inst.registry\[8\]\[2\] _2994_ VGND VGND VPWR VPWR _0729_
+ sky130_fd_sc_hd__mux2_1
XFILLER_102_465 VGND VGND VPWR VPWR sky130_fd_sc_hd__fill_2
XFILLER_88_699 VGND VGND VPWR VPWR sky130_fd_sc_hd__fill_1
XFILLER_57_69 VPWR VGND VPWR VGND sky130_ef_sc_hd__decap_12
XFILLER_48_519 VPWR VGND VPWR VGND sky130_ef_sc_hd__decap_12
XFILLER_56_541 VGND VGND VPWR VPWR sky130_fd_sc_hd__decap_3
XTAP_TAPCELL_ROW_39_750 VGND VPWR sky130_fd_sc_hd__tapvpwrvgnd_1
XFILLER_83_393 VGND VGND VPWR VPWR sky130_fd_sc_hd__decap_8
XFILLER_56_585 VGND VGND VPWR VPWR sky130_fd_sc_hd__decap_3
XFILLER_16_449 VGND VGND VPWR VPWR sky130_fd_sc_hd__fill_2
XFILLER_44_725 VGND VGND VPWR VPWR sky130_fd_sc_hd__fill_1
XFILLER_71_555 VGND VGND VPWR VPWR sky130_fd_sc_hd__decap_4
XFILLER_43_246 VGND VGND VPWR VPWR sky130_fd_sc_hd__decap_8
XTAP_TAPCELL_ROW_104_1564 VGND VPWR sky130_fd_sc_hd__tapvpwrvgnd_1
XFILLER_8_637 VGND VGND VPWR VPWR sky130_fd_sc_hd__decap_6
XFILLER_7_103 VGND VGND VPWR VPWR sky130_fd_sc_hd__decap_8
XFILLER_7_125 VPWR VGND VPWR VGND sky130_ef_sc_hd__decap_12
XFILLER_7_169 VGND VGND VPWR VPWR sky130_fd_sc_hd__fill_1
XFILLER_98_408 VPWR VGND VPWR VGND sky130_ef_sc_hd__decap_12
XFILLER_105_281 VPWR VGND VPWR VGND sky130_ef_sc_hd__decap_12
XFILLER_78_121 VPWR VGND VPWR VGND sky130_ef_sc_hd__decap_12
XFILLER_120_251 VGND VGND VPWR VPWR sky130_fd_sc_hd__fill_1
XFILLER_93_113 VPWR VGND VPWR VGND sky130_ef_sc_hd__decap_12
XFILLER_78_165 VPWR VGND VPWR VGND sky130_ef_sc_hd__decap_12
XFILLER_94_669 VPWR VGND VPWR VGND sky130_ef_sc_hd__decap_12
XFILLER_93_135 VGND VGND VPWR VPWR sky130_fd_sc_hd__fill_2
XFILLER_81_319 VGND VGND VPWR VPWR sky130_fd_sc_hd__decap_8
XFILLER_47_574 VPWR VGND VPWR VGND sky130_ef_sc_hd__decap_12
XFILLER_62_533 VPWR VGND VPWR VGND sky130_ef_sc_hd__decap_12
XTAP_TAPCELL_ROW_17_477 VGND VPWR sky130_fd_sc_hd__tapvpwrvgnd_1
X_4700_ _1383_ _2126_ _2558_ VGND VGND VPWR VPWR _2559_ sky130_fd_sc_hd__o21a_1
X_5680_ net146 VGND VGND VPWR VPWR _0088_ sky130_fd_sc_hd__inv_2
XFILLER_8_41 VPWR VGND VPWR VGND sky130_ef_sc_hd__decap_12
X_4631_ _1816_ _2284_ _2288_ VGND VGND VPWR VPWR _2506_ sky130_fd_sc_hd__a21o_1
XFILLER_8_85 VGND VGND VPWR VPWR sky130_fd_sc_hd__fill_1
XFILLER_116_513 VPWR VGND VPWR VGND sky130_ef_sc_hd__decap_12
X_4562_ _2278_ _2442_ VGND VGND VPWR VPWR _2443_ sky130_fd_sc_hd__nor2_1
X_6301_ clknet_leaf_26_clk _0709_ _0234_ VGND VGND VPWR VPWR reg_file_inst.registry\[3\]\[10\]
+ sky130_fd_sc_hd__dfrtp_1
X_3513_ reg_file_inst.registry\[11\]\[12\] _1141_ _1442_ _1443_ _1444_ VGND VGND VPWR
+ VPWR _1445_ sky130_fd_sc_hd__a2111o_1
XFILLER_6_180 VGND VGND VPWR VPWR sky130_fd_sc_hd__fill_1
X_4493_ net132 _2270_ _2268_ VGND VGND VPWR VPWR _2376_ sky130_fd_sc_hd__o21ba_1
XFILLER_116_557 VPWR VGND VPWR VGND sky130_ef_sc_hd__decap_12
X_6232_ clknet_leaf_22_clk _0640_ _0165_ VGND VGND VPWR VPWR reg_file_inst.registry\[10\]\[25\]
+ sky130_fd_sc_hd__dfrtp_1
X_3444_ reg_file_inst.registry\[14\]\[16\] _1081_ _1092_ reg_file_inst.registry\[4\]\[16\]
+ _1373_ VGND VGND VPWR VPWR _1378_ sky130_fd_sc_hd__a221o_1
Xclkbuf_leaf_6_clk clknet_3_1__leaf_clk VGND VGND VPWR VPWR clknet_leaf_6_clk sky130_fd_sc_hd__clkbuf_8
X_3375_ reg_file_inst.registry\[4\]\[20\] _1114_ _1132_ VGND VGND VPWR VPWR _1312_
+ sky130_fd_sc_hd__and3_1
XFILLER_69_143 VGND VGND VPWR VPWR sky130_fd_sc_hd__fill_1
X_6163_ clknet_leaf_2_clk _0571_ _0096_ VGND VGND VPWR VPWR JMPOFF\[12\] sky130_fd_sc_hd__dfrtp_4
XFILLER_111_273 VGND VGND VPWR VPWR sky130_fd_sc_hd__decap_6
X_6094_ clknet_leaf_19_clk _0502_ _0027_ VGND VGND VPWR VPWR reg_file_inst.registry\[15\]\[27\]
+ sky130_fd_sc_hd__dfrtp_1
XTAP_TAPCELL_ROW_90_1387 VGND VPWR sky130_fd_sc_hd__tapvpwrvgnd_1
XFILLER_57_305 VGND VGND VPWR VPWR sky130_fd_sc_hd__decap_8
X_5114_ _1542_ _2286_ _2940_ VGND VGND VPWR VPWR _2941_ sky130_fd_sc_hd__a21bo_1
XPHY_EDGE_ROW_108_Left_231 VGND VGND VPWR VPWR sky130_fd_sc_hd__decap_3
X_5045_ _2297_ _2533_ _2875_ _2881_ VGND VGND VPWR VPWR _2882_ sky130_fd_sc_hd__o211a_1
XFILLER_65_393 VPWR VGND VPWR VGND sky130_ef_sc_hd__decap_12
XTAP_TAPCELL_ROW_36_720 VGND VPWR sky130_fd_sc_hd__tapvpwrvgnd_1
XFILLER_92_190 VGND VGND VPWR VPWR sky130_fd_sc_hd__decap_6
XFILLER_25_257 VGND VGND VPWR VPWR sky130_fd_sc_hd__decap_3
X_5947_ net147 VGND VGND VPWR VPWR _0355_ sky130_fd_sc_hd__inv_2
XFILLER_25_279 VGND VGND VPWR VPWR sky130_fd_sc_hd__fill_1
XPHY_EDGE_ROW_117_Left_240 VGND VGND VPWR VPWR sky130_fd_sc_hd__decap_3
X_5878_ net148 VGND VGND VPWR VPWR _0286_ sky130_fd_sc_hd__inv_2
X_4829_ _2686_ _2687_ net133 VGND VGND VPWR VPWR _2688_ sky130_fd_sc_hd__mux2_1
XFILLER_119_373 VPWR VGND VPWR VGND sky130_ef_sc_hd__decap_12
XFILLER_5_629 VPWR VGND VPWR VGND sky130_ef_sc_hd__decap_12
XFILLER_122_505 VPWR VGND VPWR VGND sky130_ef_sc_hd__decap_12
XFILLER_108_53 VPWR VGND VPWR VGND sky130_ef_sc_hd__decap_12
XFILLER_0_312 VGND VGND VPWR VPWR sky130_fd_sc_hd__decap_8
XFILLER_108_97 VPWR VGND VPWR VGND sky130_ef_sc_hd__decap_12
XFILLER_0_323 VGND VGND VPWR VPWR sky130_fd_sc_hd__decap_8
XFILLER_0_345 VGND VGND VPWR VPWR sky130_fd_sc_hd__fill_1
XFILLER_102_262 VGND VGND VPWR VPWR sky130_fd_sc_hd__fill_2
XFILLER_88_485 VGND VGND VPWR VPWR sky130_fd_sc_hd__decap_6
XFILLER_88_474 VGND VGND VPWR VPWR sky130_fd_sc_hd__fill_2
XFILLER_75_102 VGND VGND VPWR VPWR sky130_fd_sc_hd__decap_8
XFILLER_75_113 VGND VGND VPWR VPWR sky130_fd_sc_hd__decap_3
XFILLER_91_617 VPWR VGND VPWR VGND sky130_ef_sc_hd__decap_12
XFILLER_56_393 VGND VGND VPWR VPWR sky130_fd_sc_hd__fill_2
XFILLER_71_385 VGND VGND VPWR VPWR sky130_fd_sc_hd__decap_6
XTAP_TAPCELL_ROW_65_1080 VGND VPWR sky130_fd_sc_hd__tapvpwrvgnd_1
XTAP_TAPCELL_ROW_14_436 VGND VPWR sky130_fd_sc_hd__tapvpwrvgnd_1
XFILLER_31_249 VPWR VGND VPWR VGND sky130_ef_sc_hd__decap_12
XTAP_TAPCELL_ROW_42_789 VGND VPWR sky130_fd_sc_hd__tapvpwrvgnd_1
XFILLER_8_445 VPWR VGND VPWR VGND sky130_ef_sc_hd__decap_12
XTAP_TAPCELL_ROW_117_1722 VGND VPWR sky130_fd_sc_hd__tapvpwrvgnd_1
XFILLER_113_505 VPWR VGND VPWR VGND sky130_ef_sc_hd__decap_12
XFILLER_98_249 VGND VGND VPWR VPWR sky130_fd_sc_hd__decap_3
X_3160_ JMPOFF\[27\] _1095_ _1097_ reg_file_inst.registry\[5\]\[27\] _1103_ VGND VGND
+ VPWR VPWR _1104_ sky130_fd_sc_hd__a221o_1
XFILLER_66_135 VGND VGND VPWR VPWR sky130_fd_sc_hd__fill_1
X_3091_ JMPOFF\[10\] net141 net41 VGND VGND VPWR VPWR _1035_ sky130_fd_sc_hd__a21o_1
XTAP_TAPCELL_ROW_68_1109 VGND VPWR sky130_fd_sc_hd__tapvpwrvgnd_1
XFILLER_67_669 VGND VGND VPWR VPWR sky130_fd_sc_hd__decap_3
XFILLER_66_157 VGND VGND VPWR VPWR sky130_fd_sc_hd__fill_1
XFILLER_81_116 VGND VGND VPWR VPWR sky130_fd_sc_hd__decap_3
XPHY_EDGE_ROW_8_Right_8 VGND VGND VPWR VPWR sky130_fd_sc_hd__decap_3
X_5801_ net147 VGND VGND VPWR VPWR _0209_ sky130_fd_sc_hd__inv_2
XFILLER_50_514 VPWR VGND VPWR VGND sky130_ef_sc_hd__decap_12
X_3993_ _1908_ VGND VGND VPWR VPWR _1909_ sky130_fd_sc_hd__inv_2
X_5732_ net146 VGND VGND VPWR VPWR _0140_ sky130_fd_sc_hd__inv_2
X_5663_ net44 VGND VGND VPWR VPWR _0071_ sky130_fd_sc_hd__inv_2
XTAP_TAPCELL_ROW_79_1249 VGND VPWR sky130_fd_sc_hd__tapvpwrvgnd_1
X_5594_ net147 VGND VGND VPWR VPWR _0002_ sky130_fd_sc_hd__inv_2
XFILLER_30_293 VGND VGND VPWR VPWR sky130_fd_sc_hd__decap_8
X_4614_ _1802_ _2284_ _2437_ VGND VGND VPWR VPWR _2491_ sky130_fd_sc_hd__a21o_1
XFILLER_116_321 VPWR VGND VPWR VGND sky130_ef_sc_hd__decap_12
X_4545_ _2420_ _2425_ net136 VGND VGND VPWR VPWR _2426_ sky130_fd_sc_hd__mux2_1
XFILLER_116_365 VPWR VGND VPWR VGND sky130_ef_sc_hd__decap_12
XTAP_TAPCELL_ROW_92_1416 VGND VPWR sky130_fd_sc_hd__tapvpwrvgnd_1
Xmax_cap142 _1132_ VGND VGND VPWR VPWR net142 sky130_fd_sc_hd__buf_4
Xmax_cap131 _1878_ VGND VGND VPWR VPWR net131 sky130_fd_sc_hd__clkbuf_8
X_4476_ _2360_ VGND VGND VPWR VPWR _2361_ sky130_fd_sc_hd__inv_2
X_3427_ reg_file_inst.registry\[2\]\[18\] _1137_ _1140_ reg_file_inst.registry\[3\]\[18\]
+ VGND VGND VPWR VPWR _1362_ sky130_fd_sc_hd__a22o_1
X_6215_ clknet_leaf_54_clk _0623_ _0148_ VGND VGND VPWR VPWR reg_file_inst.registry\[10\]\[8\]
+ sky130_fd_sc_hd__dfrtp_1
XPHY_EDGE_ROW_39_Right_39 VGND VGND VPWR VPWR sky130_fd_sc_hd__decap_3
X_6146_ clknet_leaf_35_clk _0554_ _0079_ VGND VGND VPWR VPWR reg_file_inst.registry\[6\]\[23\]
+ sky130_fd_sc_hd__dfrtp_1
X_3358_ _1280_ _1294_ VGND VGND VPWR VPWR _1295_ sky130_fd_sc_hd__nand2_1
XFILLER_97_293 VGND VGND VPWR VPWR sky130_fd_sc_hd__decap_3
XFILLER_97_271 VGND VGND VPWR VPWR sky130_fd_sc_hd__decap_8
XFILLER_57_113 VGND VGND VPWR VPWR sky130_fd_sc_hd__decap_4
X_3289_ reg_file_inst.registry\[9\]\[23\] _1089_ _1227_ _1228_ VGND VGND VPWR VPWR
+ _1229_ sky130_fd_sc_hd__a211o_1
XFILLER_73_617 VGND VGND VPWR VPWR sky130_fd_sc_hd__decap_6
X_6077_ clknet_leaf_28_clk _0485_ _0010_ VGND VGND VPWR VPWR reg_file_inst.registry\[15\]\[10\]
+ sky130_fd_sc_hd__dfrtp_1
XFILLER_45_308 VPWR VGND VPWR VGND sky130_ef_sc_hd__decap_12
XFILLER_26_522 VGND VGND VPWR VPWR sky130_fd_sc_hd__decap_8
X_5028_ _1403_ _1417_ _2866_ VGND VGND VPWR VPWR _2867_ sky130_fd_sc_hd__o21ai_1
XFILLER_38_371 VPWR VGND VPWR VGND sky130_ef_sc_hd__decap_12
XFILLER_72_149 VGND VGND VPWR VPWR sky130_fd_sc_hd__decap_8
XFILLER_54_15 VPWR VGND VPWR VGND sky130_ef_sc_hd__decap_12
XFILLER_26_533 VGND VGND VPWR VPWR sky130_fd_sc_hd__decap_8
XFILLER_26_555 VGND VGND VPWR VPWR sky130_fd_sc_hd__decap_8
XTAP_TAPCELL_ROW_101_1523 VGND VPWR sky130_fd_sc_hd__tapvpwrvgnd_1
XFILLER_41_558 VGND VGND VPWR VPWR sky130_fd_sc_hd__fill_2
XPHY_EDGE_ROW_48_Right_48 VGND VGND VPWR VPWR sky130_fd_sc_hd__decap_3
XFILLER_110_65 VPWR VGND VPWR VGND sky130_ef_sc_hd__decap_12
XTAP_TAPCELL_ROW_11_406 VGND VPWR sky130_fd_sc_hd__tapvpwrvgnd_1
XFILLER_119_181 VPWR VGND VPWR VGND sky130_ef_sc_hd__decap_12
XFILLER_79_45 VGND VGND VPWR VPWR sky130_fd_sc_hd__decap_8
XFILLER_79_23 VGND VGND VPWR VPWR sky130_fd_sc_hd__fill_2
XPHY_EDGE_ROW_57_Right_57 VGND VGND VPWR VPWR sky130_fd_sc_hd__decap_3
XTAP_TAPCELL_ROW_112_1663 VGND VPWR sky130_fd_sc_hd__tapvpwrvgnd_1
XFILLER_1_665 VGND VGND VPWR VPWR sky130_fd_sc_hd__decap_6
XFILLER_49_614 VGND VGND VPWR VPWR sky130_fd_sc_hd__fill_2
XFILLER_95_66 VPWR VGND VPWR VGND sky130_ef_sc_hd__decap_12
XFILLER_95_55 VGND VGND VPWR VPWR sky130_fd_sc_hd__fill_1
XFILLER_88_293 VPWR VGND VPWR VGND sky130_ef_sc_hd__decap_12
XFILLER_0_197 VGND VGND VPWR VPWR sky130_fd_sc_hd__decap_6
XFILLER_48_124 VGND VGND VPWR VPWR sky130_fd_sc_hd__decap_6
XFILLER_76_455 VGND VGND VPWR VPWR sky130_fd_sc_hd__decap_3
XFILLER_57_691 VPWR VGND VPWR VGND sky130_ef_sc_hd__decap_12
XTAP_TAPCELL_ROW_19_506 VGND VPWR sky130_fd_sc_hd__tapvpwrvgnd_1
XTAP_TAPCELL_ROW_47_848 VGND VPWR sky130_fd_sc_hd__tapvpwrvgnd_1
XFILLER_63_149 VPWR VGND VPWR VGND sky130_ef_sc_hd__decap_12
XPHY_EDGE_ROW_66_Right_66 VGND VGND VPWR VPWR sky130_fd_sc_hd__decap_3
XFILLER_44_374 VGND VGND VPWR VPWR sky130_fd_sc_hd__fill_1
XFILLER_44_81 VGND VGND VPWR VPWR sky130_fd_sc_hd__decap_3
XFILLER_9_721 VGND VGND VPWR VPWR sky130_fd_sc_hd__decap_4
XFILLER_8_253 VPWR VGND VPWR VGND sky130_ef_sc_hd__decap_12
XFILLER_99_503 VGND VGND VPWR VPWR sky130_fd_sc_hd__fill_1
XPHY_EDGE_ROW_75_Right_75 VGND VGND VPWR VPWR sky130_fd_sc_hd__decap_3
X_4330_ _2212_ _2217_ net133 VGND VGND VPWR VPWR _2218_ sky130_fd_sc_hd__mux2_1
XFILLER_113_335 VGND VGND VPWR VPWR sky130_fd_sc_hd__fill_1
XFILLER_99_558 VGND VGND VPWR VPWR sky130_fd_sc_hd__fill_2
XFILLER_87_709 VPWR VGND VPWR VGND sky130_ef_sc_hd__decap_12
X_4261_ _1721_ _2148_ VGND VGND VPWR VPWR _2149_ sky130_fd_sc_hd__and2_1
X_3212_ reg_file_inst.registry\[5\]\[26\] _1097_ _1098_ reg_file_inst.registry\[10\]\[26\]
+ VGND VGND VPWR VPWR _1155_ sky130_fd_sc_hd__a22o_1
X_6000_ net146 VGND VGND VPWR VPWR _0408_ sky130_fd_sc_hd__inv_2
X_4192_ _1920_ _2083_ _1919_ VGND VGND VPWR VPWR _2093_ sky130_fd_sc_hd__a21oi_1
X_3143_ _1078_ _1082_ VGND VGND VPWR VPWR _1087_ sky130_fd_sc_hd__and2_4
XPHY_EDGE_ROW_84_Right_84 VGND VGND VPWR VPWR sky130_fd_sc_hd__decap_3
X_3074_ _1005_ _1016_ _1004_ VGND VGND VPWR VPWR _1018_ sky130_fd_sc_hd__o21a_1
XFILLER_63_683 VGND VGND VPWR VPWR sky130_fd_sc_hd__fill_2
XFILLER_62_182 VGND VGND VPWR VPWR sky130_fd_sc_hd__decap_3
XFILLER_23_536 VGND VGND VPWR VPWR sky130_fd_sc_hd__fill_1
XFILLER_35_385 VGND VGND VPWR VPWR sky130_fd_sc_hd__decap_6
X_3976_ net131 _1889_ _1890_ net109 VGND VGND VPWR VPWR _1892_ sky130_fd_sc_hd__a31o_1
X_5715_ net147 VGND VGND VPWR VPWR _0123_ sky130_fd_sc_hd__inv_2
XFILLER_50_377 VGND VGND VPWR VPWR sky130_fd_sc_hd__fill_1
X_5646_ net147 VGND VGND VPWR VPWR _0054_ sky130_fd_sc_hd__inv_2
XPHY_EDGE_ROW_93_Right_93 VGND VGND VPWR VPWR sky130_fd_sc_hd__decap_3
XFILLER_117_641 VPWR VGND VPWR VGND sky130_ef_sc_hd__decap_12
X_5577_ reg_file_inst.registry\[15\]\[15\] _2897_ _3003_ VGND VGND VPWR VPWR _0490_
+ sky130_fd_sc_hd__mux2_1
XFILLER_117_685 VPWR VGND VPWR VGND sky130_ef_sc_hd__decap_12
X_4528_ _1736_ _1752_ _2285_ _2409_ _2410_ VGND VGND VPWR VPWR _2411_ sky130_fd_sc_hd__o311a_1
XFILLER_116_195 VGND VGND VPWR VPWR sky130_fd_sc_hd__fill_1
X_4459_ _1515_ _2190_ _1840_ VGND VGND VPWR VPWR _2344_ sky130_fd_sc_hd__a21oi_1
XFILLER_104_357 VGND VGND VPWR VPWR sky130_fd_sc_hd__decap_6
XFILLER_77_208 VGND VGND VPWR VPWR sky130_fd_sc_hd__decap_6
XFILLER_58_400 VGND VGND VPWR VPWR sky130_fd_sc_hd__decap_4
XFILLER_65_14 VGND VGND VPWR VPWR sky130_fd_sc_hd__decap_8
X_6129_ clknet_leaf_60_clk _0537_ _0062_ VGND VGND VPWR VPWR reg_file_inst.registry\[6\]\[6\]
+ sky130_fd_sc_hd__dfrtp_1
XFILLER_73_414 VPWR VGND VPWR VGND sky130_ef_sc_hd__decap_12
XFILLER_45_149 VGND VGND VPWR VPWR sky130_fd_sc_hd__decap_8
XFILLER_60_108 VGND VGND VPWR VPWR sky130_fd_sc_hd__decap_8
XFILLER_26_374 VPWR VGND VPWR VGND sky130_ef_sc_hd__decap_12
XTAP_TAPCELL_ROW_44_818 VGND VPWR sky130_fd_sc_hd__tapvpwrvgnd_1
XFILLER_81_35 VGND VGND VPWR VPWR sky130_fd_sc_hd__fill_1
XFILLER_54_694 VGND VGND VPWR VPWR sky130_fd_sc_hd__decap_6
XFILLER_81_57 VPWR VGND VPWR VGND sky130_ef_sc_hd__decap_12
XFILLER_14_62 VPWR VGND VPWR VGND sky130_ef_sc_hd__decap_12
XTAP_TAPCELL_ROW_24_564 VGND VPWR sky130_fd_sc_hd__tapvpwrvgnd_1
XFILLER_6_713 VPWR VGND VPWR VGND sky130_ef_sc_hd__decap_12
XFILLER_30_50 VPWR VGND VPWR VGND sky130_ef_sc_hd__decap_12
XFILLER_30_83 VGND VGND VPWR VPWR sky130_fd_sc_hd__fill_1
XFILLER_122_165 VGND VGND VPWR VPWR sky130_fd_sc_hd__decap_3
XFILLER_96_528 VGND VGND VPWR VPWR sky130_fd_sc_hd__decap_4
XFILLER_68_208 VPWR VGND VPWR VGND sky130_ef_sc_hd__decap_12
XFILLER_1_440 VGND VGND VPWR VPWR sky130_fd_sc_hd__decap_8
XFILLER_49_433 VGND VGND VPWR VPWR sky130_fd_sc_hd__decap_3
XFILLER_103_390 VGND VGND VPWR VPWR sky130_fd_sc_hd__fill_2
XFILLER_92_701 VPWR VGND VPWR VGND sky130_ef_sc_hd__decap_12
XFILLER_32_322 VGND VGND VPWR VPWR sky130_fd_sc_hd__fill_1
XFILLER_60_675 VPWR VGND VPWR VGND sky130_ef_sc_hd__decap_12
X_3830_ reg_file_inst.registry\[0\]\[5\] _1118_ _1739_ _1750_ VGND VGND VPWR VPWR
+ net96 sky130_fd_sc_hd__o22a_2
XFILLER_32_377 VPWR VGND VPWR VGND sky130_ef_sc_hd__decap_12
X_3761_ reg_file_inst.registry\[6\]\[6\] _1123_ _1132_ VGND VGND VPWR VPWR _1684_
+ sky130_fd_sc_hd__and3_1
X_5500_ JMPOFF\[5\] _2419_ _3000_ VGND VGND VPWR VPWR _0564_ sky130_fd_sc_hd__mux2_1
X_6480_ clknet_leaf_11_clk _0888_ _0413_ VGND VGND VPWR VPWR reg_file_inst.registry\[7\]\[13\]
+ sky130_fd_sc_hd__dfrtp_1
XFILLER_9_573 VPWR VGND VPWR VGND sky130_ef_sc_hd__decap_12
X_3692_ reg_file_inst.registry\[11\]\[8\] _1119_ _1125_ VGND VGND VPWR VPWR _1617_
+ sky130_fd_sc_hd__and3_1
X_5431_ _2883_ reg_file_inst.registry\[10\]\[16\] _2998_ VGND VGND VPWR VPWR _0631_
+ sky130_fd_sc_hd__mux2_1
XTAP_TAPCELL_ROW_76_1219 VGND VPWR sky130_fd_sc_hd__tapvpwrvgnd_1
XTAP_TAPCELL_ROW_76_1208 VGND VPWR sky130_fd_sc_hd__tapvpwrvgnd_1
X_5362_ MEMOFF\[27\] _2715_ _2996_ VGND VGND VPWR VPWR _0698_ sky130_fd_sc_hd__mux2_1
X_4313_ _2196_ _2200_ net134 VGND VGND VPWR VPWR _2201_ sky130_fd_sc_hd__mux2_1
X_5293_ _2974_ reg_file_inst.registry\[2\]\[9\] _2993_ VGND VGND VPWR VPWR _0764_
+ sky130_fd_sc_hd__mux2_1
XFILLER_114_699 VGND VGND VPWR VPWR sky130_fd_sc_hd__fill_1
X_4244_ _2129_ _2131_ _2127_ VGND VGND VPWR VPWR _2132_ sky130_fd_sc_hd__o21a_1
XFILLER_95_561 VPWR VGND VPWR VGND sky130_ef_sc_hd__decap_12
XFILLER_67_241 VPWR VGND VPWR VGND sky130_ef_sc_hd__decap_12
X_4175_ _1993_ _2002_ VGND VGND VPWR VPWR _2081_ sky130_fd_sc_hd__xor2_1
X_3126_ JMPOFF\[24\] net141 net41 VGND VGND VPWR VPWR _1070_ sky130_fd_sc_hd__a21o_1
XFILLER_67_285 VGND VGND VPWR VPWR sky130_fd_sc_hd__fill_1
XTAP_TAPCELL_ROW_87_1348 VGND VPWR sky130_fd_sc_hd__tapvpwrvgnd_1
X_3057_ JMPOFF\[4\] net38 _0966_ VGND VGND VPWR VPWR _1001_ sky130_fd_sc_hd__and3_1
XFILLER_70_428 VGND VGND VPWR VPWR sky130_fd_sc_hd__decap_3
XFILLER_63_491 VPWR VGND VPWR VGND sky130_ef_sc_hd__decap_12
XFILLER_51_631 VGND VGND VPWR VPWR sky130_fd_sc_hd__decap_3
XFILLER_51_642 VGND VGND VPWR VPWR sky130_fd_sc_hd__fill_2
XFILLER_23_333 VGND VGND VPWR VPWR sky130_fd_sc_hd__decap_3
XFILLER_35_193 VGND VGND VPWR VPWR sky130_fd_sc_hd__decap_3
XFILLER_50_141 VGND VGND VPWR VPWR sky130_fd_sc_hd__decap_3
XFILLER_109_405 VPWR VGND VPWR VGND sky130_ef_sc_hd__decap_12
XTAP_TAPCELL_ROW_21_523 VGND VPWR sky130_fd_sc_hd__tapvpwrvgnd_1
X_3959_ _0965_ _1873_ VGND VGND VPWR VPWR _1875_ sky130_fd_sc_hd__and2_1
XFILLER_109_449 VPWR VGND VPWR VGND sky130_ef_sc_hd__decap_12
XTAP_TAPCELL_ROW_98_1488 VGND VPWR sky130_fd_sc_hd__tapvpwrvgnd_1
X_5629_ net148 VGND VGND VPWR VPWR _0037_ sky130_fd_sc_hd__inv_2
XFILLER_4_6 VPWR VGND VPWR VGND sky130_ef_sc_hd__decap_12
XFILLER_120_625 VPWR VGND VPWR VGND sky130_ef_sc_hd__decap_12
XFILLER_116_53 VPWR VGND VPWR VGND sky130_ef_sc_hd__decap_12
XFILLER_104_176 VPWR VGND VPWR VGND sky130_ef_sc_hd__decap_12
XFILLER_120_669 VPWR VGND VPWR VGND sky130_ef_sc_hd__decap_12
XFILLER_116_97 VPWR VGND VPWR VGND sky130_ef_sc_hd__decap_12
XFILLER_86_572 VGND VGND VPWR VPWR sky130_fd_sc_hd__decap_3
XFILLER_74_701 VGND VGND VPWR VPWR sky130_fd_sc_hd__decap_4
XFILLER_18_105 VGND VGND VPWR VPWR sky130_fd_sc_hd__decap_8
XFILLER_19_617 VPWR VGND VPWR VGND sky130_ef_sc_hd__decap_12
XFILLER_100_393 VGND VGND VPWR VPWR sky130_fd_sc_hd__decap_8
XFILLER_73_233 VGND VGND VPWR VPWR sky130_fd_sc_hd__decap_3
XTAP_TAPCELL_ROW_29_623 VGND VPWR sky130_fd_sc_hd__tapvpwrvgnd_1
XTAP_TAPCELL_ROW_57_976 VGND VPWR sky130_fd_sc_hd__tapvpwrvgnd_1
XFILLER_27_661 VGND VGND VPWR VPWR sky130_fd_sc_hd__decap_8
XTAP_TAPCELL_ROW_1_281 VGND VPWR sky130_fd_sc_hd__tapvpwrvgnd_1
XFILLER_14_300 VGND VGND VPWR VPWR sky130_fd_sc_hd__decap_8
XFILLER_42_631 VGND VGND VPWR VPWR sky130_fd_sc_hd__fill_1
XTAP_TAPCELL_ROW_120_1762 VGND VPWR sky130_fd_sc_hd__tapvpwrvgnd_1
XTAP_TAPCELL_ROW_60_1009 VGND VPWR sky130_fd_sc_hd__tapvpwrvgnd_1
XFILLER_6_587 VGND VGND VPWR VPWR sky130_fd_sc_hd__fill_1
XFILLER_69_517 VGND VGND VPWR VPWR sky130_fd_sc_hd__fill_2
XTAP_TAPCELL_ROW_71_1149 VGND VPWR sky130_fd_sc_hd__tapvpwrvgnd_1
XTAP_TAPCELL_ROW_9_381 VGND VPWR sky130_fd_sc_hd__tapvpwrvgnd_1
XFILLER_96_347 VPWR VGND VPWR VGND sky130_ef_sc_hd__decap_12
XFILLER_1_281 VGND VGND VPWR VPWR sky130_fd_sc_hd__fill_2
XFILLER_77_572 VGND VGND VPWR VPWR sky130_fd_sc_hd__decap_3
XFILLER_2_65 VPWR VGND VPWR VGND sky130_ef_sc_hd__decap_12
XFILLER_37_403 VGND VGND VPWR VPWR sky130_fd_sc_hd__decap_8
XFILLER_92_531 VGND VGND VPWR VPWR sky130_fd_sc_hd__fill_1
XFILLER_37_447 VGND VGND VPWR VPWR sky130_fd_sc_hd__fill_1
XFILLER_49_296 VGND VGND VPWR VPWR sky130_fd_sc_hd__fill_1
XFILLER_92_586 VGND VGND VPWR VPWR sky130_fd_sc_hd__fill_2
X_5980_ net44 VGND VGND VPWR VPWR _0388_ sky130_fd_sc_hd__inv_2
X_4931_ _2441_ _2783_ net136 VGND VGND VPWR VPWR _2784_ sky130_fd_sc_hd__mux2_1
X_4862_ _2718_ VGND VGND VPWR VPWR _2719_ sky130_fd_sc_hd__inv_2
XFILLER_17_193 VPWR VGND VPWR VGND sky130_ef_sc_hd__decap_12
XFILLER_32_141 VGND VGND VPWR VPWR sky130_fd_sc_hd__decap_4
XFILLER_33_642 VGND VGND VPWR VPWR sky130_fd_sc_hd__fill_2
XTAP_TAPCELL_ROW_82_1289 VGND VPWR sky130_fd_sc_hd__tapvpwrvgnd_1
XFILLER_60_461 VPWR VGND VPWR VGND sky130_ef_sc_hd__decap_12
X_3813_ _1730_ _1731_ _1732_ _1733_ VGND VGND VPWR VPWR _1734_ sky130_fd_sc_hd__or4_1
XANTENNA_26 net102 VGND VGND VPWR VPWR sky130_fd_sc_hd__diode_2
XFILLER_60_494 VPWR VGND VPWR VGND sky130_ef_sc_hd__decap_12
X_4793_ _2637_ _2642_ _2651_ _2635_ VGND VGND VPWR VPWR _2652_ sky130_fd_sc_hd__a211o_1
XANTENNA_15 net69 VGND VGND VPWR VPWR sky130_fd_sc_hd__diode_2
XFILLER_20_347 VPWR VGND VPWR VGND sky130_ef_sc_hd__decap_12
XFILLER_119_725 VGND VGND VPWR VPWR sky130_fd_sc_hd__fill_1
X_6532_ clknet_leaf_48_clk _0940_ _0465_ VGND VGND VPWR VPWR net111 sky130_fd_sc_hd__dfrtp_1
X_3744_ MEMOFF\[7\] net98 _1113_ VGND VGND VPWR VPWR _1667_ sky130_fd_sc_hd__mux2_2
X_6463_ clknet_leaf_31_clk _0871_ _0396_ VGND VGND VPWR VPWR reg_file_inst.registry\[0\]\[24\]
+ sky130_fd_sc_hd__dfrtp_1
X_3675_ reg_file_inst.registry\[11\]\[8\] _1085_ _1088_ VGND VGND VPWR VPWR _1600_
+ sky130_fd_sc_hd__and3_1
XFILLER_106_419 VGND VGND VPWR VPWR sky130_fd_sc_hd__fill_1
X_5414_ reg_file_inst.registry\[4\]\[4\] _2455_ _2997_ VGND VGND VPWR VPWR _0647_
+ sky130_fd_sc_hd__mux2_1
Xoutput100 net100 VGND VGND VPWR VPWR DataMemoryWrite[9] sky130_fd_sc_hd__buf_1
X_6394_ clknet_leaf_19_clk _0802_ _0327_ VGND VGND VPWR VPWR reg_file_inst.registry\[14\]\[19\]
+ sky130_fd_sc_hd__dfrtp_1
Xoutput111 net111 VGND VGND VPWR VPWR IC[18] sky130_fd_sc_hd__buf_1
Xoutput122 net122 VGND VGND VPWR VPWR IC[2] sky130_fd_sc_hd__buf_1
X_5345_ _2897_ reg_file_inst.registry\[3\]\[15\] _2995_ VGND VGND VPWR VPWR _0714_
+ sky130_fd_sc_hd__mux2_1
XFILLER_102_625 VPWR VGND VPWR VGND sky130_ef_sc_hd__decap_12
XFILLER_101_113 VPWR VGND VPWR VGND sky130_ef_sc_hd__decap_12
XFILLER_87_314 VGND VGND VPWR VPWR sky130_fd_sc_hd__decap_8
X_5276_ _2747_ reg_file_inst.registry\[2\]\[26\] _2993_ VGND VGND VPWR VPWR _0781_
+ sky130_fd_sc_hd__mux2_1
XFILLER_102_669 VPWR VGND VPWR VGND sky130_ef_sc_hd__decap_12
XFILLER_87_369 VGND VGND VPWR VPWR sky130_fd_sc_hd__fill_2
X_4227_ net30 net32 _0963_ net31 VGND VGND VPWR VPWR _2115_ sky130_fd_sc_hd__and4b_4
XFILLER_56_701 VGND VGND VPWR VPWR sky130_fd_sc_hd__decap_4
XFILLER_28_414 VGND VGND VPWR VPWR sky130_fd_sc_hd__decap_6
XFILLER_95_380 VPWR VGND VPWR VGND sky130_ef_sc_hd__decap_12
XFILLER_83_520 VGND VGND VPWR VPWR sky130_fd_sc_hd__decap_8
X_4158_ _2049_ _2067_ VGND VGND VPWR VPWR _2070_ sky130_fd_sc_hd__xor2_1
XFILLER_28_447 VGND VGND VPWR VPWR sky130_fd_sc_hd__fill_1
XFILLER_46_27 VGND VGND VPWR VPWR sky130_fd_sc_hd__fill_1
XFILLER_83_553 VGND VGND VPWR VPWR sky130_fd_sc_hd__decap_6
X_4089_ _1993_ _2004_ VGND VGND VPWR VPWR _2005_ sky130_fd_sc_hd__or2_1
X_3109_ _1041_ _1052_ VGND VGND VPWR VPWR _1053_ sky130_fd_sc_hd__or2_1
XTAP_TAPCELL_ROW_54_935 VGND VPWR sky130_fd_sc_hd__tapvpwrvgnd_1
XFILLER_43_439 VGND VGND VPWR VPWR sky130_fd_sc_hd__decap_8
XFILLER_102_77 VGND VGND VPWR VPWR sky130_fd_sc_hd__decap_6
XFILLER_24_653 VPWR VGND VPWR VGND sky130_ef_sc_hd__decap_12
XFILLER_51_461 VGND VGND VPWR VPWR sky130_fd_sc_hd__decap_4
XFILLER_23_141 VGND VGND VPWR VPWR sky130_fd_sc_hd__fill_2
XTAP_TAPCELL_ROW_34_692 VGND VPWR sky130_fd_sc_hd__tapvpwrvgnd_1
XFILLER_109_279 VGND VGND VPWR VPWR sky130_fd_sc_hd__fill_1
XFILLER_3_502 VGND VGND VPWR VPWR sky130_fd_sc_hd__fill_2
XFILLER_2_3 VPWR VGND VPWR VGND sky130_ef_sc_hd__decap_12
XFILLER_105_485 VPWR VGND VPWR VGND sky130_ef_sc_hd__decap_12
XFILLER_120_433 VPWR VGND VPWR VGND sky130_ef_sc_hd__decap_12
XFILLER_87_78 VGND VGND VPWR VPWR sky130_fd_sc_hd__fill_1
XTAP_TAPCELL_ROW_6_340 VGND VPWR sky130_fd_sc_hd__tapvpwrvgnd_1
XFILLER_120_477 VPWR VGND VPWR VGND sky130_ef_sc_hd__decap_12
XFILLER_59_561 VPWR VGND VPWR VGND sky130_ef_sc_hd__decap_12
XFILLER_19_403 VPWR VGND VPWR VGND sky130_ef_sc_hd__decap_12
XTAP_TAPCELL_ROW_109_1624 VGND VPWR sky130_fd_sc_hd__tapvpwrvgnd_1
XFILLER_46_233 VPWR VGND VPWR VGND sky130_ef_sc_hd__decap_12
XTAP_TAPCELL_ROW_122_1802 VGND VPWR sky130_fd_sc_hd__tapvpwrvgnd_1
XFILLER_74_586 VGND VGND VPWR VPWR sky130_fd_sc_hd__fill_2
XFILLER_36_82 VGND VGND VPWR VPWR sky130_fd_sc_hd__fill_2
XFILLER_61_258 VGND VGND VPWR VPWR sky130_fd_sc_hd__fill_1
XFILLER_14_141 VGND VGND VPWR VPWR sky130_fd_sc_hd__decap_8
XFILLER_14_163 VGND VGND VPWR VPWR sky130_fd_sc_hd__fill_1
XFILLER_15_697 VPWR VGND VPWR VGND sky130_ef_sc_hd__decap_12
XFILLER_30_645 VGND VGND VPWR VPWR sky130_fd_sc_hd__decap_4
Xinput13 DataMemoryRead[20] VGND VGND VPWR VPWR net13 sky130_fd_sc_hd__buf_1
Xinput35 instr[1] VGND VGND VPWR VPWR net35 sky130_fd_sc_hd__buf_6
Xinput24 DataMemoryRead[5] VGND VGND VPWR VPWR net24 sky130_fd_sc_hd__buf_1
XFILLER_115_205 VPWR VGND VPWR VGND sky130_ef_sc_hd__decap_12
XFILLER_10_391 VPWR VGND VPWR VGND sky130_ef_sc_hd__decap_12
XFILLER_115_249 VPWR VGND VPWR VGND sky130_ef_sc_hd__decap_12
XFILLER_6_384 VGND VGND VPWR VPWR sky130_fd_sc_hd__decap_8
X_3460_ _1382_ _1392_ VGND VGND VPWR VPWR _1393_ sky130_fd_sc_hd__xnor2_1
X_3391_ JMPOFF\[19\] _1095_ _1325_ _1326_ net139 VGND VGND VPWR VPWR _1327_ sky130_fd_sc_hd__a2111o_1
XFILLER_97_612 VGND VGND VPWR VPWR sky130_fd_sc_hd__decap_4
XFILLER_69_314 VPWR VGND VPWR VGND sky130_ef_sc_hd__decap_12
X_5130_ _1552_ _1566_ _2954_ VGND VGND VPWR VPWR _2955_ sky130_fd_sc_hd__a21oi_1
X_5061_ _2891_ _2893_ _2895_ VGND VGND VPWR VPWR _2896_ sky130_fd_sc_hd__or3_1
XFILLER_84_306 VGND VGND VPWR VPWR sky130_fd_sc_hd__fill_2
X_4012_ _1024_ _1927_ VGND VGND VPWR VPWR _1928_ sky130_fd_sc_hd__nor2_1
XFILLER_38_701 VPWR VGND VPWR VGND sky130_ef_sc_hd__decap_12
XFILLER_37_222 VGND VGND VPWR VPWR sky130_fd_sc_hd__fill_2
XFILLER_37_266 VGND VGND VPWR VPWR sky130_fd_sc_hd__fill_2
XFILLER_92_372 VPWR VGND VPWR VGND sky130_ef_sc_hd__decap_12
XTAP_TAPCELL_ROW_84_1318 VGND VPWR sky130_fd_sc_hd__tapvpwrvgnd_1
X_5963_ net149 VGND VGND VPWR VPWR _0371_ sky130_fd_sc_hd__inv_2
XFILLER_52_203 VPWR VGND VPWR VGND sky130_ef_sc_hd__decap_12
XFILLER_25_439 VGND VGND VPWR VPWR sky130_fd_sc_hd__decap_8
X_4914_ reg_file_inst.registry\[7\]\[25\] _2767_ _2553_ VGND VGND VPWR VPWR _0900_
+ sky130_fd_sc_hd__mux2_1
XTAP_TAPCELL_ROW_51_905 VGND VPWR sky130_fd_sc_hd__tapvpwrvgnd_1
X_5894_ net146 VGND VGND VPWR VPWR _0302_ sky130_fd_sc_hd__inv_2
XFILLER_33_461 VPWR VGND VPWR VGND sky130_ef_sc_hd__decap_12
X_4845_ _2195_ _2197_ VGND VGND VPWR VPWR _2704_ sky130_fd_sc_hd__nor2_1
XFILLER_32_18 VGND VGND VPWR VPWR sky130_fd_sc_hd__decap_8
XFILLER_32_29 VPWR VGND VPWR VGND sky130_ef_sc_hd__decap_12
X_4776_ _1491_ _2634_ VGND VGND VPWR VPWR _2635_ sky130_fd_sc_hd__and2_1
XTAP_TAPCELL_ROW_31_651 VGND VPWR sky130_fd_sc_hd__tapvpwrvgnd_1
X_3727_ _1646_ _1647_ _1648_ _1650_ VGND VGND VPWR VPWR _1651_ sky130_fd_sc_hd__or4_1
X_6515_ clknet_leaf_53_clk _0923_ _0448_ VGND VGND VPWR VPWR net113 sky130_fd_sc_hd__dfrtp_1
XTAP_TAPCELL_ROW_95_1447 VGND VPWR sky130_fd_sc_hd__tapvpwrvgnd_1
X_3658_ reg_file_inst.registry\[1\]\[9\] net145 _1127_ VGND VGND VPWR VPWR _1584_
+ sky130_fd_sc_hd__and3_1
X_6446_ clknet_leaf_43_clk _0854_ _0379_ VGND VGND VPWR VPWR reg_file_inst.registry\[0\]\[7\]
+ sky130_fd_sc_hd__dfrtp_1
X_3589_ _1504_ _1516_ VGND VGND VPWR VPWR _1517_ sky130_fd_sc_hd__nand2_1
X_6377_ clknet_leaf_61_clk _0785_ _0310_ VGND VGND VPWR VPWR reg_file_inst.registry\[14\]\[2\]
+ sky130_fd_sc_hd__dfrtp_1
XFILLER_87_111 VGND VGND VPWR VPWR sky130_fd_sc_hd__fill_1
X_5328_ _2478_ reg_file_inst.registry\[8\]\[3\] _2994_ VGND VGND VPWR VPWR _0730_
+ sky130_fd_sc_hd__mux2_1
XFILLER_0_527 VGND VGND VPWR VPWR sky130_fd_sc_hd__fill_1
XFILLER_88_645 VPWR VGND VPWR VGND sky130_ef_sc_hd__decap_12
XFILLER_102_477 VGND VGND VPWR VPWR sky130_fd_sc_hd__decap_8
XFILLER_87_166 VGND VGND VPWR VPWR sky130_fd_sc_hd__fill_2
XFILLER_75_328 VGND VGND VPWR VPWR sky130_fd_sc_hd__decap_8
X_5259_ reg_file_inst.registry\[14\]\[14\] _2909_ _2992_ VGND VGND VPWR VPWR _0797_
+ sky130_fd_sc_hd__mux2_1
XFILLER_56_531 VGND VGND VPWR VPWR sky130_fd_sc_hd__fill_1
XFILLER_56_553 VPWR VGND VPWR VGND sky130_ef_sc_hd__decap_12
XFILLER_16_406 VPWR VGND VPWR VGND sky130_ef_sc_hd__decap_12
XFILLER_28_233 VPWR VGND VPWR VGND sky130_ef_sc_hd__decap_12
XTAP_TAPCELL_ROW_39_751 VGND VPWR sky130_fd_sc_hd__tapvpwrvgnd_1
XTAP_TAPCELL_ROW_104_1565 VGND VPWR sky130_fd_sc_hd__tapvpwrvgnd_1
XFILLER_11_111 VGND VGND VPWR VPWR sky130_fd_sc_hd__fill_1
XFILLER_11_177 VPWR VGND VPWR VGND sky130_ef_sc_hd__decap_12
XFILLER_7_137 VGND VGND VPWR VPWR sky130_fd_sc_hd__decap_8
XTAP_TAPCELL_ROW_59_1000 VGND VPWR sky130_fd_sc_hd__tapvpwrvgnd_1
XFILLER_22_62 VPWR VGND VPWR VGND sky130_ef_sc_hd__decap_12
XFILLER_113_709 VGND VGND VPWR VPWR sky130_fd_sc_hd__fill_1
XFILLER_3_387 VGND VGND VPWR VPWR sky130_fd_sc_hd__decap_4
XFILLER_105_293 VPWR VGND VPWR VGND sky130_ef_sc_hd__decap_12
XFILLER_78_133 VGND VGND VPWR VPWR sky130_fd_sc_hd__decap_6
XFILLER_78_177 VGND VGND VPWR VPWR sky130_fd_sc_hd__fill_1
XFILLER_93_125 VGND VGND VPWR VPWR sky130_fd_sc_hd__fill_1
XFILLER_19_211 VGND VGND VPWR VPWR sky130_fd_sc_hd__decap_3
XFILLER_19_222 VGND VGND VPWR VPWR sky130_fd_sc_hd__fill_2
XFILLER_81_309 VGND VGND VPWR VPWR sky130_fd_sc_hd__fill_1
XFILLER_47_586 VPWR VGND VPWR VGND sky130_ef_sc_hd__decap_12
XFILLER_62_545 VPWR VGND VPWR VGND sky130_ef_sc_hd__decap_12
XFILLER_15_461 VPWR VGND VPWR VGND sky130_ef_sc_hd__decap_12
XTAP_TAPCELL_ROW_17_478 VGND VPWR sky130_fd_sc_hd__tapvpwrvgnd_1
XFILLER_15_494 VGND VGND VPWR VPWR sky130_fd_sc_hd__decap_8
XFILLER_8_20 VGND VGND VPWR VPWR sky130_fd_sc_hd__decap_8
X_4630_ _1867_ _2161_ _2176_ VGND VGND VPWR VPWR _2505_ sky130_fd_sc_hd__o21a_1
XFILLER_8_53 VPWR VGND VPWR VGND sky130_ef_sc_hd__decap_12
X_6300_ clknet_leaf_6_clk _0708_ _0233_ VGND VGND VPWR VPWR reg_file_inst.registry\[3\]\[9\]
+ sky130_fd_sc_hd__dfrtp_1
X_4561_ net136 _2441_ _2440_ VGND VGND VPWR VPWR _2442_ sky130_fd_sc_hd__a21oi_1
XFILLER_116_525 VGND VGND VPWR VPWR sky130_fd_sc_hd__decap_6
X_3512_ reg_file_inst.registry\[9\]\[12\] _1131_ _1436_ _1437_ _1438_ VGND VGND VPWR
+ VPWR _1444_ sky130_fd_sc_hd__a2111o_1
XFILLER_7_671 VGND VGND VPWR VPWR sky130_fd_sc_hd__fill_1
X_4492_ reg_file_inst.registry\[11\]\[6\] _2375_ _2122_ VGND VGND VPWR VPWR _0921_
+ sky130_fd_sc_hd__mux2_1
XFILLER_116_569 VPWR VGND VPWR VGND sky130_ef_sc_hd__decap_12
X_6231_ clknet_leaf_32_clk _0639_ _0164_ VGND VGND VPWR VPWR reg_file_inst.registry\[10\]\[24\]
+ sky130_fd_sc_hd__dfrtp_1
X_3443_ MEMOFF\[16\] _1079_ _1376_ net139 VGND VGND VPWR VPWR _1377_ sky130_fd_sc_hd__a211o_1
X_6162_ clknet_leaf_2_clk _0570_ _0095_ VGND VGND VPWR VPWR JMPOFF\[11\] sky130_fd_sc_hd__dfrtp_4
XFILLER_69_111 VGND VGND VPWR VPWR sky130_fd_sc_hd__fill_1
X_3374_ reg_file_inst.registry\[8\]\[20\] _1114_ net144 VGND VGND VPWR VPWR _1311_
+ sky130_fd_sc_hd__and3_1
X_5113_ _1529_ _1541_ _2285_ VGND VGND VPWR VPWR _2940_ sky130_fd_sc_hd__or3_1
XTAP_TAPCELL_ROW_90_1388 VGND VPWR sky130_fd_sc_hd__tapvpwrvgnd_1
X_6093_ clknet_leaf_23_clk _0501_ _0026_ VGND VGND VPWR VPWR reg_file_inst.registry\[15\]\[26\]
+ sky130_fd_sc_hd__dfrtp_1
X_5044_ _2279_ _2778_ _2880_ VGND VGND VPWR VPWR _2881_ sky130_fd_sc_hd__a21oi_1
XFILLER_72_309 VGND VGND VPWR VPWR sky130_fd_sc_hd__fill_2
XFILLER_25_203 VGND VGND VPWR VPWR sky130_fd_sc_hd__decap_6
XTAP_TAPCELL_ROW_36_710 VGND VPWR sky130_fd_sc_hd__tapvpwrvgnd_1
XFILLER_25_225 VGND VGND VPWR VPWR sky130_fd_sc_hd__fill_2
X_5946_ net147 VGND VGND VPWR VPWR _0354_ sky130_fd_sc_hd__inv_2
X_5877_ net149 VGND VGND VPWR VPWR _0285_ sky130_fd_sc_hd__inv_2
XFILLER_21_431 VGND VGND VPWR VPWR sky130_fd_sc_hd__fill_2
X_4828_ _2216_ _2220_ VGND VGND VPWR VPWR _2687_ sky130_fd_sc_hd__nor2_1
XFILLER_107_503 VGND VGND VPWR VPWR sky130_fd_sc_hd__fill_1
X_4759_ _2616_ _2617_ VGND VGND VPWR VPWR _2618_ sky130_fd_sc_hd__nand2_1
XFILLER_119_385 VGND VGND VPWR VPWR sky130_fd_sc_hd__decap_6
X_6429_ clknet_leaf_24_clk _0837_ _0362_ VGND VGND VPWR VPWR reg_file_inst.registry\[1\]\[26\]
+ sky130_fd_sc_hd__dfrtp_1
XFILLER_122_517 VPWR VGND VPWR VGND sky130_ef_sc_hd__decap_12
XFILLER_108_65 VPWR VGND VPWR VGND sky130_ef_sc_hd__decap_12
XFILLER_68_69 VGND VGND VPWR VPWR sky130_fd_sc_hd__fill_1
XFILLER_0_357 VGND VGND VPWR VPWR sky130_fd_sc_hd__fill_2
XFILLER_76_637 VGND VGND VPWR VPWR sky130_fd_sc_hd__fill_1
XFILLER_75_125 VGND VGND VPWR VPWR sky130_fd_sc_hd__decap_8
XFILLER_84_24 VGND VGND VPWR VPWR sky130_fd_sc_hd__fill_1
XFILLER_75_169 VPWR VGND VPWR VGND sky130_ef_sc_hd__decap_12
XFILLER_91_629 VPWR VGND VPWR VGND sky130_ef_sc_hd__decap_12
XFILLER_84_681 VPWR VGND VPWR VGND sky130_ef_sc_hd__decap_12
XFILLER_29_597 VGND VGND VPWR VPWR sky130_fd_sc_hd__decap_4
XFILLER_44_589 VPWR VGND VPWR VGND sky130_ef_sc_hd__decap_12
XTAP_TAPCELL_ROW_65_1081 VGND VPWR sky130_fd_sc_hd__tapvpwrvgnd_1
XTAP_TAPCELL_ROW_14_437 VGND VPWR sky130_fd_sc_hd__tapvpwrvgnd_1
XFILLER_12_442 VGND VGND VPWR VPWR sky130_fd_sc_hd__decap_6
XTAP_TAPCELL_ROW_117_1723 VGND VPWR sky130_fd_sc_hd__tapvpwrvgnd_1
XFILLER_8_457 VPWR VGND VPWR VGND sky130_ef_sc_hd__decap_12
XFILLER_113_517 VPWR VGND VPWR VGND sky130_ef_sc_hd__decap_12
XFILLER_98_217 VPWR VGND VPWR VGND sky130_ef_sc_hd__decap_12
XFILLER_79_442 VGND VGND VPWR VPWR sky130_fd_sc_hd__decap_6
XFILLER_79_420 VPWR VGND VPWR VGND sky130_ef_sc_hd__decap_12
XFILLER_3_173 VGND VGND VPWR VPWR sky130_fd_sc_hd__fill_1
XFILLER_121_561 VPWR VGND VPWR VGND sky130_ef_sc_hd__decap_12
XFILLER_67_615 VGND VGND VPWR VPWR sky130_fd_sc_hd__fill_1
X_3090_ JMPOFF\[10\] _0967_ VGND VGND VPWR VPWR _1034_ sky130_fd_sc_hd__nand2_1
XFILLER_54_309 VPWR VGND VPWR VGND sky130_ef_sc_hd__decap_12
XFILLER_62_375 VGND VGND VPWR VPWR sky130_fd_sc_hd__decap_6
XFILLER_22_206 VGND VGND VPWR VPWR sky130_fd_sc_hd__decap_8
X_3992_ _1906_ _1907_ VGND VGND VPWR VPWR _1908_ sky130_fd_sc_hd__or2_1
X_5800_ net148 VGND VGND VPWR VPWR _0208_ sky130_fd_sc_hd__inv_2
X_5731_ net44 VGND VGND VPWR VPWR _0139_ sky130_fd_sc_hd__inv_2
XFILLER_22_239 VGND VGND VPWR VPWR sky130_fd_sc_hd__decap_6
XFILLER_50_526 VGND VGND VPWR VPWR sky130_fd_sc_hd__decap_6
X_5662_ net147 VGND VGND VPWR VPWR _0070_ sky130_fd_sc_hd__inv_2
X_4613_ _2283_ _2288_ _1802_ VGND VGND VPWR VPWR _2490_ sky130_fd_sc_hd__mux2_1
X_5593_ net149 VGND VGND VPWR VPWR _0001_ sky130_fd_sc_hd__inv_2
X_4544_ _2349_ _2421_ net135 VGND VGND VPWR VPWR _2425_ sky130_fd_sc_hd__mux2_1
XFILLER_116_333 VPWR VGND VPWR VGND sky130_ef_sc_hd__decap_12
XTAP_TAPCELL_ROW_92_1417 VGND VPWR sky130_fd_sc_hd__tapvpwrvgnd_1
Xmax_cap143 net144 VGND VGND VPWR VPWR net143 sky130_fd_sc_hd__buf_6
XFILLER_7_490 VPWR VGND VPWR VGND sky130_ef_sc_hd__decap_12
Xmax_cap132 _1841_ VGND VGND VPWR VPWR net132 sky130_fd_sc_hd__clkbuf_8
XFILLER_116_377 VPWR VGND VPWR VGND sky130_ef_sc_hd__decap_12
X_6214_ clknet_leaf_41_clk _0622_ _0147_ VGND VGND VPWR VPWR reg_file_inst.registry\[10\]\[7\]
+ sky130_fd_sc_hd__dfrtp_1
X_4475_ _2355_ _2359_ _1817_ VGND VGND VPWR VPWR _2360_ sky130_fd_sc_hd__mux2_1
X_3426_ reg_file_inst.registry\[10\]\[18\] _1123_ net143 VGND VGND VPWR VPWR _1361_
+ sky130_fd_sc_hd__and3_1
XFILLER_100_701 VPWR VGND VPWR VGND sky130_ef_sc_hd__decap_12
X_6145_ clknet_leaf_35_clk _0553_ _0078_ VGND VGND VPWR VPWR reg_file_inst.registry\[6\]\[22\]
+ sky130_fd_sc_hd__dfrtp_1
X_3357_ MEMOFF\[21\] net86 _1113_ VGND VGND VPWR VPWR _1294_ sky130_fd_sc_hd__mux2_4
XFILLER_58_604 VGND VGND VPWR VPWR sky130_fd_sc_hd__fill_1
X_6076_ clknet_leaf_7_clk _0484_ _0009_ VGND VGND VPWR VPWR reg_file_inst.registry\[15\]\[9\]
+ sky130_fd_sc_hd__dfrtp_1
X_3288_ reg_file_inst.registry\[8\]\[23\] _1090_ _1092_ reg_file_inst.registry\[4\]\[23\]
+ VGND VGND VPWR VPWR _1228_ sky130_fd_sc_hd__a22o_1
XFILLER_57_169 VPWR VGND VPWR VGND sky130_ef_sc_hd__decap_12
X_5027_ _1403_ _2123_ _2286_ _1418_ _2288_ VGND VGND VPWR VPWR _2866_ sky130_fd_sc_hd__a221o_1
XFILLER_72_139 VGND VGND VPWR VPWR sky130_fd_sc_hd__fill_1
XFILLER_54_38 VPWR VGND VPWR VGND sky130_ef_sc_hd__decap_12
XFILLER_54_27 VGND VGND VPWR VPWR sky130_fd_sc_hd__fill_1
XFILLER_38_383 VPWR VGND VPWR VGND sky130_ef_sc_hd__decap_12
XFILLER_81_673 VPWR VGND VPWR VGND sky130_ef_sc_hd__decap_12
XFILLER_26_589 VPWR VGND VPWR VGND sky130_ef_sc_hd__decap_12
XTAP_TAPCELL_ROW_101_1524 VGND VPWR sky130_fd_sc_hd__tapvpwrvgnd_1
XFILLER_110_77 VGND VGND VPWR VPWR sky130_fd_sc_hd__decap_6
XFILLER_70_15 VPWR VGND VPWR VGND sky130_ef_sc_hd__decap_12
X_5929_ net149 VGND VGND VPWR VPWR _0337_ sky130_fd_sc_hd__inv_2
XFILLER_70_37 VGND VGND VPWR VPWR sky130_fd_sc_hd__fill_2
XTAP_TAPCELL_ROW_11_407 VGND VPWR sky130_fd_sc_hd__tapvpwrvgnd_1
XFILLER_119_193 VPWR VGND VPWR VGND sky130_ef_sc_hd__decap_12
XFILLER_102_3 VPWR VGND VPWR VGND sky130_ef_sc_hd__decap_12
XFILLER_79_79 VGND VGND VPWR VPWR sky130_fd_sc_hd__fill_1
XFILLER_0_110 VGND VGND VPWR VPWR sky130_fd_sc_hd__fill_2
XTAP_TAPCELL_ROW_112_1664 VGND VPWR sky130_fd_sc_hd__tapvpwrvgnd_1
XFILLER_103_561 VPWR VGND VPWR VGND sky130_ef_sc_hd__decap_12
XFILLER_88_250 VGND VGND VPWR VPWR sky130_fd_sc_hd__fill_2
XFILLER_76_401 VGND VGND VPWR VPWR sky130_fd_sc_hd__decap_8
XFILLER_49_626 VGND VGND VPWR VPWR sky130_fd_sc_hd__decap_8
XFILLER_95_78 VPWR VGND VPWR VGND sky130_ef_sc_hd__decap_12
XTAP_TAPCELL_ROW_19_507 VGND VPWR sky130_fd_sc_hd__tapvpwrvgnd_1
XFILLER_28_83 VGND VGND VPWR VPWR sky130_fd_sc_hd__fill_1
XTAP_TAPCELL_ROW_47_849 VGND VPWR sky130_fd_sc_hd__tapvpwrvgnd_1
XFILLER_44_353 VGND VGND VPWR VPWR sky130_fd_sc_hd__decap_8
XFILLER_71_161 VGND VGND VPWR VPWR sky130_fd_sc_hd__decap_6
XFILLER_8_221 VPWR VGND VPWR VGND sky130_ef_sc_hd__decap_12
XFILLER_40_581 VGND VGND VPWR VPWR sky130_fd_sc_hd__decap_6
XFILLER_8_265 VGND VGND VPWR VPWR sky130_fd_sc_hd__decap_8
XFILLER_5_65 VGND VGND VPWR VPWR sky130_fd_sc_hd__decap_3
X_4260_ _1709_ _2147_ VGND VGND VPWR VPWR _2148_ sky130_fd_sc_hd__xnor2_1
X_3211_ reg_file_inst.registry\[14\]\[26\] _1081_ _1087_ reg_file_inst.registry\[1\]\[26\]
+ _1153_ VGND VGND VPWR VPWR _1154_ sky130_fd_sc_hd__a221o_1
X_4191_ _2092_ net106 net130 VGND VGND VPWR VPWR _0935_ sky130_fd_sc_hd__mux2_1
X_3142_ _1084_ _1085_ VGND VGND VPWR VPWR _1086_ sky130_fd_sc_hd__and2_4
XFILLER_121_391 VGND VGND VPWR VPWR sky130_fd_sc_hd__fill_1
XFILLER_94_253 VPWR VGND VPWR VGND sky130_ef_sc_hd__decap_12
XFILLER_67_445 VGND VGND VPWR VPWR sky130_fd_sc_hd__decap_3
XFILLER_55_629 VGND VGND VPWR VPWR sky130_fd_sc_hd__fill_2
X_3073_ _1016_ VGND VGND VPWR VPWR _1017_ sky130_fd_sc_hd__inv_2
XFILLER_39_169 VPWR VGND VPWR VGND sky130_ef_sc_hd__decap_12
XFILLER_90_470 VGND VGND VPWR VPWR sky130_fd_sc_hd__decap_6
XFILLER_62_194 VGND VGND VPWR VPWR sky130_fd_sc_hd__fill_2
X_3975_ net109 net131 _1889_ _1890_ VGND VGND VPWR VPWR _1891_ sky130_fd_sc_hd__nand4_1
X_5714_ net149 VGND VGND VPWR VPWR _0122_ sky130_fd_sc_hd__inv_2
XFILLER_109_609 VGND VGND VPWR VPWR sky130_fd_sc_hd__decap_6
X_5645_ net148 VGND VGND VPWR VPWR _0053_ sky130_fd_sc_hd__inv_2
XFILLER_40_18 VGND VGND VPWR VPWR sky130_fd_sc_hd__decap_8
XFILLER_117_653 VPWR VGND VPWR VGND sky130_ef_sc_hd__decap_12
X_5576_ reg_file_inst.registry\[15\]\[16\] _2883_ _3003_ VGND VGND VPWR VPWR _0491_
+ sky130_fd_sc_hd__mux2_1
XFILLER_117_697 VPWR VGND VPWR VGND sky130_ef_sc_hd__decap_12
XFILLER_116_141 VPWR VGND VPWR VGND sky130_ef_sc_hd__decap_12
XFILLER_2_408 VPWR VGND VPWR VGND sky130_ef_sc_hd__decap_12
X_4527_ _1751_ _2282_ VGND VGND VPWR VPWR _2410_ sky130_fd_sc_hd__or2_1
X_4458_ net132 _2198_ VGND VGND VPWR VPWR _2343_ sky130_fd_sc_hd__nor2_1
X_3409_ _1340_ _1341_ _1344_ _1118_ reg_file_inst.registry\[0\]\[19\] VGND VGND VPWR
+ VPWR net83 sky130_fd_sc_hd__o32a_2
X_6128_ clknet_leaf_28_clk _0536_ _0061_ VGND VGND VPWR VPWR reg_file_inst.registry\[6\]\[5\]
+ sky130_fd_sc_hd__dfrtp_1
X_4389_ _2129_ _2276_ VGND VGND VPWR VPWR _2277_ sky130_fd_sc_hd__nor2_4
XFILLER_105_55 VGND VGND VPWR VPWR sky130_fd_sc_hd__fill_1
XFILLER_58_456 VGND VGND VPWR VPWR sky130_fd_sc_hd__decap_3
XFILLER_73_426 VGND VGND VPWR VPWR sky130_fd_sc_hd__decap_8
X_6059_ net146 VGND VGND VPWR VPWR _0467_ sky130_fd_sc_hd__inv_2
XFILLER_18_309 VGND VGND VPWR VPWR sky130_fd_sc_hd__fill_1
XFILLER_14_504 VPWR VGND VPWR VGND sky130_ef_sc_hd__decap_12
XFILLER_26_342 VPWR VGND VPWR VGND sky130_ef_sc_hd__decap_12
XTAP_TAPCELL_ROW_44_808 VGND VPWR sky130_fd_sc_hd__tapvpwrvgnd_1
XTAP_TAPCELL_ROW_44_819 VGND VPWR sky130_fd_sc_hd__tapvpwrvgnd_1
XFILLER_26_386 VPWR VGND VPWR VGND sky130_ef_sc_hd__decap_12
XFILLER_81_69 VPWR VGND VPWR VGND sky130_ef_sc_hd__decap_12
XFILLER_41_345 VGND VGND VPWR VPWR sky130_fd_sc_hd__fill_1
XTAP_TAPCELL_ROW_62_1040 VGND VPWR sky130_fd_sc_hd__tapvpwrvgnd_1
XFILLER_14_41 VPWR VGND VPWR VGND sky130_ef_sc_hd__decap_12
XTAP_TAPCELL_ROW_24_565 VGND VPWR sky130_fd_sc_hd__tapvpwrvgnd_1
XFILLER_10_721 VGND VGND VPWR VPWR sky130_fd_sc_hd__fill_2
XFILLER_14_74 VGND VGND VPWR VPWR sky130_fd_sc_hd__decap_8
XFILLER_14_85 VPWR VGND VPWR VGND sky130_ef_sc_hd__decap_12
XFILLER_22_581 VGND VGND VPWR VPWR sky130_fd_sc_hd__decap_6
XFILLER_6_725 VGND VGND VPWR VPWR sky130_fd_sc_hd__fill_1
XFILLER_30_62 VGND VGND VPWR VPWR sky130_fd_sc_hd__decap_6
XFILLER_89_581 VGND VGND VPWR VPWR sky130_fd_sc_hd__decap_4
XTAP_TAPCELL_ROW_73_1180 VGND VPWR sky130_fd_sc_hd__tapvpwrvgnd_1
XFILLER_39_93 VPWR VGND VPWR VGND sky130_ef_sc_hd__decap_12
XFILLER_92_713 VPWR VGND VPWR VGND sky130_ef_sc_hd__decap_12
XFILLER_76_253 VGND VGND VPWR VPWR sky130_fd_sc_hd__fill_1
XFILLER_49_489 VGND VGND VPWR VPWR sky130_fd_sc_hd__decap_8
XFILLER_36_128 VPWR VGND VPWR VGND sky130_ef_sc_hd__decap_12
XFILLER_51_109 VGND VGND VPWR VPWR sky130_fd_sc_hd__decap_3
XFILLER_45_673 VPWR VGND VPWR VGND sky130_ef_sc_hd__decap_12
XFILLER_60_643 VGND VGND VPWR VPWR sky130_fd_sc_hd__fill_1
XFILLER_60_687 VPWR VGND VPWR VGND sky130_ef_sc_hd__decap_12
XFILLER_32_389 VGND VGND VPWR VPWR sky130_fd_sc_hd__decap_8
X_3760_ _1681_ _1682_ VGND VGND VPWR VPWR _1683_ sky130_fd_sc_hd__or2_1
X_5430_ _2873_ reg_file_inst.registry\[10\]\[17\] _2998_ VGND VGND VPWR VPWR _0632_
+ sky130_fd_sc_hd__mux2_1
XFILLER_9_585 VPWR VGND VPWR VGND sky130_ef_sc_hd__decap_12
X_3691_ reg_file_inst.registry\[9\]\[8\] _1125_ _1127_ VGND VGND VPWR VPWR _1616_
+ sky130_fd_sc_hd__and3_1
XTAP_TAPCELL_ROW_76_1209 VGND VPWR sky130_fd_sc_hd__tapvpwrvgnd_1
XFILLER_65_3 VGND VGND VPWR VPWR sky130_fd_sc_hd__decap_8
XFILLER_114_601 VPWR VGND VPWR VGND sky130_ef_sc_hd__decap_12
X_5361_ _1128_ _2991_ VGND VGND VPWR VPWR _2996_ sky130_fd_sc_hd__nor2_8
XFILLER_114_645 VPWR VGND VPWR VGND sky130_ef_sc_hd__decap_12
XFILLER_113_111 VGND VGND VPWR VPWR sky130_fd_sc_hd__fill_1
X_5292_ _2960_ reg_file_inst.registry\[2\]\[10\] _2993_ VGND VGND VPWR VPWR _0765_
+ sky130_fd_sc_hd__mux2_1
X_4312_ _2197_ _2199_ VGND VGND VPWR VPWR _2200_ sky130_fd_sc_hd__nor2_1
XFILLER_4_290 VPWR VGND VPWR VGND sky130_ef_sc_hd__decap_12
X_4243_ _1764_ _1790_ _1816_ _1840_ VGND VGND VPWR VPWR _2131_ sky130_fd_sc_hd__or4_2
XFILLER_95_551 VGND VGND VPWR VPWR sky130_fd_sc_hd__decap_8
X_4174_ _2080_ net111 net130 VGND VGND VPWR VPWR _0940_ sky130_fd_sc_hd__mux2_1
XFILLER_95_573 VPWR VGND VPWR VGND sky130_ef_sc_hd__decap_12
X_3125_ _0984_ _0988_ _0989_ _1068_ VGND VGND VPWR VPWR _1069_ sky130_fd_sc_hd__or4_1
XFILLER_67_253 VGND VGND VPWR VPWR sky130_fd_sc_hd__decap_4
XFILLER_28_618 VGND VGND VPWR VPWR sky130_fd_sc_hd__decap_8
XTAP_TAPCELL_ROW_87_1349 VGND VPWR sky130_fd_sc_hd__tapvpwrvgnd_1
XFILLER_55_437 VGND VGND VPWR VPWR sky130_fd_sc_hd__decap_8
X_3056_ net39 _0998_ VGND VGND VPWR VPWR _1000_ sky130_fd_sc_hd__xnor2_1
XFILLER_35_18 VPWR VGND VPWR VGND sky130_ef_sc_hd__decap_12
XFILLER_36_695 VGND VGND VPWR VPWR sky130_fd_sc_hd__decap_4
XFILLER_50_131 VGND VGND VPWR VPWR sky130_fd_sc_hd__fill_1
XTAP_TAPCELL_ROW_21_524 VGND VPWR sky130_fd_sc_hd__tapvpwrvgnd_1
X_3958_ net43 net42 VGND VGND VPWR VPWR _1874_ sky130_fd_sc_hd__nand2_1
XFILLER_109_417 VPWR VGND VPWR VGND sky130_ef_sc_hd__decap_12
X_3889_ reg_file_inst.registry\[9\]\[1\] _1078_ _1088_ VGND VGND VPWR VPWR _1807_
+ sky130_fd_sc_hd__and3_1
XTAP_TAPCELL_ROW_98_1489 VGND VPWR sky130_fd_sc_hd__tapvpwrvgnd_1
X_5628_ net146 VGND VGND VPWR VPWR _0036_ sky130_fd_sc_hd__inv_2
XFILLER_117_461 VPWR VGND VPWR VGND sky130_ef_sc_hd__decap_12
X_5559_ _2455_ reg_file_inst.registry\[9\]\[4\] _3002_ VGND VGND VPWR VPWR _0507_
+ sky130_fd_sc_hd__mux2_1
XFILLER_104_144 VPWR VGND VPWR VGND sky130_ef_sc_hd__decap_12
XFILLER_2_249 VGND VGND VPWR VPWR sky130_fd_sc_hd__decap_3
XFILLER_120_637 VGND VGND VPWR VPWR sky130_fd_sc_hd__decap_6
XFILLER_116_65 VPWR VGND VPWR VGND sky130_ef_sc_hd__decap_12
XFILLER_104_188 VGND VGND VPWR VPWR sky130_fd_sc_hd__decap_8
XFILLER_58_242 VGND VGND VPWR VPWR sky130_fd_sc_hd__decap_8
XFILLER_100_350 VPWR VGND VPWR VGND sky130_ef_sc_hd__decap_12
XFILLER_73_201 VGND VGND VPWR VPWR sky130_fd_sc_hd__fill_2
XFILLER_58_253 VGND VGND VPWR VPWR sky130_fd_sc_hd__decap_8
XFILLER_19_629 VGND VGND VPWR VPWR sky130_fd_sc_hd__decap_4
XFILLER_18_128 VPWR VGND VPWR VGND sky130_ef_sc_hd__decap_12
XTAP_TAPCELL_ROW_29_624 VGND VPWR sky130_fd_sc_hd__tapvpwrvgnd_1
XTAP_TAPCELL_ROW_57_977 VGND VPWR sky130_fd_sc_hd__tapvpwrvgnd_1
XFILLER_27_640 VGND VGND VPWR VPWR sky130_fd_sc_hd__decap_4
XTAP_TAPCELL_ROW_1_271 VGND VPWR sky130_fd_sc_hd__tapvpwrvgnd_1
XTAP_TAPCELL_ROW_1_282 VGND VPWR sky130_fd_sc_hd__tapvpwrvgnd_1
XFILLER_27_673 VGND VGND VPWR VPWR sky130_fd_sc_hd__decap_8
XTAP_TAPCELL_ROW_107_1596 VGND VPWR sky130_fd_sc_hd__tapvpwrvgnd_1
XTAP_TAPCELL_ROW_120_1763 VGND VPWR sky130_fd_sc_hd__tapvpwrvgnd_1
XFILLER_42_698 VGND VGND VPWR VPWR sky130_fd_sc_hd__fill_2
XFILLER_6_533 VPWR VGND VPWR VGND sky130_ef_sc_hd__decap_12
XFILLER_111_615 VGND VGND VPWR VPWR sky130_fd_sc_hd__fill_1
XTAP_TAPCELL_ROW_9_382 VGND VPWR sky130_fd_sc_hd__tapvpwrvgnd_1
XTAP_TAPCELL_ROW_9_371 VGND VPWR sky130_fd_sc_hd__tapvpwrvgnd_1
XFILLER_96_359 VGND VGND VPWR VPWR sky130_fd_sc_hd__decap_4
XFILLER_2_77 VGND VGND VPWR VPWR sky130_fd_sc_hd__decap_6
XFILLER_37_415 VGND VGND VPWR VPWR sky130_fd_sc_hd__decap_8
XFILLER_64_234 VGND VGND VPWR VPWR sky130_fd_sc_hd__fill_1
XFILLER_92_554 VPWR VGND VPWR VGND sky130_ef_sc_hd__decap_12
XFILLER_66_91 VGND VGND VPWR VPWR sky130_fd_sc_hd__fill_1
X_4930_ _2321_ _2743_ net135 VGND VGND VPWR VPWR _2783_ sky130_fd_sc_hd__mux2_1
X_4861_ _1764_ _2485_ _2237_ VGND VGND VPWR VPWR _2718_ sky130_fd_sc_hd__o21ai_1
XFILLER_32_120 VPWR VGND VPWR VGND sky130_ef_sc_hd__decap_12
XFILLER_82_90 VPWR VGND VPWR VGND sky130_ef_sc_hd__decap_12
XFILLER_60_473 VGND VGND VPWR VPWR sky130_fd_sc_hd__decap_3
X_3812_ reg_file_inst.registry\[14\]\[5\] _1081_ _1092_ reg_file_inst.registry\[4\]\[5\]
+ _1725_ VGND VGND VPWR VPWR _1733_ sky130_fd_sc_hd__a221o_1
XFILLER_20_315 VGND VGND VPWR VPWR sky130_fd_sc_hd__fill_1
XFILLER_32_153 VGND VGND VPWR VPWR sky130_fd_sc_hd__decap_4
XFILLER_32_164 VPWR VGND VPWR VGND sky130_ef_sc_hd__decap_12
XFILLER_33_687 VPWR VGND VPWR VGND sky130_ef_sc_hd__decap_12
XPHY_EDGE_ROW_120_Right_120 VGND VGND VPWR VPWR sky130_fd_sc_hd__decap_3
XANTENNA_27 _1123_ VGND VGND VPWR VPWR sky130_fd_sc_hd__diode_2
X_4792_ _2650_ _2644_ _2638_ _2647_ VGND VGND VPWR VPWR _2651_ sky130_fd_sc_hd__and4bb_1
XANTENNA_16 net70 VGND VGND VPWR VPWR sky130_fd_sc_hd__diode_2
XFILLER_20_337 VGND VGND VPWR VPWR sky130_fd_sc_hd__fill_1
XFILLER_32_197 VPWR VGND VPWR VGND sky130_ef_sc_hd__decap_12
X_3743_ reg_file_inst.registry\[0\]\[7\] _1118_ _1662_ _1666_ VGND VGND VPWR VPWR
+ net98 sky130_fd_sc_hd__o22a_2
X_6531_ clknet_leaf_48_clk _0939_ _0464_ VGND VGND VPWR VPWR net110 sky130_fd_sc_hd__dfrtp_1
XFILLER_20_359 VGND VGND VPWR VPWR sky130_fd_sc_hd__decap_4
X_6462_ clknet_leaf_33_clk _0870_ _0395_ VGND VGND VPWR VPWR reg_file_inst.registry\[0\]\[23\]
+ sky130_fd_sc_hd__dfrtp_1
XFILLER_9_382 VGND VGND VPWR VPWR sky130_fd_sc_hd__decap_8
X_3674_ reg_file_inst.registry\[6\]\[8\] _1080_ _1084_ VGND VGND VPWR VPWR _1599_
+ sky130_fd_sc_hd__and3_1
Xoutput101 net101 VGND VGND VPWR VPWR DmemReadEn sky130_fd_sc_hd__buf_1
X_6393_ clknet_leaf_14_clk _0801_ _0326_ VGND VGND VPWR VPWR reg_file_inst.registry\[14\]\[18\]
+ sky130_fd_sc_hd__dfrtp_1
X_5413_ reg_file_inst.registry\[4\]\[5\] _2419_ _2997_ VGND VGND VPWR VPWR _0648_
+ sky130_fd_sc_hd__mux2_1
X_5344_ _2883_ reg_file_inst.registry\[3\]\[16\] _2995_ VGND VGND VPWR VPWR _0715_
+ sky130_fd_sc_hd__mux2_1
Xoutput112 net112 VGND VGND VPWR VPWR IC[19] sky130_fd_sc_hd__buf_1
Xoutput123 net123 VGND VGND VPWR VPWR IC[3] sky130_fd_sc_hd__buf_1
XFILLER_114_475 VGND VGND VPWR VPWR sky130_fd_sc_hd__fill_1
XFILLER_102_637 VGND VGND VPWR VPWR sky130_fd_sc_hd__decap_6
X_5275_ _2715_ reg_file_inst.registry\[2\]\[27\] _2993_ VGND VGND VPWR VPWR _0782_
+ sky130_fd_sc_hd__mux2_1
XFILLER_101_125 VGND VGND VPWR VPWR sky130_fd_sc_hd__decap_3
XFILLER_99_197 VGND VGND VPWR VPWR sky130_fd_sc_hd__fill_2
XFILLER_87_337 VPWR VGND VPWR VGND sky130_ef_sc_hd__decap_12
X_4226_ net34 net130 net102 _2113_ VGND VGND VPWR VPWR _2114_ sky130_fd_sc_hd__or4b_1
XFILLER_101_169 VGND VGND VPWR VPWR sky130_fd_sc_hd__decap_8
X_4157_ _2069_ net118 net130 VGND VGND VPWR VPWR _0946_ sky130_fd_sc_hd__mux2_1
XFILLER_110_681 VPWR VGND VPWR VGND sky130_ef_sc_hd__decap_12
XFILLER_55_223 VGND VGND VPWR VPWR sky130_fd_sc_hd__fill_1
X_3108_ _1044_ _1047_ _1049_ _1051_ VGND VGND VPWR VPWR _1052_ sky130_fd_sc_hd__or4_1
X_4088_ _2003_ VGND VGND VPWR VPWR _2004_ sky130_fd_sc_hd__inv_2
XFILLER_83_598 VPWR VGND VPWR VGND sky130_ef_sc_hd__decap_12
X_3039_ JMPOFF\[23\] net141 net41 VGND VGND VPWR VPWR _0983_ sky130_fd_sc_hd__a21o_1
XFILLER_55_289 VGND VGND VPWR VPWR sky130_fd_sc_hd__fill_2
XTAP_TAPCELL_ROW_54_936 VGND VPWR sky130_fd_sc_hd__tapvpwrvgnd_1
XFILLER_51_440 VGND VGND VPWR VPWR sky130_fd_sc_hd__decap_8
XFILLER_24_665 VPWR VGND VPWR VGND sky130_ef_sc_hd__decap_12
XFILLER_11_337 VGND VGND VPWR VPWR sky130_fd_sc_hd__fill_1
XFILLER_11_315 VPWR VGND VPWR VGND sky130_ef_sc_hd__decap_12
XTAP_TAPCELL_ROW_34_693 VGND VPWR sky130_fd_sc_hd__tapvpwrvgnd_1
XFILLER_109_225 VPWR VGND VPWR VGND sky130_ef_sc_hd__decap_12
XFILLER_120_401 VPWR VGND VPWR VGND sky130_ef_sc_hd__decap_12
XFILLER_105_497 VGND VGND VPWR VPWR sky130_fd_sc_hd__decap_6
XFILLER_87_57 VGND VGND VPWR VPWR sky130_fd_sc_hd__fill_2
XFILLER_120_445 VPWR VGND VPWR VGND sky130_ef_sc_hd__decap_12
XTAP_TAPCELL_ROW_6_341 VGND VPWR sky130_fd_sc_hd__tapvpwrvgnd_1
XFILLER_120_489 VPWR VGND VPWR VGND sky130_ef_sc_hd__decap_12
XFILLER_59_573 VGND VGND VPWR VPWR sky130_fd_sc_hd__decap_8
XTAP_TAPCELL_ROW_109_1625 VGND VPWR sky130_fd_sc_hd__tapvpwrvgnd_1
XFILLER_74_510 VPWR VGND VPWR VGND sky130_ef_sc_hd__decap_12
XFILLER_19_415 VGND VGND VPWR VPWR sky130_fd_sc_hd__decap_8
XFILLER_62_705 VGND VGND VPWR VPWR sky130_fd_sc_hd__fill_1
XFILLER_46_245 VGND VGND VPWR VPWR sky130_fd_sc_hd__decap_6
XTAP_TAPCELL_ROW_122_1803 VGND VPWR sky130_fd_sc_hd__tapvpwrvgnd_1
XFILLER_27_470 VGND VGND VPWR VPWR sky130_fd_sc_hd__decap_6
XFILLER_34_418 VGND VGND VPWR VPWR sky130_fd_sc_hd__fill_2
XFILLER_14_131 VGND VGND VPWR VPWR sky130_fd_sc_hd__decap_8
XFILLER_14_197 VGND VGND VPWR VPWR sky130_fd_sc_hd__decap_8
Xinput36 instr[2] VGND VGND VPWR VPWR net36 sky130_fd_sc_hd__clkbuf_8
Xinput25 DataMemoryRead[6] VGND VGND VPWR VPWR net25 sky130_fd_sc_hd__buf_1
Xinput14 DataMemoryRead[21] VGND VGND VPWR VPWR net14 sky130_fd_sc_hd__buf_1
XFILLER_115_217 VGND VGND VPWR VPWR sky130_fd_sc_hd__decap_6
X_3390_ MEMOFF\[19\] _1079_ _1093_ reg_file_inst.registry\[15\]\[19\] VGND VGND VPWR
+ VPWR _1326_ sky130_fd_sc_hd__a22o_1
XFILLER_69_326 VGND VGND VPWR VPWR sky130_fd_sc_hd__decap_6
X_5060_ _2129_ _2894_ _2721_ VGND VGND VPWR VPWR _2895_ sky130_fd_sc_hd__o21a_1
XFILLER_96_167 VGND VGND VPWR VPWR sky130_fd_sc_hd__fill_2
X_4011_ _0993_ _0994_ _0995_ _1023_ VGND VGND VPWR VPWR _1927_ sky130_fd_sc_hd__a211oi_1
XFILLER_38_713 VGND VGND VPWR VPWR sky130_fd_sc_hd__decap_3
XFILLER_92_351 VPWR VGND VPWR VGND sky130_ef_sc_hd__decap_12
XTAP_TAPCELL_ROW_84_1308 VGND VPWR sky130_fd_sc_hd__tapvpwrvgnd_1
XFILLER_92_384 VGND VGND VPWR VPWR sky130_fd_sc_hd__fill_2
XTAP_TAPCELL_ROW_84_1319 VGND VPWR sky130_fd_sc_hd__tapvpwrvgnd_1
X_5962_ net149 VGND VGND VPWR VPWR _0370_ sky130_fd_sc_hd__inv_2
XFILLER_52_215 VPWR VGND VPWR VGND sky130_ef_sc_hd__decap_12
XFILLER_18_470 VGND VGND VPWR VPWR sky130_fd_sc_hd__decap_6
XFILLER_92_395 VGND VGND VPWR VPWR sky130_fd_sc_hd__fill_2
X_4913_ net18 net101 net62 _2308_ VGND VGND VPWR VPWR _2767_ sky130_fd_sc_hd__a22o_4
X_5893_ net146 VGND VGND VPWR VPWR _0301_ sky130_fd_sc_hd__inv_2
XTAP_TAPCELL_ROW_51_906 VGND VPWR sky130_fd_sc_hd__tapvpwrvgnd_1
XFILLER_33_473 VPWR VGND VPWR VGND sky130_ef_sc_hd__decap_12
XFILLER_60_270 VGND VGND VPWR VPWR sky130_fd_sc_hd__decap_4
X_4844_ _1152_ _2286_ _2456_ _2698_ _2702_ VGND VGND VPWR VPWR _2703_ sky130_fd_sc_hd__a221o_1
X_4775_ _1480_ _2557_ VGND VGND VPWR VPWR _2634_ sky130_fd_sc_hd__xnor2_1
XTAP_TAPCELL_ROW_31_652 VGND VPWR sky130_fd_sc_hd__tapvpwrvgnd_1
X_3726_ reg_file_inst.registry\[1\]\[7\] _1087_ _1097_ reg_file_inst.registry\[5\]\[7\]
+ _1649_ VGND VGND VPWR VPWR _1650_ sky130_fd_sc_hd__a221o_1
X_6514_ clknet_leaf_45_clk _0922_ _0447_ VGND VGND VPWR VPWR reg_file_inst.registry\[11\]\[7\]
+ sky130_fd_sc_hd__dfrtp_1
XTAP_TAPCELL_ROW_95_1448 VGND VPWR sky130_fd_sc_hd__tapvpwrvgnd_1
X_3657_ reg_file_inst.registry\[0\]\[9\] _1118_ VGND VGND VPWR VPWR _1583_ sky130_fd_sc_hd__or2_1
X_6445_ clknet_leaf_3_clk _0853_ _0378_ VGND VGND VPWR VPWR reg_file_inst.registry\[0\]\[6\]
+ sky130_fd_sc_hd__dfrtp_1
X_3588_ _1515_ VGND VGND VPWR VPWR _1516_ sky130_fd_sc_hd__inv_2
X_6376_ clknet_leaf_58_clk _0784_ _0309_ VGND VGND VPWR VPWR reg_file_inst.registry\[14\]\[1\]
+ sky130_fd_sc_hd__dfrtp_1
X_5327_ _2455_ reg_file_inst.registry\[8\]\[4\] _2994_ VGND VGND VPWR VPWR _0731_
+ sky130_fd_sc_hd__mux2_1
XFILLER_88_657 VPWR VGND VPWR VGND sky130_ef_sc_hd__decap_12
X_5258_ reg_file_inst.registry\[14\]\[15\] _2897_ _2992_ VGND VGND VPWR VPWR _0798_
+ sky130_fd_sc_hd__mux2_1
XFILLER_75_318 VGND VGND VPWR VPWR sky130_fd_sc_hd__fill_1
XTAP_TAPCELL_ROW_3_300 VGND VPWR sky130_fd_sc_hd__tapvpwrvgnd_1
X_5189_ _2883_ reg_file_inst.registry\[0\]\[16\] _2988_ VGND VGND VPWR VPWR _0863_
+ sky130_fd_sc_hd__mux2_1
X_4209_ _2103_ net126 net130 VGND VGND VPWR VPWR _0928_ sky130_fd_sc_hd__mux2_1
XFILLER_29_724 VGND VGND VPWR VPWR sky130_fd_sc_hd__fill_2
XFILLER_113_55 VGND VGND VPWR VPWR sky130_fd_sc_hd__fill_1
XFILLER_56_565 VPWR VGND VPWR VGND sky130_ef_sc_hd__decap_12
XFILLER_28_245 VGND VGND VPWR VPWR sky130_fd_sc_hd__decap_6
XTAP_TAPCELL_ROW_39_752 VGND VPWR sky130_fd_sc_hd__tapvpwrvgnd_1
XFILLER_73_15 VPWR VGND VPWR VGND sky130_ef_sc_hd__decap_12
XFILLER_16_418 VGND VGND VPWR VPWR sky130_fd_sc_hd__fill_2
XFILLER_16_429 VPWR VGND VPWR VGND sky130_ef_sc_hd__decap_12
XTAP_TAPCELL_ROW_104_1566 VGND VPWR sky130_fd_sc_hd__tapvpwrvgnd_1
XFILLER_24_451 VGND VGND VPWR VPWR sky130_fd_sc_hd__fill_2
XFILLER_51_281 VGND VGND VPWR VPWR sky130_fd_sc_hd__fill_2
XFILLER_24_484 VGND VGND VPWR VPWR sky130_fd_sc_hd__fill_1
XFILLER_11_189 VPWR VGND VPWR VGND sky130_ef_sc_hd__decap_12
XFILLER_22_41 VPWR VGND VPWR VGND sky130_ef_sc_hd__decap_12
XTAP_TAPCELL_ROW_59_1001 VGND VPWR sky130_fd_sc_hd__tapvpwrvgnd_1
XFILLER_22_74 VGND VGND VPWR VPWR sky130_fd_sc_hd__decap_8
XFILLER_22_85 VGND VGND VPWR VPWR sky130_fd_sc_hd__fill_2
XFILLER_121_721 VGND VGND VPWR VPWR sky130_fd_sc_hd__decap_4
XFILLER_112_209 VPWR VGND VPWR VGND sky130_ef_sc_hd__decap_12
XFILLER_105_261 VPWR VGND VPWR VGND sky130_ef_sc_hd__decap_12
XFILLER_120_253 VPWR VGND VPWR VGND sky130_ef_sc_hd__decap_12
XFILLER_93_104 VGND VGND VPWR VPWR sky130_fd_sc_hd__decap_8
XFILLER_66_307 VGND VGND VPWR VPWR sky130_fd_sc_hd__fill_1
XFILLER_59_381 VGND VGND VPWR VPWR sky130_fd_sc_hd__decap_8
XFILLER_93_159 VGND VGND VPWR VPWR sky130_fd_sc_hd__decap_8
XFILLER_74_340 VGND VGND VPWR VPWR sky130_fd_sc_hd__decap_3
XFILLER_47_598 VPWR VGND VPWR VGND sky130_ef_sc_hd__decap_12
XFILLER_62_557 VPWR VGND VPWR VGND sky130_ef_sc_hd__decap_12
XTAP_TAPCELL_ROW_17_479 VGND VPWR sky130_fd_sc_hd__tapvpwrvgnd_1
XFILLER_15_473 VGND VGND VPWR VPWR sky130_fd_sc_hd__decap_8
XFILLER_30_421 VPWR VGND VPWR VGND sky130_ef_sc_hd__decap_12
XFILLER_30_454 VGND VGND VPWR VPWR sky130_fd_sc_hd__fill_1
XFILLER_8_65 VPWR VGND VPWR VGND sky130_ef_sc_hd__decap_12
X_4560_ _2315_ _2320_ net135 VGND VGND VPWR VPWR _2441_ sky130_fd_sc_hd__mux2_1
X_3511_ reg_file_inst.registry\[4\]\[12\] _1134_ _1138_ reg_file_inst.registry\[14\]\[12\]
+ VGND VGND VPWR VPWR _1443_ sky130_fd_sc_hd__a22o_1
X_4491_ net25 _2309_ _2374_ VGND VGND VPWR VPWR _2375_ sky130_fd_sc_hd__o21a_4
X_6230_ clknet_leaf_32_clk _0638_ _0163_ VGND VGND VPWR VPWR reg_file_inst.registry\[10\]\[23\]
+ sky130_fd_sc_hd__dfrtp_1
X_3442_ reg_file_inst.registry\[5\]\[16\] _1097_ _1098_ reg_file_inst.registry\[10\]\[16\]
+ VGND VGND VPWR VPWR _1376_ sky130_fd_sc_hd__a22o_1
X_6161_ clknet_leaf_29_clk _0569_ _0094_ VGND VGND VPWR VPWR JMPOFF\[10\] sky130_fd_sc_hd__dfrtp_4
X_3373_ reg_file_inst.registry\[9\]\[20\] net144 _1127_ VGND VGND VPWR VPWR _1310_
+ sky130_fd_sc_hd__and3_1
X_5112_ _1529_ _1541_ _2938_ VGND VGND VPWR VPWR _2939_ sky130_fd_sc_hd__a21oi_1
XTAP_TAPCELL_ROW_90_1389 VGND VPWR sky130_fd_sc_hd__tapvpwrvgnd_1
XFILLER_85_627 VPWR VGND VPWR VGND sky130_ef_sc_hd__decap_12
X_6092_ clknet_leaf_23_clk _0500_ _0025_ VGND VGND VPWR VPWR reg_file_inst.registry\[15\]\[25\]
+ sky130_fd_sc_hd__dfrtp_1
XFILLER_69_167 VGND VGND VPWR VPWR sky130_fd_sc_hd__fill_1
X_5043_ _2711_ _2784_ _2801_ _2537_ _2879_ VGND VGND VPWR VPWR _2880_ sky130_fd_sc_hd__a221o_1
XFILLER_93_671 VGND VGND VPWR VPWR sky130_fd_sc_hd__fill_1
XTAP_TAPCELL_ROW_36_711 VGND VPWR sky130_fd_sc_hd__tapvpwrvgnd_1
XFILLER_38_587 VGND VGND VPWR VPWR sky130_fd_sc_hd__fill_1
XFILLER_38_598 VGND VGND VPWR VPWR sky130_fd_sc_hd__fill_1
XFILLER_80_365 VPWR VGND VPWR VGND sky130_ef_sc_hd__decap_12
XFILLER_80_354 VGND VGND VPWR VPWR sky130_fd_sc_hd__decap_8
X_5945_ net148 VGND VGND VPWR VPWR _0353_ sky130_fd_sc_hd__inv_2
XFILLER_33_281 VGND VGND VPWR VPWR sky130_fd_sc_hd__decap_6
X_5876_ net146 VGND VGND VPWR VPWR _0284_ sky130_fd_sc_hd__inv_2
XFILLER_21_443 VGND VGND VPWR VPWR sky130_fd_sc_hd__decap_4
X_4827_ net132 _2225_ _2222_ VGND VGND VPWR VPWR _2686_ sky130_fd_sc_hd__o21ba_1
XFILLER_5_609 VGND VGND VPWR VPWR sky130_fd_sc_hd__decap_6
X_4758_ _1620_ _2615_ VGND VGND VPWR VPWR _2617_ sky130_fd_sc_hd__or2_1
X_4689_ reg_file_inst.registry\[11\]\[27\] _2478_ _2551_ VGND VGND VPWR VPWR _0906_
+ sky130_fd_sc_hd__mux2_1
X_3709_ _1372_ _1631_ _1632_ VGND VGND VPWR VPWR _1633_ sky130_fd_sc_hd__o21a_1
XFILLER_107_559 VGND VGND VPWR VPWR sky130_fd_sc_hd__fill_1
X_6428_ clknet_leaf_32_clk _0836_ _0361_ VGND VGND VPWR VPWR reg_file_inst.registry\[1\]\[25\]
+ sky130_fd_sc_hd__dfrtp_1
XFILLER_122_529 VGND VGND VPWR VPWR sky130_fd_sc_hd__decap_3
XFILLER_108_77 VGND VGND VPWR VPWR sky130_fd_sc_hd__decap_6
XFILLER_88_421 VPWR VGND VPWR VGND sky130_ef_sc_hd__decap_12
X_6359_ clknet_leaf_7_clk _0767_ _0292_ VGND VGND VPWR VPWR reg_file_inst.registry\[2\]\[12\]
+ sky130_fd_sc_hd__dfrtp_1
XFILLER_102_242 VGND VGND VPWR VPWR sky130_fd_sc_hd__decap_8
XFILLER_75_137 VPWR VGND VPWR VGND sky130_ef_sc_hd__decap_12
XFILLER_17_705 VGND VGND VPWR VPWR sky130_fd_sc_hd__fill_1
XFILLER_84_693 VGND VGND VPWR VPWR sky130_fd_sc_hd__decap_6
XFILLER_71_321 VPWR VGND VPWR VGND sky130_ef_sc_hd__decap_12
XFILLER_44_568 VGND VGND VPWR VPWR sky130_fd_sc_hd__fill_1
XTAP_TAPCELL_ROW_65_1082 VGND VPWR sky130_fd_sc_hd__tapvpwrvgnd_1
XTAP_TAPCELL_ROW_65_1071 VGND VPWR sky130_fd_sc_hd__tapvpwrvgnd_1
XFILLER_12_421 VPWR VGND VPWR VGND sky130_ef_sc_hd__decap_12
XFILLER_12_454 VPWR VGND VPWR VGND sky130_ef_sc_hd__decap_12
XTAP_TAPCELL_ROW_14_438 VGND VPWR sky130_fd_sc_hd__tapvpwrvgnd_1
XFILLER_8_469 VGND VGND VPWR VPWR sky130_fd_sc_hd__decap_6
XPHY_EDGE_ROW_49_Left_172 VGND VGND VPWR VPWR sky130_fd_sc_hd__decap_3
XTAP_TAPCELL_ROW_117_1724 VGND VPWR sky130_fd_sc_hd__tapvpwrvgnd_1
XFILLER_113_529 VPWR VGND VPWR VGND sky130_ef_sc_hd__decap_12
XFILLER_98_229 VPWR VGND VPWR VGND sky130_ef_sc_hd__decap_12
XFILLER_106_581 VGND VGND VPWR VPWR sky130_fd_sc_hd__decap_6
XFILLER_79_432 VGND VGND VPWR VPWR sky130_fd_sc_hd__fill_1
XFILLER_121_573 VPWR VGND VPWR VGND sky130_ef_sc_hd__decap_12
XFILLER_58_81 VGND VGND VPWR VPWR sky130_fd_sc_hd__decap_3
XPHY_EDGE_ROW_58_Left_181 VGND VGND VPWR VPWR sky130_fd_sc_hd__decap_3
XFILLER_12_6 VPWR VGND VPWR VGND sky130_ef_sc_hd__decap_12
XFILLER_75_671 VGND VGND VPWR VPWR sky130_fd_sc_hd__fill_1
XFILLER_35_513 VGND VGND VPWR VPWR sky130_fd_sc_hd__decap_4
XFILLER_62_321 VPWR VGND VPWR VGND sky130_ef_sc_hd__decap_12
XFILLER_62_365 VGND VGND VPWR VPWR sky130_fd_sc_hd__fill_1
X_3991_ net131 _1905_ net106 VGND VGND VPWR VPWR _1907_ sky130_fd_sc_hd__a21oi_1
X_5730_ net147 VGND VGND VPWR VPWR _0138_ sky130_fd_sc_hd__inv_2
XFILLER_95_3 VPWR VGND VPWR VGND sky130_ef_sc_hd__decap_12
XFILLER_50_549 VGND VGND VPWR VPWR sky130_fd_sc_hd__fill_1
XFILLER_15_281 VGND VGND VPWR VPWR sky130_fd_sc_hd__decap_8
XPHY_EDGE_ROW_67_Left_190 VGND VGND VPWR VPWR sky130_fd_sc_hd__decap_3
X_5661_ net147 VGND VGND VPWR VPWR _0069_ sky130_fd_sc_hd__inv_2
XFILLER_30_251 VGND VGND VPWR VPWR sky130_fd_sc_hd__fill_1
X_5592_ reg_file_inst.registry\[15\]\[0\] _2550_ _3003_ VGND VGND VPWR VPWR _0475_
+ sky130_fd_sc_hd__mux2_1
X_4612_ _2163_ _2164_ _2177_ VGND VGND VPWR VPWR _2489_ sky130_fd_sc_hd__a21oi_1
XTAP_TAPCELL_ROW_41_780 VGND VPWR sky130_fd_sc_hd__tapvpwrvgnd_1
XFILLER_116_301 VGND VGND VPWR VPWR sky130_fd_sc_hd__decap_6
X_4543_ _2422_ _2423_ net136 VGND VGND VPWR VPWR _2424_ sky130_fd_sc_hd__mux2_1
XFILLER_116_345 VPWR VGND VPWR VGND sky130_ef_sc_hd__decap_12
XTAP_TAPCELL_ROW_92_1418 VGND VPWR sky130_fd_sc_hd__tapvpwrvgnd_1
Xmax_cap144 _1125_ VGND VGND VPWR VPWR net144 sky130_fd_sc_hd__buf_4
Xmax_cap133 net135 VGND VGND VPWR VPWR net133 sky130_fd_sc_hd__clkbuf_8
XFILLER_116_389 VPWR VGND VPWR VGND sky130_ef_sc_hd__decap_12
XFILLER_89_218 VGND VGND VPWR VPWR sky130_fd_sc_hd__decap_6
X_4474_ _2358_ VGND VGND VPWR VPWR _2359_ sky130_fd_sc_hd__inv_2
X_6213_ clknet_leaf_3_clk _0621_ _0146_ VGND VGND VPWR VPWR reg_file_inst.registry\[10\]\[6\]
+ sky130_fd_sc_hd__dfrtp_1
X_3425_ reg_file_inst.registry\[1\]\[18\] net145 _1127_ VGND VGND VPWR VPWR _1360_
+ sky130_fd_sc_hd__and3_1
X_3356_ reg_file_inst.registry\[0\]\[21\] _1118_ _1290_ _1293_ VGND VGND VPWR VPWR
+ net86 sky130_fd_sc_hd__o22a_2
X_6144_ clknet_leaf_42_clk _0552_ _0077_ VGND VGND VPWR VPWR reg_file_inst.registry\[6\]\[21\]
+ sky130_fd_sc_hd__dfrtp_1
XFILLER_100_713 VGND VGND VPWR VPWR sky130_fd_sc_hd__decap_4
X_3287_ reg_file_inst.registry\[2\]\[23\] _1083_ _1096_ reg_file_inst.registry\[11\]\[23\]
+ VGND VGND VPWR VPWR _1227_ sky130_fd_sc_hd__a22o_1
X_6075_ clknet_leaf_54_clk _0483_ _0008_ VGND VGND VPWR VPWR reg_file_inst.registry\[15\]\[8\]
+ sky130_fd_sc_hd__dfrtp_1
X_5026_ _2667_ _2864_ VGND VGND VPWR VPWR _2865_ sky130_fd_sc_hd__xnor2_1
XFILLER_81_641 VPWR VGND VPWR VGND sky130_ef_sc_hd__decap_12
XFILLER_65_181 VGND VGND VPWR VPWR sky130_fd_sc_hd__fill_1
XFILLER_38_395 VGND VGND VPWR VPWR sky130_fd_sc_hd__decap_6
XTAP_TAPCELL_ROW_49_880 VGND VPWR sky130_fd_sc_hd__tapvpwrvgnd_1
XFILLER_81_685 VGND VGND VPWR VPWR sky130_fd_sc_hd__fill_2
X_5928_ net146 VGND VGND VPWR VPWR _0336_ sky130_fd_sc_hd__inv_2
XTAP_TAPCELL_ROW_101_1525 VGND VPWR sky130_fd_sc_hd__tapvpwrvgnd_1
X_5859_ net147 VGND VGND VPWR VPWR _0267_ sky130_fd_sc_hd__inv_2
XFILLER_70_27 VGND VGND VPWR VPWR sky130_fd_sc_hd__fill_1
XFILLER_21_262 VGND VGND VPWR VPWR sky130_fd_sc_hd__fill_1
XFILLER_119_161 VGND VGND VPWR VPWR sky130_fd_sc_hd__decap_6
XFILLER_122_337 VPWR VGND VPWR VGND sky130_ef_sc_hd__decap_12
XTAP_TAPCELL_ROW_112_1665 VGND VPWR sky130_fd_sc_hd__tapvpwrvgnd_1
XFILLER_0_144 VGND VGND VPWR VPWR sky130_fd_sc_hd__fill_2
XFILLER_103_573 VPWR VGND VPWR VGND sky130_ef_sc_hd__decap_12
XFILLER_76_424 VPWR VGND VPWR VGND sky130_ef_sc_hd__decap_12
XFILLER_0_188 VGND VGND VPWR VPWR sky130_fd_sc_hd__fill_2
XFILLER_91_416 VPWR VGND VPWR VGND sky130_ef_sc_hd__decap_12
XFILLER_91_405 VGND VGND VPWR VPWR sky130_fd_sc_hd__decap_4
XTAP_TAPCELL_ROW_67_1100 VGND VPWR sky130_fd_sc_hd__tapvpwrvgnd_1
XFILLER_57_671 VGND VGND VPWR VPWR sky130_fd_sc_hd__fill_1
XFILLER_91_449 VGND VGND VPWR VPWR sky130_fd_sc_hd__decap_8
XFILLER_72_641 VGND VGND VPWR VPWR sky130_fd_sc_hd__decap_3
XFILLER_44_321 VGND VGND VPWR VPWR sky130_fd_sc_hd__decap_4
XTAP_TAPCELL_ROW_27_596 VGND VPWR sky130_fd_sc_hd__tapvpwrvgnd_1
XFILLER_32_549 VGND VGND VPWR VPWR sky130_fd_sc_hd__fill_1
XFILLER_12_251 VGND VGND VPWR VPWR sky130_fd_sc_hd__fill_1
XFILLER_8_233 VPWR VGND VPWR VGND sky130_ef_sc_hd__decap_12
XTAP_TAPCELL_ROW_78_1240 VGND VPWR sky130_fd_sc_hd__tapvpwrvgnd_1
XFILLER_8_299 VGND VGND VPWR VPWR sky130_fd_sc_hd__decap_4
XFILLER_99_527 VGND VGND VPWR VPWR sky130_fd_sc_hd__decap_8
XFILLER_99_505 VGND VGND VPWR VPWR sky130_fd_sc_hd__decap_8
XFILLER_5_55 VGND VGND VPWR VPWR sky130_fd_sc_hd__fill_1
XFILLER_113_337 VPWR VGND VPWR VGND sky130_ef_sc_hd__decap_12
XFILLER_4_483 VGND VGND VPWR VPWR sky130_fd_sc_hd__fill_1
X_3210_ reg_file_inst.registry\[2\]\[26\] _1083_ _1096_ reg_file_inst.registry\[11\]\[26\]
+ VGND VGND VPWR VPWR _1153_ sky130_fd_sc_hd__a22o_1
XFILLER_69_80 VGND VGND VPWR VPWR sky130_fd_sc_hd__decap_4
X_4190_ _1908_ _2084_ VGND VGND VPWR VPWR _2092_ sky130_fd_sc_hd__xnor2_1
XFILLER_79_284 VPWR VGND VPWR VGND sky130_ef_sc_hd__decap_12
X_3141_ net38 net39 net34 VGND VGND VPWR VPWR _1085_ sky130_fd_sc_hd__a21o_2
XFILLER_94_221 VGND VGND VPWR VPWR sky130_fd_sc_hd__decap_8
XFILLER_67_468 VPWR VGND VPWR VGND sky130_ef_sc_hd__decap_12
XFILLER_10_3 VPWR VGND VPWR VGND sky130_ef_sc_hd__decap_12
XFILLER_94_265 VGND VGND VPWR VPWR sky130_fd_sc_hd__decap_8
XFILLER_54_107 VPWR VGND VPWR VGND sky130_ef_sc_hd__decap_12
X_3072_ _1005_ _1013_ _1014_ VGND VGND VPWR VPWR _1016_ sky130_fd_sc_hd__nor3b_1
XTAP_TAPCELL_ROW_89_1380 VGND VPWR sky130_fd_sc_hd__tapvpwrvgnd_1
XFILLER_23_505 VGND VGND VPWR VPWR sky130_fd_sc_hd__decap_6
X_3974_ _1045_ _1051_ _1888_ VGND VGND VPWR VPWR _1890_ sky130_fd_sc_hd__nand3_1
X_5713_ net148 VGND VGND VPWR VPWR _0121_ sky130_fd_sc_hd__inv_2
X_5644_ net149 VGND VGND VPWR VPWR _0052_ sky130_fd_sc_hd__inv_2
XFILLER_108_109 VPWR VGND VPWR VGND sky130_ef_sc_hd__decap_12
X_5575_ reg_file_inst.registry\[15\]\[17\] _2873_ _3003_ VGND VGND VPWR VPWR _0492_
+ sky130_fd_sc_hd__mux2_1
XFILLER_117_665 VGND VGND VPWR VPWR sky130_fd_sc_hd__decap_6
XFILLER_116_153 VPWR VGND VPWR VGND sky130_ef_sc_hd__decap_12
X_4526_ _1735_ _1751_ _2288_ VGND VGND VPWR VPWR _2409_ sky130_fd_sc_hd__o21ai_1
XFILLER_116_197 VPWR VGND VPWR VGND sky130_ef_sc_hd__decap_12
X_4457_ _2340_ _2341_ VGND VGND VPWR VPWR _2342_ sky130_fd_sc_hd__nor2_1
X_3408_ reg_file_inst.registry\[3\]\[19\] _1140_ _1338_ _1342_ _1343_ VGND VGND VPWR
+ VPWR _1344_ sky130_fd_sc_hd__a2111o_1
X_6127_ clknet_leaf_54_clk _0535_ _0060_ VGND VGND VPWR VPWR reg_file_inst.registry\[6\]\[4\]
+ sky130_fd_sc_hd__dfrtp_1
X_4388_ net43 _2126_ _2252_ net30 VGND VGND VPWR VPWR _2276_ sky130_fd_sc_hd__or4b_4
XFILLER_85_243 VGND VGND VPWR VPWR sky130_fd_sc_hd__fill_1
X_3339_ reg_file_inst.registry\[1\]\[21\] _1087_ _1095_ JMPOFF\[21\] _1276_ VGND VGND
+ VPWR VPWR _1277_ sky130_fd_sc_hd__a221o_1
XFILLER_85_265 VGND VGND VPWR VPWR sky130_fd_sc_hd__decap_3
X_6058_ net146 VGND VGND VPWR VPWR _0466_ sky130_fd_sc_hd__inv_2
XFILLER_73_449 VGND VGND VPWR VPWR sky130_fd_sc_hd__fill_2
X_5009_ _2279_ _2710_ _2711_ _2689_ _2851_ VGND VGND VPWR VPWR _2852_ sky130_fd_sc_hd__a221o_1
XFILLER_54_652 VGND VGND VPWR VPWR sky130_fd_sc_hd__decap_8
XFILLER_26_354 VGND VGND VPWR VPWR sky130_fd_sc_hd__decap_3
XFILLER_26_365 VGND VGND VPWR VPWR sky130_fd_sc_hd__decap_3
XTAP_TAPCELL_ROW_44_809 VGND VPWR sky130_fd_sc_hd__tapvpwrvgnd_1
XFILLER_121_55 VGND VGND VPWR VPWR sky130_fd_sc_hd__fill_1
XFILLER_81_15 VPWR VGND VPWR VGND sky130_ef_sc_hd__decap_12
XFILLER_14_516 VPWR VGND VPWR VGND sky130_ef_sc_hd__decap_12
XFILLER_26_398 VPWR VGND VPWR VGND sky130_ef_sc_hd__decap_12
XFILLER_41_335 VGND VGND VPWR VPWR sky130_fd_sc_hd__fill_1
XTAP_TAPCELL_ROW_62_1041 VGND VPWR sky130_fd_sc_hd__tapvpwrvgnd_1
XFILLER_14_53 VGND VGND VPWR VPWR sky130_fd_sc_hd__decap_6
XTAP_TAPCELL_ROW_24_566 VGND VPWR sky130_fd_sc_hd__tapvpwrvgnd_1
XFILLER_108_643 VGND VGND VPWR VPWR sky130_fd_sc_hd__fill_1
XFILLER_5_225 VGND VGND VPWR VPWR sky130_fd_sc_hd__decap_8
XFILLER_5_258 VPWR VGND VPWR VGND sky130_ef_sc_hd__decap_12
XFILLER_5_247 VGND VGND VPWR VPWR sky130_fd_sc_hd__decap_4
XFILLER_30_85 VGND VGND VPWR VPWR sky130_fd_sc_hd__fill_2
XFILLER_30_96 VPWR VGND VPWR VGND sky130_ef_sc_hd__decap_12
XFILLER_110_307 VGND VGND VPWR VPWR sky130_fd_sc_hd__fill_1
XTAP_TAPCELL_ROW_73_1181 VGND VPWR sky130_fd_sc_hd__tapvpwrvgnd_1
XFILLER_92_725 VGND VGND VPWR VPWR sky130_fd_sc_hd__fill_1
XPHY_EDGE_ROW_101_Right_101 VGND VGND VPWR VPWR sky130_fd_sc_hd__decap_3
Xclkbuf_leaf_56_clk clknet_3_4__leaf_clk VGND VGND VPWR VPWR clknet_leaf_56_clk sky130_fd_sc_hd__clkbuf_8
XFILLER_91_246 VPWR VGND VPWR VGND sky130_ef_sc_hd__decap_12
XFILLER_29_192 VGND VGND VPWR VPWR sky130_fd_sc_hd__fill_2
XFILLER_45_641 VGND VGND VPWR VPWR sky130_fd_sc_hd__decap_4
XFILLER_45_685 VGND VGND VPWR VPWR sky130_fd_sc_hd__decap_4
XFILLER_60_699 VGND VGND VPWR VPWR sky130_fd_sc_hd__fill_1
X_3690_ reg_file_inst.registry\[6\]\[8\] _1123_ _1132_ VGND VGND VPWR VPWR _1615_
+ sky130_fd_sc_hd__and3_1
XFILLER_9_597 VPWR VGND VPWR VGND sky130_ef_sc_hd__decap_12
XFILLER_58_3 VGND VGND VPWR VPWR sky130_fd_sc_hd__decap_8
X_5360_ _2550_ reg_file_inst.registry\[3\]\[0\] _2995_ VGND VGND VPWR VPWR _0699_
+ sky130_fd_sc_hd__mux2_1
XFILLER_114_613 VPWR VGND VPWR VGND sky130_ef_sc_hd__decap_12
X_4311_ _1840_ _2198_ VGND VGND VPWR VPWR _2199_ sky130_fd_sc_hd__nor2_1
X_5291_ _2948_ reg_file_inst.registry\[2\]\[11\] _2993_ VGND VGND VPWR VPWR _0766_
+ sky130_fd_sc_hd__mux2_1
XFILLER_114_657 VPWR VGND VPWR VGND sky130_ef_sc_hd__decap_12
XFILLER_99_346 VPWR VGND VPWR VGND sky130_ef_sc_hd__decap_12
XFILLER_87_508 VPWR VGND VPWR VGND sky130_ef_sc_hd__decap_12
X_4242_ _1790_ _1816_ _1840_ VGND VGND VPWR VPWR _2130_ sky130_fd_sc_hd__or3_1
XFILLER_113_167 VGND VGND VPWR VPWR sky130_fd_sc_hd__fill_1
X_4173_ _1998_ _2079_ VGND VGND VPWR VPWR _2080_ sky130_fd_sc_hd__xor2_1
XFILLER_95_585 VPWR VGND VPWR VGND sky130_ef_sc_hd__decap_12
X_3124_ _1053_ _1058_ _1060_ _1067_ _0991_ VGND VGND VPWR VPWR _1068_ sky130_fd_sc_hd__a2111o_1
XFILLER_27_107 VGND VGND VPWR VPWR sky130_fd_sc_hd__decap_4
X_3055_ JMPOFF\[5\] net39 _0966_ VGND VGND VPWR VPWR _0999_ sky130_fd_sc_hd__nand3_1
Xclkbuf_leaf_47_clk clknet_3_5__leaf_clk VGND VGND VPWR VPWR clknet_leaf_47_clk sky130_fd_sc_hd__clkbuf_8
XFILLER_70_419 VGND VGND VPWR VPWR sky130_fd_sc_hd__fill_1
X_3957_ net43 net42 VGND VGND VPWR VPWR _1873_ sky130_fd_sc_hd__and2_4
XTAP_TAPCELL_ROW_21_525 VGND VPWR sky130_fd_sc_hd__tapvpwrvgnd_1
XFILLER_109_429 VPWR VGND VPWR VGND sky130_ef_sc_hd__decap_12
X_3888_ reg_file_inst.registry\[14\]\[1\] _1081_ _1095_ JMPOFF\[1\] VGND VGND VPWR
+ VPWR _1806_ sky130_fd_sc_hd__a22o_1
X_5627_ net146 VGND VGND VPWR VPWR _0035_ sky130_fd_sc_hd__inv_2
X_5558_ _2419_ reg_file_inst.registry\[9\]\[5\] _3002_ VGND VGND VPWR VPWR _0508_
+ sky130_fd_sc_hd__mux2_1
XFILLER_117_473 VPWR VGND VPWR VGND sky130_ef_sc_hd__decap_12
X_4509_ _2390_ _2391_ net136 VGND VGND VPWR VPWR _2392_ sky130_fd_sc_hd__mux2_1
XFILLER_104_156 VPWR VGND VPWR VGND sky130_ef_sc_hd__decap_12
X_5489_ JMPOFF\[16\] _2883_ _3000_ VGND VGND VPWR VPWR _0575_ sky130_fd_sc_hd__mux2_1
XFILLER_116_77 VGND VGND VPWR VPWR sky130_fd_sc_hd__decap_6
XFILLER_58_221 VPWR VGND VPWR VGND sky130_ef_sc_hd__decap_12
XFILLER_100_362 VGND VGND VPWR VPWR sky130_fd_sc_hd__fill_2
XTAP_TAPCELL_ROW_29_625 VGND VPWR sky130_fd_sc_hd__tapvpwrvgnd_1
XTAP_TAPCELL_ROW_57_978 VGND VPWR sky130_fd_sc_hd__tapvpwrvgnd_1
XFILLER_61_419 VPWR VGND VPWR VGND sky130_ef_sc_hd__decap_12
XTAP_TAPCELL_ROW_1_272 VGND VPWR sky130_fd_sc_hd__tapvpwrvgnd_1
XTAP_TAPCELL_ROW_107_1597 VGND VPWR sky130_fd_sc_hd__tapvpwrvgnd_1
XFILLER_41_110 VGND VGND VPWR VPWR sky130_fd_sc_hd__fill_2
XFILLER_41_121 VGND VGND VPWR VPWR sky130_fd_sc_hd__fill_2
XFILLER_42_655 VGND VGND VPWR VPWR sky130_fd_sc_hd__fill_2
XFILLER_14_357 VGND VGND VPWR VPWR sky130_fd_sc_hd__decap_6
XFILLER_14_379 VPWR VGND VPWR VGND sky130_ef_sc_hd__decap_12
XTAP_TAPCELL_ROW_120_1764 VGND VPWR sky130_fd_sc_hd__tapvpwrvgnd_1
XFILLER_6_545 VPWR VGND VPWR VGND sky130_ef_sc_hd__decap_12
XFILLER_6_589 VPWR VGND VPWR VGND sky130_ef_sc_hd__decap_12
XTAP_TAPCELL_ROW_9_372 VGND VPWR sky130_fd_sc_hd__tapvpwrvgnd_1
XFILLER_77_541 VGND VGND VPWR VPWR sky130_fd_sc_hd__decap_8
XFILLER_65_703 VGND VGND VPWR VPWR sky130_fd_sc_hd__fill_2
XFILLER_65_725 VGND VGND VPWR VPWR sky130_fd_sc_hd__fill_1
XFILLER_37_449 VGND VGND VPWR VPWR sky130_fd_sc_hd__decap_6
XFILLER_92_566 VPWR VGND VPWR VGND sky130_ef_sc_hd__decap_12
XFILLER_92_544 VGND VGND VPWR VPWR sky130_fd_sc_hd__fill_1
Xclkbuf_leaf_29_clk clknet_3_6__leaf_clk VGND VGND VPWR VPWR clknet_leaf_29_clk sky130_fd_sc_hd__clkbuf_8
XFILLER_52_408 VGND VGND VPWR VPWR sky130_fd_sc_hd__decap_3
XFILLER_18_641 VGND VGND VPWR VPWR sky130_fd_sc_hd__decap_3
XFILLER_18_685 VGND VGND VPWR VPWR sky130_fd_sc_hd__decap_6
X_4860_ _2679_ _2716_ _2176_ VGND VGND VPWR VPWR _2717_ sky130_fd_sc_hd__and3b_1
XFILLER_32_132 VGND VGND VPWR VPWR sky130_fd_sc_hd__decap_4
X_3811_ reg_file_inst.registry\[7\]\[5\] _1086_ _1097_ reg_file_inst.registry\[5\]\[5\]
+ VGND VGND VPWR VPWR _1732_ sky130_fd_sc_hd__a22o_1
XFILLER_20_305 VGND VGND VPWR VPWR sky130_fd_sc_hd__decap_3
X_4791_ _2630_ _2646_ VGND VGND VPWR VPWR _2650_ sky130_fd_sc_hd__and2_1
XANTENNA_28 net65 VGND VGND VPWR VPWR sky130_fd_sc_hd__diode_2
XFILLER_32_176 VPWR VGND VPWR VGND sky130_ef_sc_hd__decap_12
XFILLER_33_699 VGND VGND VPWR VPWR sky130_fd_sc_hd__decap_4
XANTENNA_17 net84 VGND VGND VPWR VPWR sky130_fd_sc_hd__diode_2
X_6530_ clknet_leaf_48_clk _0938_ _0463_ VGND VGND VPWR VPWR net109 sky130_fd_sc_hd__dfrtp_1
X_3742_ _1658_ _1663_ _1664_ _1665_ VGND VGND VPWR VPWR _1666_ sky130_fd_sc_hd__or4_1
X_6461_ clknet_leaf_30_clk _0869_ _0394_ VGND VGND VPWR VPWR reg_file_inst.registry\[0\]\[22\]
+ sky130_fd_sc_hd__dfrtp_1
X_3673_ reg_file_inst.registry\[4\]\[8\] _1074_ _1084_ VGND VGND VPWR VPWR _1598_
+ sky130_fd_sc_hd__and3_1
X_6392_ clknet_leaf_26_clk _0800_ _0325_ VGND VGND VPWR VPWR reg_file_inst.registry\[14\]\[17\]
+ sky130_fd_sc_hd__dfrtp_1
X_5412_ reg_file_inst.registry\[4\]\[6\] _2375_ _2997_ VGND VGND VPWR VPWR _0649_
+ sky130_fd_sc_hd__mux2_1
Xoutput102 net102 VGND VGND VPWR VPWR DmemWriteEn sky130_fd_sc_hd__buf_1
XFILLER_114_421 VPWR VGND VPWR VGND sky130_ef_sc_hd__decap_12
X_5343_ _2873_ reg_file_inst.registry\[3\]\[17\] _2995_ VGND VGND VPWR VPWR _0716_
+ sky130_fd_sc_hd__mux2_1
Xoutput113 net113 VGND VGND VPWR VPWR IC[1] sky130_fd_sc_hd__buf_1
Xoutput124 net124 VGND VGND VPWR VPWR IC[4] sky130_fd_sc_hd__buf_1
X_5274_ _1123_ _2987_ VGND VGND VPWR VPWR _2993_ sky130_fd_sc_hd__nand2_8
XFILLER_87_349 VGND VGND VPWR VPWR sky130_fd_sc_hd__decap_4
XFILLER_68_530 VGND VGND VPWR VPWR sky130_fd_sc_hd__fill_2
X_4225_ _0960_ net42 _0962_ _0963_ VGND VGND VPWR VPWR _2113_ sky130_fd_sc_hd__nand4_1
X_4156_ _2048_ _2068_ VGND VGND VPWR VPWR _2069_ sky130_fd_sc_hd__xnor2_1
XFILLER_110_693 VGND VGND VPWR VPWR sky130_fd_sc_hd__decap_6
XFILLER_95_393 VPWR VGND VPWR VGND sky130_ef_sc_hd__decap_12
XFILLER_83_533 VGND VGND VPWR VPWR sky130_fd_sc_hd__decap_3
X_3107_ JMPOFF\[15\] _0967_ _1050_ VGND VGND VPWR VPWR _1051_ sky130_fd_sc_hd__a21bo_1
XFILLER_46_29 VGND VGND VPWR VPWR sky130_fd_sc_hd__decap_4
X_4087_ _1998_ _2002_ VGND VGND VPWR VPWR _2003_ sky130_fd_sc_hd__nor2_1
X_3038_ JMPOFF\[20\] _0967_ _0981_ VGND VGND VPWR VPWR _0982_ sky130_fd_sc_hd__a21bo_1
XFILLER_55_279 VGND VGND VPWR VPWR sky130_fd_sc_hd__fill_1
XTAP_TAPCELL_ROW_54_937 VGND VPWR sky130_fd_sc_hd__tapvpwrvgnd_1
XFILLER_70_249 VGND VGND VPWR VPWR sky130_fd_sc_hd__decap_3
XFILLER_24_677 VGND VGND VPWR VPWR sky130_fd_sc_hd__fill_1
XFILLER_11_327 VGND VGND VPWR VPWR sky130_fd_sc_hd__decap_4
X_4989_ _2278_ _2832_ _2833_ _2297_ _2433_ VGND VGND VPWR VPWR _2834_ sky130_fd_sc_hd__o32a_1
XFILLER_24_699 VGND VGND VPWR VPWR sky130_fd_sc_hd__fill_1
XTAP_TAPCELL_ROW_34_683 VGND VPWR sky130_fd_sc_hd__tapvpwrvgnd_1
XTAP_TAPCELL_ROW_34_694 VGND VPWR sky130_fd_sc_hd__tapvpwrvgnd_1
XFILLER_109_237 VPWR VGND VPWR VGND sky130_ef_sc_hd__decap_12
XPHY_EDGE_ROW_12_Left_135 VGND VGND VPWR VPWR sky130_fd_sc_hd__decap_3
XFILLER_117_281 VPWR VGND VPWR VGND sky130_ef_sc_hd__decap_12
XFILLER_3_559 VGND VGND VPWR VPWR sky130_fd_sc_hd__fill_1
XFILLER_120_413 VGND VGND VPWR VPWR sky130_fd_sc_hd__decap_6
XTAP_TAPCELL_ROW_70_1140 VGND VPWR sky130_fd_sc_hd__tapvpwrvgnd_1
XTAP_TAPCELL_ROW_6_342 VGND VPWR sky130_fd_sc_hd__tapvpwrvgnd_1
XFILLER_120_457 VPWR VGND VPWR VGND sky130_ef_sc_hd__decap_12
XPHY_EDGE_ROW_21_Left_144 VGND VGND VPWR VPWR sky130_fd_sc_hd__decap_3
XFILLER_47_703 VGND VGND VPWR VPWR sky130_fd_sc_hd__fill_2
XTAP_TAPCELL_ROW_109_1626 VGND VPWR sky130_fd_sc_hd__tapvpwrvgnd_1
XFILLER_101_671 VGND VGND VPWR VPWR sky130_fd_sc_hd__fill_1
XFILLER_86_393 VGND VGND VPWR VPWR sky130_fd_sc_hd__decap_4
XFILLER_74_533 VGND VGND VPWR VPWR sky130_fd_sc_hd__decap_8
XFILLER_74_522 VGND VGND VPWR VPWR sky130_fd_sc_hd__decap_8
XFILLER_47_725 VGND VGND VPWR VPWR sky130_fd_sc_hd__fill_1
XFILLER_74_566 VPWR VGND VPWR VGND sky130_ef_sc_hd__decap_12
XFILLER_19_449 VGND VGND VPWR VPWR sky130_fd_sc_hd__decap_6
XTAP_TAPCELL_ROW_122_1804 VGND VPWR sky130_fd_sc_hd__tapvpwrvgnd_1
XFILLER_36_73 VGND VGND VPWR VPWR sky130_fd_sc_hd__fill_2
XFILLER_14_110 VGND VGND VPWR VPWR sky130_fd_sc_hd__fill_1
XFILLER_42_474 VGND VGND VPWR VPWR sky130_fd_sc_hd__fill_2
XTAP_TAPCELL_ROW_81_1280 VGND VPWR sky130_fd_sc_hd__tapvpwrvgnd_1
XPHY_EDGE_ROW_30_Left_153 VGND VGND VPWR VPWR sky130_fd_sc_hd__decap_3
Xinput37 instr[3] VGND VGND VPWR VPWR net37 sky130_fd_sc_hd__clkbuf_8
XFILLER_10_371 VGND VGND VPWR VPWR sky130_fd_sc_hd__decap_8
Xinput26 DataMemoryRead[7] VGND VGND VPWR VPWR net26 sky130_fd_sc_hd__buf_1
Xinput15 DataMemoryRead[22] VGND VGND VPWR VPWR net15 sky130_fd_sc_hd__buf_1
XFILLER_6_331 VGND VGND VPWR VPWR sky130_fd_sc_hd__fill_1
XFILLER_96_135 VGND VGND VPWR VPWR sky130_fd_sc_hd__decap_4
XFILLER_2_581 VGND VGND VPWR VPWR sky130_fd_sc_hd__decap_6
X_4010_ _1915_ _1919_ _1914_ VGND VGND VPWR VPWR _1926_ sky130_fd_sc_hd__o21bai_1
XFILLER_77_382 VGND VGND VPWR VPWR sky130_fd_sc_hd__decap_8
XFILLER_77_371 VGND VGND VPWR VPWR sky130_fd_sc_hd__fill_2
XFILLER_92_363 VGND VGND VPWR VPWR sky130_fd_sc_hd__fill_1
XTAP_TAPCELL_ROW_84_1309 VGND VPWR sky130_fd_sc_hd__tapvpwrvgnd_1
XFILLER_80_525 VGND VGND VPWR VPWR sky130_fd_sc_hd__decap_6
X_5961_ net146 VGND VGND VPWR VPWR _0369_ sky130_fd_sc_hd__inv_2
XFILLER_18_460 VGND VGND VPWR VPWR sky130_fd_sc_hd__decap_6
XFILLER_52_227 VGND VGND VPWR VPWR sky130_fd_sc_hd__decap_3
X_4912_ _2766_ _2751_ _2749_ VGND VGND VPWR VPWR net62 sky130_fd_sc_hd__or3b_1
X_5892_ net149 VGND VGND VPWR VPWR _0300_ sky130_fd_sc_hd__inv_2
XTAP_TAPCELL_ROW_51_907 VGND VPWR sky130_fd_sc_hd__tapvpwrvgnd_1
XFILLER_33_441 VGND VGND VPWR VPWR sky130_fd_sc_hd__fill_1
XFILLER_60_282 VPWR VGND VPWR VGND sky130_ef_sc_hd__decap_12
XFILLER_33_485 VPWR VGND VPWR VGND sky130_ef_sc_hd__decap_12
X_4843_ _2700_ _2701_ _2699_ VGND VGND VPWR VPWR _2702_ sky130_fd_sc_hd__or3b_1
X_4774_ _2622_ _2627_ _2632_ _2625_ _2605_ VGND VGND VPWR VPWR _2633_ sky130_fd_sc_hd__a2111o_2
XTAP_TAPCELL_ROW_31_653 VGND VPWR sky130_fd_sc_hd__tapvpwrvgnd_1
X_3725_ reg_file_inst.registry\[7\]\[7\] _1084_ _1085_ _1093_ reg_file_inst.registry\[15\]\[7\]
+ VGND VGND VPWR VPWR _1649_ sky130_fd_sc_hd__a32o_1
X_6513_ clknet_leaf_3_clk _0921_ _0446_ VGND VGND VPWR VPWR reg_file_inst.registry\[11\]\[6\]
+ sky130_fd_sc_hd__dfrtp_1
XFILLER_20_179 VPWR VGND VPWR VGND sky130_ef_sc_hd__decap_12
Xclkbuf_leaf_9_clk clknet_3_2__leaf_clk VGND VGND VPWR VPWR clknet_leaf_9_clk sky130_fd_sc_hd__clkbuf_8
X_6444_ clknet_leaf_44_clk _0852_ _0377_ VGND VGND VPWR VPWR reg_file_inst.registry\[0\]\[5\]
+ sky130_fd_sc_hd__dfrtp_1
XTAP_TAPCELL_ROW_95_1449 VGND VPWR sky130_fd_sc_hd__tapvpwrvgnd_1
X_3656_ _1581_ VGND VGND VPWR VPWR _1582_ sky130_fd_sc_hd__inv_2
X_3587_ MEMOFF\[14\] net78 _1113_ VGND VGND VPWR VPWR _1515_ sky130_fd_sc_hd__mux2_4
X_6375_ clknet_leaf_46_clk _0783_ _0308_ VGND VGND VPWR VPWR reg_file_inst.registry\[14\]\[0\]
+ sky130_fd_sc_hd__dfrtp_1
XFILLER_114_251 VGND VGND VPWR VPWR sky130_fd_sc_hd__fill_1
X_5326_ _2419_ reg_file_inst.registry\[8\]\[5\] _2994_ VGND VGND VPWR VPWR _0732_
+ sky130_fd_sc_hd__mux2_1
X_5257_ reg_file_inst.registry\[14\]\[16\] _2883_ _2992_ VGND VGND VPWR VPWR _0799_
+ sky130_fd_sc_hd__mux2_1
XFILLER_88_669 VPWR VGND VPWR VGND sky130_ef_sc_hd__decap_12
XTAP_TAPCELL_ROW_3_301 VGND VPWR sky130_fd_sc_hd__tapvpwrvgnd_1
X_4208_ _1970_ _2102_ VGND VGND VPWR VPWR _2103_ sky130_fd_sc_hd__xnor2_1
XFILLER_68_360 VGND VGND VPWR VPWR sky130_fd_sc_hd__decap_4
X_5188_ _2873_ reg_file_inst.registry\[0\]\[17\] _2988_ VGND VGND VPWR VPWR _0864_
+ sky130_fd_sc_hd__mux2_1
X_4139_ _0950_ _1880_ _2052_ _2053_ VGND VGND VPWR VPWR _2055_ sky130_fd_sc_hd__o2bb2a_1
XFILLER_56_533 VGND VGND VPWR VPWR sky130_fd_sc_hd__decap_8
XTAP_TAPCELL_ROW_39_753 VGND VPWR sky130_fd_sc_hd__tapvpwrvgnd_1
XFILLER_73_38 VPWR VGND VPWR VGND sky130_ef_sc_hd__decap_12
XFILLER_73_27 VGND VGND VPWR VPWR sky130_fd_sc_hd__fill_2
XFILLER_71_514 VPWR VGND VPWR VGND sky130_ef_sc_hd__decap_12
XFILLER_56_577 VGND VGND VPWR VPWR sky130_fd_sc_hd__decap_8
XTAP_TAPCELL_ROW_104_1567 VGND VPWR sky130_fd_sc_hd__tapvpwrvgnd_1
XFILLER_11_113 VGND VGND VPWR VPWR sky130_fd_sc_hd__decap_4
XFILLER_11_124 VPWR VGND VPWR VGND sky130_ef_sc_hd__decap_12
XTAP_TAPCELL_ROW_59_1002 VGND VPWR sky130_fd_sc_hd__tapvpwrvgnd_1
XFILLER_22_53 VGND VGND VPWR VPWR sky130_fd_sc_hd__decap_6
XTAP_TAPCELL_ROW_115_1696 VGND VPWR sky130_fd_sc_hd__tapvpwrvgnd_1
XFILLER_79_603 VPWR VGND VPWR VGND sky130_ef_sc_hd__decap_12
XFILLER_120_221 VPWR VGND VPWR VGND sky130_ef_sc_hd__decap_12
XFILLER_105_273 VGND VGND VPWR VPWR sky130_fd_sc_hd__decap_6
XFILLER_79_636 VPWR VGND VPWR VGND sky130_ef_sc_hd__decap_12
XFILLER_120_265 VPWR VGND VPWR VGND sky130_ef_sc_hd__decap_12
XFILLER_74_363 VGND VGND VPWR VPWR sky130_fd_sc_hd__fill_1
XFILLER_19_279 VGND VGND VPWR VPWR sky130_fd_sc_hd__fill_1
XFILLER_34_227 VPWR VGND VPWR VGND sky130_ef_sc_hd__decap_12
XFILLER_62_569 VPWR VGND VPWR VGND sky130_ef_sc_hd__decap_12
Xclkbuf_3_4__f_clk clknet_0_clk VGND VGND VPWR VPWR clknet_3_4__leaf_clk sky130_fd_sc_hd__clkbuf_16
X_3510_ reg_file_inst.registry\[7\]\[12\] _1133_ _1135_ reg_file_inst.registry\[6\]\[12\]
+ VGND VGND VPWR VPWR _1442_ sky130_fd_sc_hd__a22o_1
XFILLER_8_77 VGND VGND VPWR VPWR sky130_fd_sc_hd__fill_2
XFILLER_7_673 VPWR VGND VPWR VGND sky130_ef_sc_hd__decap_12
X_4490_ net40 _2117_ _2308_ net69 net101 VGND VGND VPWR VPWR _2374_ sky130_fd_sc_hd__a221o_1
X_3441_ reg_file_inst.registry\[2\]\[16\] _1083_ _1086_ reg_file_inst.registry\[7\]\[16\]
+ _1374_ VGND VGND VPWR VPWR _1375_ sky130_fd_sc_hd__a221o_1
X_3372_ reg_file_inst.registry\[7\]\[20\] _1119_ _1132_ VGND VGND VPWR VPWR _1309_
+ sky130_fd_sc_hd__and3_1
X_6160_ clknet_leaf_4_clk _0568_ _0093_ VGND VGND VPWR VPWR JMPOFF\[9\] sky130_fd_sc_hd__dfrtp_4
X_5111_ _1529_ _2124_ _2289_ VGND VGND VPWR VPWR _2938_ sky130_fd_sc_hd__o21a_1
X_6091_ clknet_leaf_31_clk _0499_ _0024_ VGND VGND VPWR VPWR reg_file_inst.registry\[15\]\[24\]
+ sky130_fd_sc_hd__dfrtp_1
XFILLER_85_639 VPWR VGND VPWR VGND sky130_ef_sc_hd__decap_12
X_5042_ _1392_ _2282_ _2876_ _2878_ VGND VGND VPWR VPWR _2879_ sky130_fd_sc_hd__o211ai_2
XFILLER_38_533 VGND VGND VPWR VPWR sky130_fd_sc_hd__decap_4
XTAP_TAPCELL_ROW_36_712 VGND VPWR sky130_fd_sc_hd__tapvpwrvgnd_1
X_5944_ net44 VGND VGND VPWR VPWR _0352_ sky130_fd_sc_hd__inv_2
XFILLER_80_377 VPWR VGND VPWR VGND sky130_ef_sc_hd__decap_12
XFILLER_40_208 VGND VGND VPWR VPWR sky130_fd_sc_hd__fill_2
X_5875_ net148 VGND VGND VPWR VPWR _0283_ sky130_fd_sc_hd__inv_2
X_4826_ _1791_ _2273_ VGND VGND VPWR VPWR _2685_ sky130_fd_sc_hd__nor2_1
X_4757_ _1620_ _2615_ VGND VGND VPWR VPWR _2616_ sky130_fd_sc_hd__nand2_1
XFILLER_107_505 VPWR VGND VPWR VGND sky130_ef_sc_hd__decap_12
X_4688_ _0960_ net42 _1111_ VGND VGND VPWR VPWR _2551_ sky130_fd_sc_hd__and3_2
X_3708_ _1347_ _1358_ _1369_ _1345_ _1334_ VGND VGND VPWR VPWR _1632_ sky130_fd_sc_hd__o32a_1
XFILLER_104_8 VPWR VGND VPWR VGND sky130_ef_sc_hd__decap_12
X_6427_ clknet_leaf_32_clk _0835_ _0360_ VGND VGND VPWR VPWR reg_file_inst.registry\[1\]\[24\]
+ sky130_fd_sc_hd__dfrtp_1
X_3639_ MEMOFF\[10\] _1113_ VGND VGND VPWR VPWR _1565_ sky130_fd_sc_hd__or2_1
X_6358_ clknet_leaf_0_clk _0766_ _0291_ VGND VGND VPWR VPWR reg_file_inst.registry\[2\]\[11\]
+ sky130_fd_sc_hd__dfrtp_1
XFILLER_102_221 VGND VGND VPWR VPWR sky130_fd_sc_hd__fill_1
XFILLER_88_433 VPWR VGND VPWR VGND sky130_ef_sc_hd__decap_12
X_5309_ _2817_ reg_file_inst.registry\[8\]\[22\] _2994_ VGND VGND VPWR VPWR _0749_
+ sky130_fd_sc_hd__mux2_1
XFILLER_68_49 VPWR VGND VPWR VGND sky130_ef_sc_hd__decap_12
XFILLER_68_27 VGND VGND VPWR VPWR sky130_fd_sc_hd__fill_1
XFILLER_0_337 VGND VGND VPWR VPWR sky130_fd_sc_hd__decap_8
XFILLER_88_466 VGND VGND VPWR VPWR sky130_fd_sc_hd__decap_8
X_6289_ clknet_leaf_23_clk _0697_ _0222_ VGND VGND VPWR VPWR MEMOFF\[26\] sky130_fd_sc_hd__dfrtp_1
XFILLER_75_149 VGND VGND VPWR VPWR sky130_fd_sc_hd__decap_6
XFILLER_56_363 VGND VGND VPWR VPWR sky130_fd_sc_hd__fill_1
XFILLER_29_577 VGND VGND VPWR VPWR sky130_fd_sc_hd__decap_6
XFILLER_71_333 VGND VGND VPWR VPWR sky130_fd_sc_hd__decap_3
XFILLER_56_385 VGND VGND VPWR VPWR sky130_fd_sc_hd__decap_8
XFILLER_16_249 VGND VGND VPWR VPWR sky130_fd_sc_hd__decap_3
XTAP_TAPCELL_ROW_65_1072 VGND VPWR sky130_fd_sc_hd__tapvpwrvgnd_1
XTAP_TAPCELL_ROW_14_439 VGND VPWR sky130_fd_sc_hd__tapvpwrvgnd_1
XFILLER_8_437 VGND VGND VPWR VPWR sky130_fd_sc_hd__fill_1
XFILLER_12_466 VGND VGND VPWR VPWR sky130_fd_sc_hd__decap_3
XTAP_TAPCELL_ROW_117_1725 VGND VPWR sky130_fd_sc_hd__tapvpwrvgnd_1
XFILLER_99_709 VPWR VGND VPWR VGND sky130_ef_sc_hd__decap_12
XFILLER_4_643 VGND VGND VPWR VPWR sky130_fd_sc_hd__fill_1
XFILLER_121_541 VPWR VGND VPWR VGND sky130_ef_sc_hd__decap_12
XFILLER_67_617 VPWR VGND VPWR VGND sky130_ef_sc_hd__decap_12
XFILLER_121_585 VPWR VGND VPWR VGND sky130_ef_sc_hd__decap_12
XFILLER_62_333 VGND VGND VPWR VPWR sky130_fd_sc_hd__decap_6
XFILLER_47_396 VGND VGND VPWR VPWR sky130_fd_sc_hd__decap_8
XFILLER_35_558 VGND VGND VPWR VPWR sky130_fd_sc_hd__fill_2
X_3990_ net106 net131 _1905_ VGND VGND VPWR VPWR _1906_ sky130_fd_sc_hd__and3_1
X_5660_ net147 VGND VGND VPWR VPWR _0068_ sky130_fd_sc_hd__inv_2
X_4611_ _2192_ _2484_ _2487_ _2249_ _2255_ VGND VGND VPWR VPWR _2488_ sky130_fd_sc_hd__o221a_1
X_5591_ reg_file_inst.registry\[15\]\[1\] _2528_ _3003_ VGND VGND VPWR VPWR _0476_
+ sky130_fd_sc_hd__mux2_1
XTAP_TAPCELL_ROW_41_781 VGND VPWR sky130_fd_sc_hd__tapvpwrvgnd_1
X_4542_ _2330_ _2345_ _1816_ VGND VGND VPWR VPWR _2423_ sky130_fd_sc_hd__mux2_1
XTAP_TAPCELL_ROW_92_1408 VGND VPWR sky130_fd_sc_hd__tapvpwrvgnd_1
Xmax_cap134 _1817_ VGND VGND VPWR VPWR net134 sky130_fd_sc_hd__buf_4
X_4473_ _2202_ _2357_ _1840_ VGND VGND VPWR VPWR _2358_ sky130_fd_sc_hd__mux2_1
XFILLER_116_357 VGND VGND VPWR VPWR sky130_fd_sc_hd__decap_6
XFILLER_104_508 VPWR VGND VPWR VGND sky130_ef_sc_hd__decap_12
XTAP_TAPCELL_ROW_92_1419 VGND VPWR sky130_fd_sc_hd__tapvpwrvgnd_1
X_3424_ reg_file_inst.registry\[4\]\[18\] _1114_ net142 VGND VGND VPWR VPWR _1359_
+ sky130_fd_sc_hd__and3_1
X_6212_ clknet_leaf_44_clk _0620_ _0145_ VGND VGND VPWR VPWR reg_file_inst.registry\[10\]\[5\]
+ sky130_fd_sc_hd__dfrtp_1
XPHY_EDGE_ROW_115_Right_115 VGND VGND VPWR VPWR sky130_fd_sc_hd__decap_3
X_3355_ reg_file_inst.registry\[5\]\[21\] _1139_ _1288_ _1291_ _1292_ VGND VGND VPWR
+ VPWR _1293_ sky130_fd_sc_hd__a2111o_1
X_6143_ clknet_leaf_29_clk _0551_ _0076_ VGND VGND VPWR VPWR reg_file_inst.registry\[6\]\[20\]
+ sky130_fd_sc_hd__dfrtp_1
X_3286_ reg_file_inst.registry\[1\]\[23\] _1087_ _1093_ reg_file_inst.registry\[15\]\[23\]
+ VGND VGND VPWR VPWR _1226_ sky130_fd_sc_hd__a22o_1
XFILLER_58_628 VGND VGND VPWR VPWR sky130_fd_sc_hd__decap_4
X_6074_ clknet_leaf_47_clk _0482_ _0007_ VGND VGND VPWR VPWR reg_file_inst.registry\[15\]\[7\]
+ sky130_fd_sc_hd__dfrtp_1
X_5025_ _1392_ _2654_ _2656_ VGND VGND VPWR VPWR _2864_ sky130_fd_sc_hd__a21oi_1
XFILLER_72_119 VGND VGND VPWR VPWR sky130_fd_sc_hd__fill_2
XFILLER_38_363 VGND VGND VPWR VPWR sky130_fd_sc_hd__fill_1
XTAP_TAPCELL_ROW_49_881 VGND VPWR sky130_fd_sc_hd__tapvpwrvgnd_1
XFILLER_81_653 VPWR VGND VPWR VGND sky130_ef_sc_hd__decap_12
X_5927_ net44 VGND VGND VPWR VPWR _0335_ sky130_fd_sc_hd__inv_2
XFILLER_53_377 VPWR VGND VPWR VGND sky130_ef_sc_hd__decap_12
XTAP_TAPCELL_ROW_101_1526 VGND VPWR sky130_fd_sc_hd__tapvpwrvgnd_1
X_5858_ net147 VGND VGND VPWR VPWR _0266_ sky130_fd_sc_hd__inv_2
XFILLER_21_241 VGND VGND VPWR VPWR sky130_fd_sc_hd__decap_8
X_5789_ net149 VGND VGND VPWR VPWR _0197_ sky130_fd_sc_hd__inv_2
X_4809_ _2655_ _2658_ _2662_ _2667_ VGND VGND VPWR VPWR _2668_ sky130_fd_sc_hd__or4b_1
XPHY_EDGE_ROW_17_Right_17 VGND VGND VPWR VPWR sky130_fd_sc_hd__decap_3
XFILLER_119_55 VGND VGND VPWR VPWR sky130_fd_sc_hd__fill_1
XFILLER_107_335 VGND VGND VPWR VPWR sky130_fd_sc_hd__fill_1
XFILLER_122_305 VGND VGND VPWR VPWR sky130_fd_sc_hd__decap_3
XFILLER_122_349 VPWR VGND VPWR VGND sky130_ef_sc_hd__decap_12
XTAP_TAPCELL_ROW_112_1666 VGND VPWR sky130_fd_sc_hd__tapvpwrvgnd_1
XFILLER_103_541 VPWR VGND VPWR VGND sky130_ef_sc_hd__decap_12
XFILLER_103_585 VPWR VGND VPWR VGND sky130_ef_sc_hd__decap_12
XFILLER_0_167 VGND VGND VPWR VPWR sky130_fd_sc_hd__fill_1
XPHY_EDGE_ROW_26_Right_26 VGND VGND VPWR VPWR sky130_fd_sc_hd__decap_3
XFILLER_76_447 VGND VGND VPWR VPWR sky130_fd_sc_hd__decap_8
XFILLER_76_436 VGND VGND VPWR VPWR sky130_fd_sc_hd__decap_8
XFILLER_28_41 VGND VGND VPWR VPWR sky130_fd_sc_hd__decap_4
XFILLER_48_149 VGND VGND VPWR VPWR sky130_fd_sc_hd__fill_1
XFILLER_91_428 VPWR VGND VPWR VGND sky130_ef_sc_hd__decap_12
XTAP_TAPCELL_ROW_67_1101 VGND VPWR sky130_fd_sc_hd__tapvpwrvgnd_1
XFILLER_44_333 VGND VGND VPWR VPWR sky130_fd_sc_hd__decap_6
XFILLER_44_40 VPWR VGND VPWR VGND sky130_ef_sc_hd__decap_12
XPHY_EDGE_ROW_4_Left_127 VGND VGND VPWR VPWR sky130_fd_sc_hd__decap_3
XTAP_TAPCELL_ROW_27_597 VGND VPWR sky130_fd_sc_hd__tapvpwrvgnd_1
XFILLER_44_73 VGND VGND VPWR VPWR sky130_fd_sc_hd__decap_8
XFILLER_44_95 VPWR VGND VPWR VGND sky130_ef_sc_hd__decap_12
XPHY_EDGE_ROW_35_Right_35 VGND VGND VPWR VPWR sky130_fd_sc_hd__decap_3
XFILLER_8_245 VGND VGND VPWR VPWR sky130_fd_sc_hd__decap_6
XTAP_TAPCELL_ROW_78_1241 VGND VPWR sky130_fd_sc_hd__tapvpwrvgnd_1
XFILLER_113_305 VPWR VGND VPWR VGND sky130_ef_sc_hd__decap_12
XFILLER_4_451 VGND VGND VPWR VPWR sky130_fd_sc_hd__decap_4
XFILLER_4_495 VGND VGND VPWR VPWR sky130_fd_sc_hd__fill_1
XFILLER_113_349 VPWR VGND VPWR VGND sky130_ef_sc_hd__decap_12
XPHY_EDGE_ROW_44_Right_44 VGND VGND VPWR VPWR sky130_fd_sc_hd__decap_3
X_3140_ net34 net41 net40 VGND VGND VPWR VPWR _1084_ sky130_fd_sc_hd__nor3b_4
XFILLER_39_105 VGND VGND VPWR VPWR sky130_fd_sc_hd__fill_2
XFILLER_121_393 VPWR VGND VPWR VGND sky130_ef_sc_hd__decap_12
XFILLER_79_296 VGND VGND VPWR VPWR sky130_fd_sc_hd__decap_4
XFILLER_67_458 VGND VGND VPWR VPWR sky130_fd_sc_hd__decap_3
XFILLER_94_277 VGND VGND VPWR VPWR sky130_fd_sc_hd__decap_8
XFILLER_85_80 VGND VGND VPWR VPWR sky130_fd_sc_hd__fill_1
X_3071_ _1005_ _1014_ VGND VGND VPWR VPWR _1015_ sky130_fd_sc_hd__nand2b_1
XTAP_TAPCELL_ROW_89_1381 VGND VPWR sky130_fd_sc_hd__tapvpwrvgnd_1
XFILLER_54_119 VGND VGND VPWR VPWR sky130_fd_sc_hd__decap_3
XFILLER_90_450 VGND VGND VPWR VPWR sky130_fd_sc_hd__decap_4
XFILLER_62_141 VPWR VGND VPWR VGND sky130_ef_sc_hd__decap_12
XTAP_TAPCELL_ROW_46_840 VGND VPWR sky130_fd_sc_hd__tapvpwrvgnd_1
XPHY_EDGE_ROW_53_Right_53 VGND VGND VPWR VPWR sky130_fd_sc_hd__decap_3
X_5712_ net146 VGND VGND VPWR VPWR _0120_ sky130_fd_sc_hd__inv_2
X_3973_ _1045_ _1888_ _1051_ VGND VGND VPWR VPWR _1889_ sky130_fd_sc_hd__a21o_1
XFILLER_31_561 VGND VGND VPWR VPWR sky130_fd_sc_hd__fill_1
X_5643_ net146 VGND VGND VPWR VPWR _0051_ sky130_fd_sc_hd__inv_2
X_5574_ reg_file_inst.registry\[15\]\[18\] _2863_ _3003_ VGND VGND VPWR VPWR _0493_
+ sky130_fd_sc_hd__mux2_1
XFILLER_116_121 VPWR VGND VPWR VGND sky130_ef_sc_hd__decap_12
X_4525_ _2124_ _2254_ _1736_ VGND VGND VPWR VPWR _2408_ sky130_fd_sc_hd__a21o_1
XFILLER_116_165 VPWR VGND VPWR VGND sky130_ef_sc_hd__decap_12
XPHY_EDGE_ROW_62_Right_62 VGND VGND VPWR VPWR sky130_fd_sc_hd__decap_3
X_4456_ _1392_ _2190_ _1840_ VGND VGND VPWR VPWR _2341_ sky130_fd_sc_hd__a21oi_1
X_3407_ reg_file_inst.registry\[6\]\[19\] _1135_ _1142_ reg_file_inst.registry\[1\]\[19\]
+ VGND VGND VPWR VPWR _1343_ sky130_fd_sc_hd__a22o_1
X_4387_ _2274_ VGND VGND VPWR VPWR _2275_ sky130_fd_sc_hd__inv_2
XFILLER_86_701 VPWR VGND VPWR VGND sky130_ef_sc_hd__decap_12
X_3338_ reg_file_inst.registry\[14\]\[21\] _1081_ _1093_ reg_file_inst.registry\[15\]\[21\]
+ VGND VGND VPWR VPWR _1276_ sky130_fd_sc_hd__a22o_1
X_6126_ clknet_leaf_58_clk _0534_ _0059_ VGND VGND VPWR VPWR reg_file_inst.registry\[6\]\[3\]
+ sky130_fd_sc_hd__dfrtp_1
XFILLER_105_57 VPWR VGND VPWR VGND sky130_ef_sc_hd__decap_12
X_3269_ reg_file_inst.registry\[9\]\[24\] _1131_ _1141_ reg_file_inst.registry\[11\]\[24\]
+ VGND VGND VPWR VPWR _1210_ sky130_fd_sc_hd__a22o_1
XFILLER_85_255 VGND VGND VPWR VPWR sky130_fd_sc_hd__fill_1
X_6057_ net146 VGND VGND VPWR VPWR _0465_ sky130_fd_sc_hd__inv_2
XFILLER_39_661 VGND VGND VPWR VPWR sky130_fd_sc_hd__decap_8
X_5008_ _2472_ _2801_ _2850_ VGND VGND VPWR VPWR _2851_ sky130_fd_sc_hd__a21bo_1
XFILLER_38_182 VGND VGND VPWR VPWR sky130_fd_sc_hd__fill_1
XFILLER_81_27 VGND VGND VPWR VPWR sky130_fd_sc_hd__decap_8
XPHY_EDGE_ROW_71_Right_71 VGND VGND VPWR VPWR sky130_fd_sc_hd__decap_3
XFILLER_14_528 VGND VGND VPWR VPWR sky130_fd_sc_hd__decap_4
XTAP_TAPCELL_ROW_62_1042 VGND VPWR sky130_fd_sc_hd__tapvpwrvgnd_1
XFILLER_10_701 VPWR VGND VPWR VGND sky130_ef_sc_hd__decap_12
XTAP_TAPCELL_ROW_24_567 VGND VPWR sky130_fd_sc_hd__tapvpwrvgnd_1
XPHY_EDGE_ROW_80_Right_80 VGND VGND VPWR VPWR sky130_fd_sc_hd__decap_3
XFILLER_122_113 VPWR VGND VPWR VGND sky130_ef_sc_hd__decap_12
XFILLER_108_699 VGND VGND VPWR VPWR sky130_fd_sc_hd__fill_1
XTAP_TAPCELL_ROW_73_1182 VGND VPWR sky130_fd_sc_hd__tapvpwrvgnd_1
XTAP_TAPCELL_ROW_73_1171 VGND VPWR sky130_fd_sc_hd__tapvpwrvgnd_1
XFILLER_39_84 VGND VGND VPWR VPWR sky130_fd_sc_hd__fill_2
XFILLER_49_447 VGND VGND VPWR VPWR sky130_fd_sc_hd__fill_1
XFILLER_91_225 VPWR VGND VPWR VGND sky130_ef_sc_hd__decap_12
XFILLER_91_258 VGND VGND VPWR VPWR sky130_fd_sc_hd__fill_2
XFILLER_44_130 VGND VGND VPWR VPWR sky130_fd_sc_hd__fill_1
XFILLER_60_623 VPWR VGND VPWR VGND sky130_ef_sc_hd__decap_12
XFILLER_60_601 VPWR VGND VPWR VGND sky130_ef_sc_hd__decap_12
XFILLER_55_83 VPWR VGND VPWR VGND sky130_ef_sc_hd__decap_12
XFILLER_17_377 VGND VGND VPWR VPWR sky130_fd_sc_hd__fill_1
XFILLER_45_697 VGND VGND VPWR VPWR sky130_fd_sc_hd__decap_6
XFILLER_60_645 VGND VGND VPWR VPWR sky130_fd_sc_hd__decap_8
XFILLER_32_336 VGND VGND VPWR VPWR sky130_fd_sc_hd__decap_6
XFILLER_13_561 VPWR VGND VPWR VGND sky130_ef_sc_hd__decap_12
XFILLER_71_71 VPWR VGND VPWR VGND sky130_ef_sc_hd__decap_12
XFILLER_118_419 VGND VGND VPWR VPWR sky130_fd_sc_hd__fill_1
XFILLER_114_625 VPWR VGND VPWR VGND sky130_ef_sc_hd__decap_12
XFILLER_113_113 VPWR VGND VPWR VGND sky130_ef_sc_hd__decap_12
X_5290_ _2934_ reg_file_inst.registry\[2\]\[12\] _2993_ VGND VGND VPWR VPWR _0767_
+ sky130_fd_sc_hd__mux2_1
X_4310_ _1491_ _2190_ VGND VGND VPWR VPWR _2198_ sky130_fd_sc_hd__and2_1
XFILLER_114_669 VPWR VGND VPWR VGND sky130_ef_sc_hd__decap_12
XFILLER_99_358 VPWR VGND VPWR VGND sky130_ef_sc_hd__decap_12
X_4241_ _1708_ _1735_ VGND VGND VPWR VPWR _2129_ sky130_fd_sc_hd__or2_4
XFILLER_68_701 VGND VGND VPWR VPWR sky130_fd_sc_hd__decap_4
X_4172_ _1993_ _2002_ _2001_ VGND VGND VPWR VPWR _2079_ sky130_fd_sc_hd__o21ba_1
X_3123_ _1064_ _1066_ VGND VGND VPWR VPWR _1067_ sky130_fd_sc_hd__or2_1
XFILLER_95_597 VPWR VGND VPWR VGND sky130_ef_sc_hd__decap_12
X_3054_ JMPOFF\[5\] _0966_ VGND VGND VPWR VPWR _0998_ sky130_fd_sc_hd__nand2_1
XFILLER_48_491 VPWR VGND VPWR VGND sky130_ef_sc_hd__decap_12
XFILLER_51_623 VGND VGND VPWR VPWR sky130_fd_sc_hd__decap_8
XFILLER_51_612 VGND VGND VPWR VPWR sky130_fd_sc_hd__decap_4
XFILLER_23_325 VGND VGND VPWR VPWR sky130_fd_sc_hd__decap_8
X_3956_ _1221_ _1871_ VGND VGND VPWR VPWR _1872_ sky130_fd_sc_hd__nand2_1
XTAP_TAPCELL_ROW_21_526 VGND VPWR sky130_fd_sc_hd__tapvpwrvgnd_1
X_5626_ net148 VGND VGND VPWR VPWR _0034_ sky130_fd_sc_hd__inv_2
X_3887_ reg_file_inst.registry\[5\]\[1\] _1078_ _1084_ VGND VGND VPWR VPWR _1805_
+ sky130_fd_sc_hd__and3_1
XFILLER_117_441 VGND VGND VPWR VPWR sky130_fd_sc_hd__decap_6
X_5557_ _2375_ reg_file_inst.registry\[9\]\[6\] _3002_ VGND VGND VPWR VPWR _0509_
+ sky130_fd_sc_hd__mux2_1
XFILLER_117_485 VPWR VGND VPWR VGND sky130_ef_sc_hd__decap_12
X_5488_ JMPOFF\[17\] _2873_ _3000_ VGND VGND VPWR VPWR _0576_ sky130_fd_sc_hd__mux2_1
X_4508_ _2204_ _2239_ _1816_ VGND VGND VPWR VPWR _2391_ sky130_fd_sc_hd__mux2_1
XFILLER_2_229 VPWR VGND VPWR VGND sky130_ef_sc_hd__decap_12
X_4439_ _1679_ _2123_ _2286_ _1693_ _2288_ VGND VGND VPWR VPWR _2324_ sky130_fd_sc_hd__a221o_1
XFILLER_104_168 VGND VGND VPWR VPWR sky130_fd_sc_hd__decap_4
XFILLER_98_380 VPWR VGND VPWR VGND sky130_ef_sc_hd__decap_12
XFILLER_86_531 VGND VGND VPWR VPWR sky130_fd_sc_hd__fill_1
XFILLER_76_27 VGND VGND VPWR VPWR sky130_fd_sc_hd__fill_1
X_6109_ clknet_leaf_12_clk _0517_ _0042_ VGND VGND VPWR VPWR reg_file_inst.registry\[9\]\[14\]
+ sky130_fd_sc_hd__dfrtp_1
XFILLER_73_225 VGND VGND VPWR VPWR sky130_fd_sc_hd__decap_8
XTAP_TAPCELL_ROW_29_626 VGND VPWR sky130_fd_sc_hd__tapvpwrvgnd_1
XFILLER_46_417 VGND VGND VPWR VPWR sky130_fd_sc_hd__decap_3
XFILLER_92_26 VGND VGND VPWR VPWR sky130_fd_sc_hd__fill_2
XPHY_EDGE_ROW_85_Left_208 VGND VGND VPWR VPWR sky130_fd_sc_hd__decap_3
XFILLER_73_269 VGND VGND VPWR VPWR sky130_fd_sc_hd__fill_2
XTAP_TAPCELL_ROW_57_979 VGND VPWR sky130_fd_sc_hd__tapvpwrvgnd_1
XFILLER_92_59 VPWR VGND VPWR VGND sky130_ef_sc_hd__decap_12
XFILLER_92_37 VGND VGND VPWR VPWR sky130_fd_sc_hd__fill_2
XFILLER_54_472 VGND VGND VPWR VPWR sky130_fd_sc_hd__decap_4
XTAP_TAPCELL_ROW_1_273 VGND VPWR sky130_fd_sc_hd__tapvpwrvgnd_1
XFILLER_26_141 VGND VGND VPWR VPWR sky130_fd_sc_hd__decap_4
XTAP_TAPCELL_ROW_107_1598 VGND VPWR sky130_fd_sc_hd__tapvpwrvgnd_1
XFILLER_14_347 VGND VGND VPWR VPWR sky130_fd_sc_hd__fill_1
XFILLER_25_42 VPWR VGND VPWR VGND sky130_ef_sc_hd__decap_12
XFILLER_25_86 VGND VGND VPWR VPWR sky130_fd_sc_hd__fill_1
XFILLER_42_678 VGND VGND VPWR VPWR sky130_fd_sc_hd__decap_3
XTAP_TAPCELL_ROW_120_1765 VGND VPWR sky130_fd_sc_hd__tapvpwrvgnd_1
XFILLER_22_380 VGND VGND VPWR VPWR sky130_fd_sc_hd__fill_2
XPHY_EDGE_ROW_94_Left_217 VGND VGND VPWR VPWR sky130_fd_sc_hd__decap_3
XTAP_TAPCELL_ROW_75_1200 VGND VPWR sky130_fd_sc_hd__tapvpwrvgnd_1
XFILLER_6_557 VPWR VGND VPWR VGND sky130_ef_sc_hd__decap_12
XFILLER_111_617 VPWR VGND VPWR VGND sky130_ef_sc_hd__decap_12
XFILLER_96_306 VGND VGND VPWR VPWR sky130_fd_sc_hd__fill_2
XTAP_TAPCELL_ROW_9_373 VGND VPWR sky130_fd_sc_hd__tapvpwrvgnd_1
XFILLER_77_520 VGND VGND VPWR VPWR sky130_fd_sc_hd__decap_4
XFILLER_77_564 VGND VGND VPWR VPWR sky130_fd_sc_hd__decap_8
XTAP_TAPCELL_ROW_86_1340 VGND VPWR sky130_fd_sc_hd__tapvpwrvgnd_1
XFILLER_92_589 VPWR VGND VPWR VGND sky130_ef_sc_hd__decap_12
XFILLER_92_578 VGND VGND VPWR VPWR sky130_fd_sc_hd__decap_8
XFILLER_18_675 VGND VGND VPWR VPWR sky130_fd_sc_hd__fill_1
XFILLER_32_111 VGND VGND VPWR VPWR sky130_fd_sc_hd__fill_2
XFILLER_33_634 VGND VGND VPWR VPWR sky130_fd_sc_hd__decap_8
XFILLER_45_483 VGND VGND VPWR VPWR sky130_fd_sc_hd__fill_1
X_3810_ JMPOFF\[5\] _1095_ _1098_ reg_file_inst.registry\[10\]\[5\] VGND VGND VPWR
+ VPWR _1731_ sky130_fd_sc_hd__a22o_1
X_4790_ _2635_ _2636_ _2644_ _2648_ VGND VGND VPWR VPWR _2649_ sky130_fd_sc_hd__or4_1
XANTENNA_29 net142 VGND VGND VPWR VPWR sky130_fd_sc_hd__diode_2
X_3741_ reg_file_inst.registry\[6\]\[7\] _1135_ _1138_ reg_file_inst.registry\[14\]\[7\]
+ _1661_ VGND VGND VPWR VPWR _1665_ sky130_fd_sc_hd__a221o_1
XANTENNA_18 net84 VGND VGND VPWR VPWR sky130_fd_sc_hd__diode_2
XFILLER_32_188 VGND VGND VPWR VPWR sky130_fd_sc_hd__decap_8
X_6460_ clknet_leaf_29_clk _0868_ _0393_ VGND VGND VPWR VPWR reg_file_inst.registry\[0\]\[21\]
+ sky130_fd_sc_hd__dfrtp_1
XFILLER_70_3 VGND VGND VPWR VPWR sky130_fd_sc_hd__decap_8
XFILLER_9_373 VGND VGND VPWR VPWR sky130_fd_sc_hd__decap_3
XFILLER_9_362 VGND VGND VPWR VPWR sky130_fd_sc_hd__fill_2
X_3672_ reg_file_inst.registry\[5\]\[8\] _1078_ _1084_ VGND VGND VPWR VPWR _1597_
+ sky130_fd_sc_hd__and3_1
X_6391_ clknet_leaf_17_clk _0799_ _0324_ VGND VGND VPWR VPWR reg_file_inst.registry\[14\]\[16\]
+ sky130_fd_sc_hd__dfrtp_1
X_5411_ reg_file_inst.registry\[4\]\[7\] _2311_ _2997_ VGND VGND VPWR VPWR _0650_
+ sky130_fd_sc_hd__mux2_1
XTAP_TAPCELL_ROW_97_1480 VGND VPWR sky130_fd_sc_hd__tapvpwrvgnd_1
X_5342_ _2863_ reg_file_inst.registry\[3\]\[18\] _2995_ VGND VGND VPWR VPWR _0717_
+ sky130_fd_sc_hd__mux2_1
Xoutput114 net114 VGND VGND VPWR VPWR IC[20] sky130_fd_sc_hd__buf_1
Xoutput125 net125 VGND VGND VPWR VPWR IC[5] sky130_fd_sc_hd__buf_1
Xoutput103 net103 VGND VGND VPWR VPWR IC[10] sky130_fd_sc_hd__buf_1
XFILLER_114_433 VPWR VGND VPWR VGND sky130_ef_sc_hd__decap_12
XFILLER_114_477 VPWR VGND VPWR VGND sky130_ef_sc_hd__decap_12
X_5273_ reg_file_inst.registry\[14\]\[0\] _2550_ _2992_ VGND VGND VPWR VPWR _0783_
+ sky130_fd_sc_hd__mux2_1
X_4224_ _1111_ _1873_ VGND VGND VPWR VPWR net102 sky130_fd_sc_hd__and2_4
X_4155_ _2049_ _2067_ _2044_ VGND VGND VPWR VPWR _2068_ sky130_fd_sc_hd__a21oi_1
XFILLER_55_225 VGND VGND VPWR VPWR sky130_fd_sc_hd__decap_8
X_3106_ JMPOFF\[15\] net141 net41 VGND VGND VPWR VPWR _1050_ sky130_fd_sc_hd__a21o_1
X_4086_ _0951_ _2000_ VGND VGND VPWR VPWR _2002_ sky130_fd_sc_hd__xnor2_1
X_3037_ JMPOFF\[20\] net141 net41 VGND VGND VPWR VPWR _0981_ sky130_fd_sc_hd__a21o_1
XTAP_TAPCELL_ROW_54_938 VGND VPWR sky130_fd_sc_hd__tapvpwrvgnd_1
XFILLER_36_450 VPWR VGND VPWR VGND sky130_ef_sc_hd__decap_12
XFILLER_23_111 VGND VGND VPWR VPWR sky130_fd_sc_hd__fill_1
XFILLER_62_29 VGND VGND VPWR VPWR sky130_fd_sc_hd__decap_6
XFILLER_24_689 VGND VGND VPWR VPWR sky130_fd_sc_hd__fill_1
XFILLER_11_306 VGND VGND VPWR VPWR sky130_fd_sc_hd__decap_3
X_4988_ net136 _2777_ VGND VGND VPWR VPWR _2833_ sky130_fd_sc_hd__nor2_1
XTAP_TAPCELL_ROW_34_684 VGND VPWR sky130_fd_sc_hd__tapvpwrvgnd_1
XTAP_TAPCELL_ROW_34_695 VGND VPWR sky130_fd_sc_hd__tapvpwrvgnd_1
XFILLER_109_205 VPWR VGND VPWR VGND sky130_ef_sc_hd__decap_12
X_3939_ _1827_ _1853_ _1779_ _1803_ VGND VGND VPWR VPWR _1855_ sky130_fd_sc_hd__a211oi_1
XFILLER_109_249 VPWR VGND VPWR VGND sky130_ef_sc_hd__decap_12
X_5609_ net148 VGND VGND VPWR VPWR _0017_ sky130_fd_sc_hd__inv_2
XFILLER_11_55 VGND VGND VPWR VPWR sky130_fd_sc_hd__fill_1
XFILLER_3_505 VPWR VGND VPWR VGND sky130_ef_sc_hd__decap_12
XFILLER_117_293 VPWR VGND VPWR VGND sky130_ef_sc_hd__decap_12
XFILLER_87_15 VGND VGND VPWR VPWR sky130_fd_sc_hd__decap_4
XTAP_TAPCELL_ROW_70_1141 VGND VPWR sky130_fd_sc_hd__tapvpwrvgnd_1
XFILLER_59_520 VPWR VGND VPWR VGND sky130_ef_sc_hd__decap_12
XTAP_TAPCELL_ROW_6_343 VGND VPWR sky130_fd_sc_hd__tapvpwrvgnd_1
XFILLER_120_469 VGND VGND VPWR VPWR sky130_fd_sc_hd__decap_6
XTAP_TAPCELL_ROW_109_1627 VGND VPWR sky130_fd_sc_hd__tapvpwrvgnd_1
XFILLER_19_428 VPWR VGND VPWR VGND sky130_ef_sc_hd__decap_12
XFILLER_100_193 VGND VGND VPWR VPWR sky130_fd_sc_hd__decap_3
XFILLER_100_182 VGND VGND VPWR VPWR sky130_fd_sc_hd__fill_2
XTAP_TAPCELL_ROW_122_1805 VGND VPWR sky130_fd_sc_hd__tapvpwrvgnd_1
XFILLER_74_589 VPWR VGND VPWR VGND sky130_ef_sc_hd__decap_12
XFILLER_74_578 VGND VGND VPWR VPWR sky130_fd_sc_hd__decap_8
XFILLER_15_601 VPWR VGND VPWR VGND sky130_ef_sc_hd__decap_12
XFILLER_36_41 VPWR VGND VPWR VGND sky130_ef_sc_hd__decap_12
XFILLER_61_228 VPWR VGND VPWR VGND sky130_ef_sc_hd__decap_12
XFILLER_15_645 VGND VGND VPWR VPWR sky130_fd_sc_hd__fill_1
XFILLER_36_85 VPWR VGND VPWR VGND sky130_ef_sc_hd__decap_12
XFILLER_30_604 VGND VGND VPWR VPWR sky130_fd_sc_hd__fill_2
XFILLER_30_626 VGND VGND VPWR VPWR sky130_fd_sc_hd__fill_2
XTAP_TAPCELL_ROW_81_1281 VGND VPWR sky130_fd_sc_hd__tapvpwrvgnd_1
XFILLER_10_350 VPWR VGND VPWR VGND sky130_ef_sc_hd__decap_12
Xinput27 DataMemoryRead[8] VGND VGND VPWR VPWR net27 sky130_fd_sc_hd__clkbuf_1
Xinput16 DataMemoryRead[23] VGND VGND VPWR VPWR net16 sky130_fd_sc_hd__buf_1
Xinput38 instr[4] VGND VGND VPWR VPWR net38 sky130_fd_sc_hd__buf_4
XFILLER_35_6 VPWR VGND VPWR VGND sky130_ef_sc_hd__decap_12
XFILLER_111_447 VGND VGND VPWR VPWR sky130_fd_sc_hd__fill_1
XFILLER_77_350 VGND VGND VPWR VPWR sky130_fd_sc_hd__fill_1
XFILLER_65_534 VPWR VGND VPWR VGND sky130_ef_sc_hd__decap_12
XFILLER_37_225 VGND VGND VPWR VPWR sky130_fd_sc_hd__fill_2
X_5960_ net149 VGND VGND VPWR VPWR _0368_ sky130_fd_sc_hd__inv_2
XFILLER_37_258 VGND VGND VPWR VPWR sky130_fd_sc_hd__decap_8
X_5891_ net44 VGND VGND VPWR VPWR _0299_ sky130_fd_sc_hd__inv_2
X_4911_ _2684_ _2765_ _2762_ _2754_ VGND VGND VPWR VPWR _2766_ sky130_fd_sc_hd__a211o_1
XFILLER_20_103 VPWR VGND VPWR VGND sky130_ef_sc_hd__decap_12
XFILLER_21_615 VGND VGND VPWR VPWR sky130_fd_sc_hd__fill_1
XFILLER_33_497 VGND VGND VPWR VPWR sky130_fd_sc_hd__decap_6
X_4842_ _1108_ _1151_ _2288_ VGND VGND VPWR VPWR _2701_ sky130_fd_sc_hd__o21a_1
XFILLER_119_503 VGND VGND VPWR VPWR sky130_fd_sc_hd__fill_1
XFILLER_60_294 VPWR VGND VPWR VGND sky130_ef_sc_hd__decap_12
X_4773_ _2631_ VGND VGND VPWR VPWR _2632_ sky130_fd_sc_hd__inv_2
X_3724_ reg_file_inst.registry\[2\]\[7\] _1083_ _1098_ reg_file_inst.registry\[10\]\[7\]
+ VGND VGND VPWR VPWR _1648_ sky130_fd_sc_hd__a22o_1
X_6512_ clknet_leaf_44_clk _0920_ _0445_ VGND VGND VPWR VPWR reg_file_inst.registry\[11\]\[5\]
+ sky130_fd_sc_hd__dfrtp_1
XFILLER_20_158 VPWR VGND VPWR VGND sky130_ef_sc_hd__decap_12
XTAP_TAPCELL_ROW_31_654 VGND VPWR sky130_fd_sc_hd__tapvpwrvgnd_1
XFILLER_107_709 VPWR VGND VPWR VGND sky130_ef_sc_hd__decap_12
X_3655_ _1576_ _1580_ reg_file_inst.registry\[0\]\[9\] net138 VGND VGND VPWR VPWR
+ _1581_ sky130_fd_sc_hd__o2bb2a_2
X_6443_ clknet_leaf_54_clk _0851_ _0376_ VGND VGND VPWR VPWR reg_file_inst.registry\[0\]\[4\]
+ sky130_fd_sc_hd__dfrtp_2
X_6374_ clknet_leaf_20_clk _0782_ _0307_ VGND VGND VPWR VPWR reg_file_inst.registry\[2\]\[27\]
+ sky130_fd_sc_hd__dfrtp_1
X_3586_ reg_file_inst.registry\[0\]\[14\] _1118_ _1510_ _1514_ VGND VGND VPWR VPWR
+ net78 sky130_fd_sc_hd__o22a_1
X_5325_ _2375_ reg_file_inst.registry\[8\]\[6\] _2994_ VGND VGND VPWR VPWR _0733_
+ sky130_fd_sc_hd__mux2_1
XFILLER_0_508 VGND VGND VPWR VPWR sky130_fd_sc_hd__decap_6
XFILLER_0_519 VGND VGND VPWR VPWR sky130_fd_sc_hd__decap_8
X_5256_ reg_file_inst.registry\[14\]\[17\] _2873_ _2992_ VGND VGND VPWR VPWR _0800_
+ sky130_fd_sc_hd__mux2_1
XFILLER_87_169 VGND VGND VPWR VPWR sky130_fd_sc_hd__fill_2
XTAP_TAPCELL_ROW_3_302 VGND VPWR sky130_fd_sc_hd__tapvpwrvgnd_1
X_4207_ _0953_ _1942_ _1969_ VGND VGND VPWR VPWR _2102_ sky130_fd_sc_hd__o21bai_1
XFILLER_29_704 VPWR VGND VPWR VGND sky130_ef_sc_hd__decap_12
XFILLER_96_681 VPWR VGND VPWR VGND sky130_ef_sc_hd__decap_12
XFILLER_68_372 VPWR VGND VPWR VGND sky130_ef_sc_hd__decap_12
X_5187_ _2863_ reg_file_inst.registry\[0\]\[18\] _2988_ VGND VGND VPWR VPWR _0865_
+ sky130_fd_sc_hd__mux2_1
XFILLER_28_203 VGND VGND VPWR VPWR sky130_fd_sc_hd__fill_1
X_4138_ net120 _1880_ VGND VGND VPWR VPWR _2054_ sky130_fd_sc_hd__xnor2_1
XFILLER_113_57 VPWR VGND VPWR VGND sky130_ef_sc_hd__decap_12
X_4069_ net103 _1984_ VGND VGND VPWR VPWR _1985_ sky130_fd_sc_hd__xnor2_1
XTAP_TAPCELL_ROW_39_754 VGND VPWR sky130_fd_sc_hd__tapvpwrvgnd_1
XFILLER_71_559 VGND VGND VPWR VPWR sky130_fd_sc_hd__fill_1
XFILLER_71_526 VGND VGND VPWR VPWR sky130_fd_sc_hd__decap_6
XFILLER_24_431 VPWR VGND VPWR VGND sky130_ef_sc_hd__decap_12
XTAP_TAPCELL_ROW_104_1568 VGND VPWR sky130_fd_sc_hd__tapvpwrvgnd_1
XFILLER_11_103 VGND VGND VPWR VPWR sky130_fd_sc_hd__fill_2
XFILLER_24_475 VGND VGND VPWR VPWR sky130_fd_sc_hd__fill_1
XFILLER_11_136 VPWR VGND VPWR VGND sky130_ef_sc_hd__decap_12
XFILLER_11_169 VGND VGND VPWR VPWR sky130_fd_sc_hd__fill_2
XTAP_TAPCELL_ROW_59_1003 VGND VPWR sky130_fd_sc_hd__tapvpwrvgnd_1
XFILLER_118_3 VPWR VGND VPWR VGND sky130_ef_sc_hd__decap_12
XFILLER_3_335 VGND VGND VPWR VPWR sky130_fd_sc_hd__fill_1
XFILLER_79_615 VGND VGND VPWR VPWR sky130_fd_sc_hd__fill_1
XFILLER_0_3 VGND VGND VPWR VPWR sky130_fd_sc_hd__decap_3
XTAP_TAPCELL_ROW_115_1697 VGND VPWR sky130_fd_sc_hd__tapvpwrvgnd_1
XFILLER_79_659 VGND VGND VPWR VPWR sky130_fd_sc_hd__decap_8
XFILLER_79_648 VGND VGND VPWR VPWR sky130_fd_sc_hd__decap_4
XFILLER_120_233 VPWR VGND VPWR VGND sky130_ef_sc_hd__decap_12
XFILLER_66_309 VGND VGND VPWR VPWR sky130_fd_sc_hd__decap_3
XFILLER_120_277 VPWR VGND VPWR VGND sky130_ef_sc_hd__decap_12
XFILLER_19_203 VGND VGND VPWR VPWR sky130_fd_sc_hd__decap_8
XFILLER_74_320 VPWR VGND VPWR VGND sky130_ef_sc_hd__decap_12
XFILLER_19_225 VGND VGND VPWR VPWR sky130_fd_sc_hd__decap_4
XFILLER_19_236 VGND VGND VPWR VPWR sky130_fd_sc_hd__fill_2
XFILLER_19_247 VPWR VGND VPWR VGND sky130_ef_sc_hd__decap_12
XFILLER_47_51 VGND VGND VPWR VPWR sky130_fd_sc_hd__decap_4
XFILLER_47_73 VGND VGND VPWR VPWR sky130_fd_sc_hd__fill_1
XFILLER_47_545 VPWR VGND VPWR VGND sky130_ef_sc_hd__decap_12
XFILLER_34_206 VPWR VGND VPWR VGND sky130_ef_sc_hd__decap_12
XFILLER_74_386 VGND VGND VPWR VPWR sky130_fd_sc_hd__fill_2
XFILLER_62_526 VGND VGND VPWR VPWR sky130_fd_sc_hd__decap_6
XFILLER_34_239 VGND VGND VPWR VPWR sky130_fd_sc_hd__decap_6
XFILLER_63_72 VGND VGND VPWR VPWR sky130_fd_sc_hd__decap_8
XFILLER_7_641 VPWR VGND VPWR VGND sky130_ef_sc_hd__decap_12
XFILLER_7_685 VPWR VGND VPWR VGND sky130_ef_sc_hd__decap_12
X_3440_ reg_file_inst.registry\[6\]\[16\] _1094_ _1096_ reg_file_inst.registry\[11\]\[16\]
+ VGND VGND VPWR VPWR _1374_ sky130_fd_sc_hd__a22o_1
XFILLER_6_195 VGND VGND VPWR VPWR sky130_fd_sc_hd__fill_1
XFILLER_112_701 VPWR VGND VPWR VGND sky130_ef_sc_hd__decap_12
X_3371_ reg_file_inst.registry\[11\]\[20\] _1119_ net144 VGND VGND VPWR VPWR _1308_
+ sky130_fd_sc_hd__and3_1
X_6090_ clknet_leaf_31_clk _0498_ _0023_ VGND VGND VPWR VPWR reg_file_inst.registry\[15\]\[23\]
+ sky130_fd_sc_hd__dfrtp_1
X_5110_ _2603_ _2605_ _2623_ _2935_ _2609_ VGND VGND VPWR VPWR _2937_ sky130_fd_sc_hd__o221a_1
XFILLER_33_3 VGND VGND VPWR VPWR sky130_fd_sc_hd__decap_8
XFILLER_97_467 VPWR VGND VPWR VGND sky130_ef_sc_hd__decap_12
X_5041_ _1383_ _2124_ _2287_ _1393_ _2877_ VGND VGND VPWR VPWR _2878_ sky130_fd_sc_hd__o221a_1
XFILLER_78_681 VPWR VGND VPWR VGND sky130_ef_sc_hd__decap_12
XFILLER_69_169 VGND VGND VPWR VPWR sky130_fd_sc_hd__fill_2
XFILLER_93_673 VPWR VGND VPWR VGND sky130_ef_sc_hd__decap_12
XFILLER_65_386 VGND VGND VPWR VPWR sky130_fd_sc_hd__decap_6
XFILLER_53_548 VGND VGND VPWR VPWR sky130_fd_sc_hd__fill_2
XTAP_TAPCELL_ROW_36_713 VGND VPWR sky130_fd_sc_hd__tapvpwrvgnd_1
X_5943_ net44 VGND VGND VPWR VPWR _0351_ sky130_fd_sc_hd__inv_2
XFILLER_53_559 VGND VGND VPWR VPWR sky130_fd_sc_hd__fill_1
XFILLER_80_389 VPWR VGND VPWR VGND sky130_ef_sc_hd__decap_12
XFILLER_21_401 VGND VGND VPWR VPWR sky130_fd_sc_hd__fill_2
X_5874_ net147 VGND VGND VPWR VPWR _0282_ sky130_fd_sc_hd__inv_2
XTAP_TAPCELL_ROW_16_470 VGND VPWR sky130_fd_sc_hd__tapvpwrvgnd_1
XFILLER_21_423 VGND VGND VPWR VPWR sky130_fd_sc_hd__decap_8
X_4825_ _2249_ _2276_ VGND VGND VPWR VPWR _2684_ sky130_fd_sc_hd__nor2_2
X_4756_ _1607_ _2614_ VGND VGND VPWR VPWR _2615_ sky130_fd_sc_hd__xnor2_1
XFILLER_107_517 VPWR VGND VPWR VGND sky130_ef_sc_hd__decap_12
X_3707_ _1383_ _1392_ _1419_ _1417_ _1404_ VGND VGND VPWR VPWR _1631_ sky130_fd_sc_hd__o32a_1
X_4687_ _2550_ reg_file_inst.registry\[11\]\[8\] _2118_ VGND VGND VPWR VPWR _0907_
+ sky130_fd_sc_hd__mux2_1
X_6426_ clknet_leaf_33_clk _0834_ _0359_ VGND VGND VPWR VPWR reg_file_inst.registry\[1\]\[23\]
+ sky130_fd_sc_hd__dfrtp_1
X_3638_ reg_file_inst.registry\[0\]\[10\] _1118_ _1561_ _1564_ VGND VGND VPWR VPWR
+ net74 sky130_fd_sc_hd__o22a_2
XFILLER_115_561 VPWR VGND VPWR VGND sky130_ef_sc_hd__decap_12
X_6357_ clknet_leaf_29_clk _0765_ _0290_ VGND VGND VPWR VPWR reg_file_inst.registry\[2\]\[10\]
+ sky130_fd_sc_hd__dfrtp_1
X_3569_ reg_file_inst.registry\[4\]\[14\] _1092_ _1095_ JMPOFF\[14\] _1497_ VGND VGND
+ VPWR VPWR _1498_ sky130_fd_sc_hd__a221o_1
X_5308_ _2806_ reg_file_inst.registry\[8\]\[23\] _2994_ VGND VGND VPWR VPWR _0750_
+ sky130_fd_sc_hd__mux2_1
XFILLER_0_305 VGND VGND VPWR VPWR sky130_fd_sc_hd__decap_3
XFILLER_88_445 VPWR VGND VPWR VGND sky130_ef_sc_hd__decap_12
X_6288_ clknet_leaf_31_clk _0696_ _0221_ VGND VGND VPWR VPWR MEMOFF\[25\] sky130_fd_sc_hd__dfrtp_1
XFILLER_0_349 VGND VGND VPWR VPWR sky130_fd_sc_hd__decap_8
XFILLER_76_629 VGND VGND VPWR VPWR sky130_fd_sc_hd__fill_1
X_5239_ _2455_ reg_file_inst.registry\[1\]\[4\] _2990_ VGND VGND VPWR VPWR _0815_
+ sky130_fd_sc_hd__mux2_1
XFILLER_48_309 VGND VGND VPWR VPWR sky130_fd_sc_hd__fill_2
XFILLER_56_331 VPWR VGND VPWR VGND sky130_ef_sc_hd__decap_12
XFILLER_16_217 VPWR VGND VPWR VGND sky130_ef_sc_hd__decap_12
XFILLER_44_548 VPWR VGND VPWR VGND sky130_ef_sc_hd__decap_12
XTAP_TAPCELL_ROW_65_1073 VGND VPWR sky130_fd_sc_hd__tapvpwrvgnd_1
XFILLER_24_261 VGND VGND VPWR VPWR sky130_fd_sc_hd__decap_6
XFILLER_40_710 VPWR VGND VPWR VGND sky130_ef_sc_hd__decap_12
XFILLER_33_42 VPWR VGND VPWR VGND sky130_ef_sc_hd__decap_12
XFILLER_8_405 VPWR VGND VPWR VGND sky130_ef_sc_hd__decap_12
XFILLER_12_489 VGND VGND VPWR VPWR sky130_fd_sc_hd__fill_2
XTAP_TAPCELL_ROW_117_1726 VGND VPWR sky130_fd_sc_hd__tapvpwrvgnd_1
XFILLER_4_699 VGND VGND VPWR VPWR sky130_fd_sc_hd__fill_1
XFILLER_3_187 VGND VGND VPWR VPWR sky130_fd_sc_hd__fill_2
XFILLER_121_553 VGND VGND VPWR VPWR sky130_fd_sc_hd__decap_6
XFILLER_3_198 VGND VGND VPWR VPWR sky130_fd_sc_hd__decap_3
XFILLER_79_478 VGND VGND VPWR VPWR sky130_fd_sc_hd__decap_4
XFILLER_67_629 VPWR VGND VPWR VGND sky130_ef_sc_hd__decap_12
XFILLER_121_597 VPWR VGND VPWR VGND sky130_ef_sc_hd__decap_12
XFILLER_66_139 VGND VGND VPWR VPWR sky130_fd_sc_hd__fill_1
XFILLER_59_180 VGND VGND VPWR VPWR sky130_fd_sc_hd__fill_1
XFILLER_81_109 VGND VGND VPWR VPWR sky130_fd_sc_hd__decap_3
XFILLER_75_673 VPWR VGND VPWR VGND sky130_ef_sc_hd__decap_12
XFILLER_90_643 VGND VGND VPWR VPWR sky130_fd_sc_hd__fill_1
XFILLER_43_581 VPWR VGND VPWR VGND sky130_ef_sc_hd__decap_12
X_4610_ net137 _2485_ _2486_ _2449_ VGND VGND VPWR VPWR _2487_ sky130_fd_sc_hd__o22a_1
XFILLER_30_242 VGND VGND VPWR VPWR sky130_fd_sc_hd__fill_1
X_5590_ reg_file_inst.registry\[15\]\[2\] _2501_ _3003_ VGND VGND VPWR VPWR _0477_
+ sky130_fd_sc_hd__mux2_1
XTAP_TAPCELL_ROW_41_771 VGND VPWR sky130_fd_sc_hd__tapvpwrvgnd_1
XTAP_TAPCELL_ROW_41_782 VGND VPWR sky130_fd_sc_hd__tapvpwrvgnd_1
X_4541_ _2338_ _2342_ net134 VGND VGND VPWR VPWR _2422_ sky130_fd_sc_hd__mux2_1
XTAP_TAPCELL_ROW_92_1409 VGND VPWR sky130_fd_sc_hd__tapvpwrvgnd_1
X_4472_ _1242_ _2190_ VGND VGND VPWR VPWR _2357_ sky130_fd_sc_hd__and2_1
Xmax_cap135 _1817_ VGND VGND VPWR VPWR net135 sky130_fd_sc_hd__buf_6
X_3423_ reg_file_inst.registry\[0\]\[18\] net138 _1350_ _1356_ VGND VGND VPWR VPWR
+ _1358_ sky130_fd_sc_hd__a2bb2o_2
X_6211_ clknet_leaf_55_clk _0619_ _0144_ VGND VGND VPWR VPWR reg_file_inst.registry\[10\]\[4\]
+ sky130_fd_sc_hd__dfrtp_1
X_6142_ clknet_leaf_20_clk _0550_ _0075_ VGND VGND VPWR VPWR reg_file_inst.registry\[6\]\[19\]
+ sky130_fd_sc_hd__dfrtp_1
XFILLER_112_531 VGND VGND VPWR VPWR sky130_fd_sc_hd__fill_1
XFILLER_97_220 VGND VGND VPWR VPWR sky130_fd_sc_hd__decap_4
X_3354_ reg_file_inst.registry\[14\]\[21\] _1138_ _1282_ _1284_ _1286_ VGND VGND VPWR
+ VPWR _1292_ sky130_fd_sc_hd__a2111o_1
XFILLER_97_253 VGND VGND VPWR VPWR sky130_fd_sc_hd__decap_3
X_3285_ reg_file_inst.registry\[14\]\[23\] _1081_ _1098_ reg_file_inst.registry\[10\]\[23\]
+ _1224_ VGND VGND VPWR VPWR _1225_ sky130_fd_sc_hd__a221o_1
XFILLER_85_404 VGND VGND VPWR VPWR sky130_fd_sc_hd__decap_3
XFILLER_57_117 VGND VGND VPWR VPWR sky130_fd_sc_hd__fill_1
X_6073_ clknet_leaf_60_clk _0481_ _0006_ VGND VGND VPWR VPWR reg_file_inst.registry\[15\]\[6\]
+ sky130_fd_sc_hd__dfrtp_1
X_5024_ reg_file_inst.registry\[7\]\[18\] _2863_ _2553_ VGND VGND VPWR VPWR _0893_
+ sky130_fd_sc_hd__mux2_1
XFILLER_66_651 VGND VGND VPWR VPWR sky130_fd_sc_hd__decap_8
XTAP_TAPCELL_ROW_49_871 VGND VPWR sky130_fd_sc_hd__tapvpwrvgnd_1
XTAP_TAPCELL_ROW_49_882 VGND VPWR sky130_fd_sc_hd__tapvpwrvgnd_1
XFILLER_81_665 VGND VGND VPWR VPWR sky130_fd_sc_hd__decap_6
XFILLER_65_194 VPWR VGND VPWR VGND sky130_ef_sc_hd__decap_12
XFILLER_53_356 VPWR VGND VPWR VGND sky130_ef_sc_hd__decap_12
X_5926_ net44 VGND VGND VPWR VPWR _0334_ sky130_fd_sc_hd__inv_2
XFILLER_53_389 VGND VGND VPWR VPWR sky130_fd_sc_hd__decap_3
XTAP_TAPCELL_ROW_101_1527 VGND VPWR sky130_fd_sc_hd__tapvpwrvgnd_1
XFILLER_80_197 VGND VGND VPWR VPWR sky130_fd_sc_hd__fill_2
XFILLER_22_721 VGND VGND VPWR VPWR sky130_fd_sc_hd__fill_2
XFILLER_70_29 VGND VGND VPWR VPWR sky130_fd_sc_hd__decap_8
X_5857_ net147 VGND VGND VPWR VPWR _0265_ sky130_fd_sc_hd__inv_2
X_4808_ _2665_ _2666_ VGND VGND VPWR VPWR _2667_ sky130_fd_sc_hd__and2_1
X_5788_ net149 VGND VGND VPWR VPWR _0196_ sky130_fd_sc_hd__inv_2
X_4739_ _2591_ _2597_ VGND VGND VPWR VPWR _2598_ sky130_fd_sc_hd__nor2_1
XFILLER_5_408 VPWR VGND VPWR VGND sky130_ef_sc_hd__decap_12
X_6409_ clknet_leaf_4_clk _0817_ _0342_ VGND VGND VPWR VPWR reg_file_inst.registry\[1\]\[6\]
+ sky130_fd_sc_hd__dfrtp_1
XFILLER_89_721 VGND VGND VPWR VPWR sky130_fd_sc_hd__decap_4
XFILLER_0_102 VGND VGND VPWR VPWR sky130_fd_sc_hd__decap_8
XFILLER_115_391 VGND VGND VPWR VPWR sky130_fd_sc_hd__fill_1
XTAP_TAPCELL_ROW_112_1667 VGND VPWR sky130_fd_sc_hd__tapvpwrvgnd_1
XFILLER_103_553 VGND VGND VPWR VPWR sky130_fd_sc_hd__decap_6
XFILLER_0_124 VGND VGND VPWR VPWR sky130_fd_sc_hd__fill_1
XFILLER_95_15 VPWR VGND VPWR VGND sky130_ef_sc_hd__decap_12
XFILLER_103_597 VPWR VGND VPWR VGND sky130_ef_sc_hd__decap_12
XFILLER_28_20 VGND VGND VPWR VPWR sky130_fd_sc_hd__decap_8
XFILLER_48_139 VGND VGND VPWR VPWR sky130_fd_sc_hd__fill_1
XFILLER_57_673 VPWR VGND VPWR VGND sky130_ef_sc_hd__decap_12
XFILLER_28_75 VGND VGND VPWR VPWR sky130_fd_sc_hd__decap_8
XTAP_TAPCELL_ROW_67_1102 VGND VPWR sky130_fd_sc_hd__tapvpwrvgnd_1
XFILLER_56_150 VGND VGND VPWR VPWR sky130_fd_sc_hd__decap_6
XFILLER_29_397 VPWR VGND VPWR VGND sky130_ef_sc_hd__decap_12
XFILLER_44_52 VPWR VGND VPWR VGND sky130_ef_sc_hd__decap_12
XTAP_TAPCELL_ROW_27_598 VGND VPWR sky130_fd_sc_hd__tapvpwrvgnd_1
XFILLER_44_85 VGND VGND VPWR VPWR sky130_fd_sc_hd__decap_4
XFILLER_12_253 VPWR VGND VPWR VGND sky130_ef_sc_hd__decap_12
XFILLER_12_231 VPWR VGND VPWR VGND sky130_ef_sc_hd__decap_12
XFILLER_9_725 VGND VGND VPWR VPWR sky130_fd_sc_hd__fill_1
XFILLER_60_40 VPWR VGND VPWR VGND sky130_ef_sc_hd__decap_12
XFILLER_12_275 VPWR VGND VPWR VGND sky130_ef_sc_hd__decap_12
XTAP_TAPCELL_ROW_78_1242 VGND VPWR sky130_fd_sc_hd__tapvpwrvgnd_1
XFILLER_113_317 VPWR VGND VPWR VGND sky130_ef_sc_hd__decap_12
XFILLER_5_57 VGND VGND VPWR VPWR sky130_fd_sc_hd__decap_8
XFILLER_121_361 VPWR VGND VPWR VGND sky130_ef_sc_hd__decap_12
XPHY_EDGE_ROW_105_Left_228 VGND VGND VPWR VPWR sky130_fd_sc_hd__decap_3
X_3070_ JMPOFF\[2\] _0966_ net36 VGND VGND VPWR VPWR _1014_ sky130_fd_sc_hd__a21o_1
XTAP_TAPCELL_ROW_89_1382 VGND VPWR sky130_fd_sc_hd__tapvpwrvgnd_1
XTAP_TAPCELL_ROW_89_1371 VGND VPWR sky130_fd_sc_hd__tapvpwrvgnd_1
XFILLER_63_643 VPWR VGND VPWR VGND sky130_ef_sc_hd__decap_12
XTAP_TAPCELL_ROW_46_841 VGND VPWR sky130_fd_sc_hd__tapvpwrvgnd_1
XFILLER_62_153 VGND VGND VPWR VPWR sky130_fd_sc_hd__decap_6
XPHY_EDGE_ROW_114_Left_237 VGND VGND VPWR VPWR sky130_fd_sc_hd__decap_3
XFILLER_62_197 VPWR VGND VPWR VGND sky130_ef_sc_hd__decap_12
X_5711_ net146 VGND VGND VPWR VPWR _0119_ sky130_fd_sc_hd__inv_2
X_3972_ _1056_ _1887_ _1047_ VGND VGND VPWR VPWR _1888_ sky130_fd_sc_hd__a21o_1
X_5642_ net146 VGND VGND VPWR VPWR _0050_ sky130_fd_sc_hd__inv_2
X_5573_ reg_file_inst.registry\[15\]\[19\] _2854_ _3003_ VGND VGND VPWR VPWR _0494_
+ sky130_fd_sc_hd__mux2_1
X_4524_ _2406_ VGND VGND VPWR VPWR _2407_ sky130_fd_sc_hd__inv_2
XFILLER_116_133 VGND VGND VPWR VPWR sky130_fd_sc_hd__decap_6
XFILLER_116_177 VPWR VGND VPWR VGND sky130_ef_sc_hd__decap_12
X_4455_ net132 _2194_ VGND VGND VPWR VPWR _2340_ sky130_fd_sc_hd__nor2_1
X_3406_ reg_file_inst.registry\[5\]\[19\] _1139_ _1335_ _1336_ _1337_ VGND VGND VPWR
+ VPWR _1342_ sky130_fd_sc_hd__a2111o_1
X_4386_ _2265_ _2273_ _1791_ VGND VGND VPWR VPWR _2274_ sky130_fd_sc_hd__mux2_1
XFILLER_100_501 VGND VGND VPWR VPWR sky130_fd_sc_hd__decap_8
XFILLER_86_713 VPWR VGND VPWR VGND sky130_ef_sc_hd__decap_12
X_3337_ reg_file_inst.registry\[5\]\[21\] _1097_ _1075_ VGND VGND VPWR VPWR _1275_
+ sky130_fd_sc_hd__a21o_1
X_6125_ clknet_leaf_62_clk _0533_ _0058_ VGND VGND VPWR VPWR reg_file_inst.registry\[6\]\[2\]
+ sky130_fd_sc_hd__dfrtp_1
XFILLER_85_223 VGND VGND VPWR VPWR sky130_fd_sc_hd__fill_1
XFILLER_58_448 VGND VGND VPWR VPWR sky130_fd_sc_hd__decap_8
XFILLER_105_69 VPWR VGND VPWR VGND sky130_ef_sc_hd__decap_12
XFILLER_100_556 VPWR VGND VPWR VGND sky130_ef_sc_hd__decap_12
X_3268_ reg_file_inst.registry\[10\]\[24\] _1126_ _1139_ reg_file_inst.registry\[5\]\[24\]
+ VGND VGND VPWR VPWR _1209_ sky130_fd_sc_hd__a22o_1
X_6056_ net146 VGND VGND VPWR VPWR _0464_ sky130_fd_sc_hd__inv_2
XFILLER_100_589 VPWR VGND VPWR VGND sky130_ef_sc_hd__decap_12
X_3199_ reg_file_inst.registry\[5\]\[27\] _1139_ _1142_ reg_file_inst.registry\[1\]\[27\]
+ VGND VGND VPWR VPWR _1143_ sky130_fd_sc_hd__a22o_1
X_5007_ _1345_ _2282_ _2285_ _1346_ _2849_ VGND VGND VPWR VPWR _2850_ sky130_fd_sc_hd__o221a_1
XFILLER_39_673 VPWR VGND VPWR VGND sky130_ef_sc_hd__decap_12
XFILLER_38_194 VGND VGND VPWR VPWR sky130_fd_sc_hd__fill_2
XFILLER_121_57 VPWR VGND VPWR VGND sky130_ef_sc_hd__decap_12
XFILLER_41_304 VGND VGND VPWR VPWR sky130_fd_sc_hd__decap_4
XFILLER_81_39 VPWR VGND VPWR VGND sky130_ef_sc_hd__decap_12
XFILLER_41_337 VGND VGND VPWR VPWR sky130_fd_sc_hd__decap_8
X_5909_ net148 VGND VGND VPWR VPWR _0317_ sky130_fd_sc_hd__inv_2
XTAP_TAPCELL_ROW_62_1043 VGND VPWR sky130_fd_sc_hd__tapvpwrvgnd_1
XTAP_TAPCELL_ROW_24_568 VGND VPWR sky130_fd_sc_hd__tapvpwrvgnd_1
XFILLER_10_713 VGND VGND VPWR VPWR sky130_fd_sc_hd__decap_8
XFILLER_108_601 VPWR VGND VPWR VGND sky130_ef_sc_hd__decap_12
XFILLER_108_645 VPWR VGND VPWR VGND sky130_ef_sc_hd__decap_12
XFILLER_107_111 VGND VGND VPWR VPWR sky130_fd_sc_hd__fill_1
XFILLER_30_32 VGND VGND VPWR VPWR sky130_fd_sc_hd__fill_2
XFILLER_122_125 VPWR VGND VPWR VGND sky130_ef_sc_hd__decap_12
XFILLER_89_540 VGND VGND VPWR VPWR sky130_fd_sc_hd__decap_8
XFILLER_122_169 VPWR VGND VPWR VGND sky130_ef_sc_hd__decap_12
XFILLER_110_309 VPWR VGND VPWR VGND sky130_ef_sc_hd__decap_12
XFILLER_103_361 VGND VGND VPWR VPWR sky130_fd_sc_hd__decap_8
XFILLER_77_702 VGND VGND VPWR VPWR sky130_fd_sc_hd__decap_4
XTAP_TAPCELL_ROW_73_1172 VGND VPWR sky130_fd_sc_hd__tapvpwrvgnd_1
XFILLER_76_267 VGND VGND VPWR VPWR sky130_fd_sc_hd__fill_1
XFILLER_17_301 VGND VGND VPWR VPWR sky130_fd_sc_hd__decap_8
XFILLER_36_109 VGND VGND VPWR VPWR sky130_fd_sc_hd__decap_8
XFILLER_17_323 VPWR VGND VPWR VGND sky130_ef_sc_hd__decap_12
XFILLER_60_613 VGND VGND VPWR VPWR sky130_fd_sc_hd__decap_6
XFILLER_55_95 VPWR VGND VPWR VGND sky130_ef_sc_hd__decap_12
XTAP_TAPCELL_ROW_43_800 VGND VPWR sky130_fd_sc_hd__tapvpwrvgnd_1
XFILLER_60_635 VGND VGND VPWR VPWR sky130_fd_sc_hd__decap_8
XFILLER_71_83 VPWR VGND VPWR VGND sky130_ef_sc_hd__decap_12
XFILLER_9_544 VPWR VGND VPWR VGND sky130_ef_sc_hd__decap_12
XFILLER_13_573 VGND VGND VPWR VPWR sky130_fd_sc_hd__decap_6
XFILLER_114_637 VGND VGND VPWR VPWR sky130_fd_sc_hd__decap_6
XFILLER_113_125 VPWR VGND VPWR VGND sky130_ef_sc_hd__decap_12
X_4240_ _1708_ _1735_ VGND VGND VPWR VPWR _2128_ sky130_fd_sc_hd__nor2_2
XFILLER_113_169 VPWR VGND VPWR VGND sky130_ef_sc_hd__decap_12
X_4171_ _2078_ net112 net130 VGND VGND VPWR VPWR _0941_ sky130_fd_sc_hd__mux2_1
X_3122_ _0974_ _1065_ VGND VGND VPWR VPWR _1066_ sky130_fd_sc_hd__nand2_1
XFILLER_82_204 VGND VGND VPWR VPWR sky130_fd_sc_hd__decap_6
X_3053_ _0995_ _0996_ VGND VGND VPWR VPWR _0997_ sky130_fd_sc_hd__nand2b_1
XFILLER_36_665 VGND VGND VPWR VPWR sky130_fd_sc_hd__decap_3
XFILLER_23_315 VGND VGND VPWR VPWR sky130_fd_sc_hd__fill_2
XFILLER_23_337 VGND VGND VPWR VPWR sky130_fd_sc_hd__decap_4
XFILLER_51_679 VGND VGND VPWR VPWR sky130_fd_sc_hd__fill_1
XFILLER_51_668 VGND VGND VPWR VPWR sky130_fd_sc_hd__decap_4
X_3955_ _1420_ _1641_ _1870_ VGND VGND VPWR VPWR _1871_ sky130_fd_sc_hd__and3_1
XTAP_TAPCELL_ROW_21_527 VGND VPWR sky130_fd_sc_hd__tapvpwrvgnd_1
XFILLER_50_167 VGND VGND VPWR VPWR sky130_fd_sc_hd__decap_6
X_5625_ net146 VGND VGND VPWR VPWR _0033_ sky130_fd_sc_hd__inv_2
X_3886_ reg_file_inst.registry\[11\]\[1\] _1085_ _1088_ VGND VGND VPWR VPWR _1804_
+ sky130_fd_sc_hd__and3_1
X_5556_ _2311_ reg_file_inst.registry\[9\]\[7\] _3002_ VGND VGND VPWR VPWR _0510_
+ sky130_fd_sc_hd__mux2_1
XFILLER_3_709 VPWR VGND VPWR VGND sky130_ef_sc_hd__decap_12
XFILLER_105_615 VGND VGND VPWR VPWR sky130_fd_sc_hd__fill_1
X_5487_ JMPOFF\[18\] _2863_ _3000_ VGND VGND VPWR VPWR _0577_ sky130_fd_sc_hd__mux2_1
X_4507_ _2389_ VGND VGND VPWR VPWR _2390_ sky130_fd_sc_hd__inv_2
XFILLER_117_497 VGND VGND VPWR VPWR sky130_fd_sc_hd__decap_6
X_4438_ _2318_ _2322_ net136 VGND VGND VPWR VPWR _2323_ sky130_fd_sc_hd__mux2_1
XFILLER_98_392 VGND VGND VPWR VPWR sky130_fd_sc_hd__decap_6
X_4369_ _1826_ _2190_ VGND VGND VPWR VPWR _2257_ sky130_fd_sc_hd__nand2_1
XFILLER_74_705 VGND VGND VPWR VPWR sky130_fd_sc_hd__fill_1
X_6108_ clknet_leaf_1_clk _0516_ _0041_ VGND VGND VPWR VPWR reg_file_inst.registry\[9\]\[13\]
+ sky130_fd_sc_hd__dfrtp_1
XFILLER_86_587 VGND VGND VPWR VPWR sky130_fd_sc_hd__fill_1
X_6039_ net149 VGND VGND VPWR VPWR _0447_ sky130_fd_sc_hd__inv_2
XTAP_TAPCELL_ROW_29_627 VGND VPWR sky130_fd_sc_hd__tapvpwrvgnd_1
XFILLER_73_248 VPWR VGND VPWR VGND sky130_ef_sc_hd__decap_12
XTAP_TAPCELL_ROW_1_274 VGND VPWR sky130_fd_sc_hd__tapvpwrvgnd_1
XFILLER_25_21 VPWR VGND VPWR VGND sky130_ef_sc_hd__decap_12
XTAP_TAPCELL_ROW_107_1599 VGND VPWR sky130_fd_sc_hd__tapvpwrvgnd_1
XFILLER_81_281 VGND VGND VPWR VPWR sky130_fd_sc_hd__fill_2
XFILLER_25_54 VGND VGND VPWR VPWR sky130_fd_sc_hd__fill_2
XFILLER_26_197 VGND VGND VPWR VPWR sky130_fd_sc_hd__decap_4
XFILLER_42_635 VGND VGND VPWR VPWR sky130_fd_sc_hd__decap_6
XTAP_TAPCELL_ROW_120_1766 VGND VPWR sky130_fd_sc_hd__tapvpwrvgnd_1
XFILLER_25_98 VGND VGND VPWR VPWR sky130_fd_sc_hd__decap_3
XFILLER_10_587 VGND VGND VPWR VPWR sky130_fd_sc_hd__fill_1
XFILLER_6_503 VPWR VGND VPWR VGND sky130_ef_sc_hd__decap_12
XFILLER_41_53 VGND VGND VPWR VPWR sky130_fd_sc_hd__decap_3
XTAP_TAPCELL_ROW_75_1201 VGND VPWR sky130_fd_sc_hd__tapvpwrvgnd_1
XFILLER_6_569 VPWR VGND VPWR VGND sky130_ef_sc_hd__decap_12
XFILLER_108_475 VGND VGND VPWR VPWR sky130_fd_sc_hd__fill_1
XFILLER_111_629 VPWR VGND VPWR VGND sky130_ef_sc_hd__decap_12
XTAP_TAPCELL_ROW_9_374 VGND VPWR sky130_fd_sc_hd__tapvpwrvgnd_1
XFILLER_110_139 VGND VGND VPWR VPWR sky130_fd_sc_hd__fill_1
XFILLER_104_681 VPWR VGND VPWR VGND sky130_ef_sc_hd__decap_12
XFILLER_49_223 VGND VGND VPWR VPWR sky130_fd_sc_hd__fill_1
XFILLER_64_226 VGND VGND VPWR VPWR sky130_fd_sc_hd__decap_8
XFILLER_18_621 VGND VGND VPWR VPWR sky130_fd_sc_hd__decap_3
XTAP_TAPCELL_ROW_86_1341 VGND VPWR sky130_fd_sc_hd__tapvpwrvgnd_1
XFILLER_33_613 VGND VGND VPWR VPWR sky130_fd_sc_hd__decap_3
XFILLER_60_421 VGND VGND VPWR VPWR sky130_fd_sc_hd__decap_3
XFILLER_60_410 VGND VGND VPWR VPWR sky130_fd_sc_hd__decap_8
XFILLER_32_101 VGND VGND VPWR VPWR sky130_fd_sc_hd__fill_1
XANTENNA_19 net85 VGND VGND VPWR VPWR sky130_fd_sc_hd__diode_2
X_3740_ reg_file_inst.registry\[4\]\[7\] _1134_ _1142_ reg_file_inst.registry\[1\]\[7\]
+ _1660_ VGND VGND VPWR VPWR _1664_ sky130_fd_sc_hd__a221o_1
XFILLER_20_329 VGND VGND VPWR VPWR sky130_fd_sc_hd__decap_8
X_3671_ reg_file_inst.registry\[2\]\[8\] _1080_ _1082_ VGND VGND VPWR VPWR _1596_
+ sky130_fd_sc_hd__and3_1
X_6390_ clknet_leaf_15_clk _0798_ _0323_ VGND VGND VPWR VPWR reg_file_inst.registry\[14\]\[15\]
+ sky130_fd_sc_hd__dfrtp_1
X_5410_ reg_file_inst.registry\[4\]\[8\] _2986_ _2997_ VGND VGND VPWR VPWR _0651_
+ sky130_fd_sc_hd__mux2_1
XFILLER_114_401 VPWR VGND VPWR VGND sky130_ef_sc_hd__decap_12
X_5341_ _2854_ reg_file_inst.registry\[3\]\[19\] _2995_ VGND VGND VPWR VPWR _0718_
+ sky130_fd_sc_hd__mux2_1
XTAP_TAPCELL_ROW_97_1481 VGND VPWR sky130_fd_sc_hd__tapvpwrvgnd_1
Xoutput115 net115 VGND VGND VPWR VPWR IC[21] sky130_fd_sc_hd__buf_1
Xoutput104 net104 VGND VGND VPWR VPWR IC[11] sky130_fd_sc_hd__buf_1
XFILLER_114_445 VPWR VGND VPWR VGND sky130_ef_sc_hd__decap_12
Xoutput126 net126 VGND VGND VPWR VPWR IC[6] sky130_fd_sc_hd__buf_1
X_5272_ reg_file_inst.registry\[14\]\[1\] _2528_ _2992_ VGND VGND VPWR VPWR _0784_
+ sky130_fd_sc_hd__mux2_1
XFILLER_114_489 VPWR VGND VPWR VGND sky130_ef_sc_hd__decap_12
XFILLER_99_189 VGND VGND VPWR VPWR sky130_fd_sc_hd__decap_8
XFILLER_87_329 VGND VGND VPWR VPWR sky130_fd_sc_hd__decap_6
XFILLER_68_510 VGND VGND VPWR VPWR sky130_fd_sc_hd__decap_3
X_4223_ net30 _1873_ VGND VGND VPWR VPWR _2112_ sky130_fd_sc_hd__nand2_1
X_4154_ _2036_ _2046_ VGND VGND VPWR VPWR _2067_ sky130_fd_sc_hd__nand2_1
XFILLER_56_705 VGND VGND VPWR VPWR sky130_fd_sc_hd__fill_1
XFILLER_68_598 VGND VGND VPWR VPWR sky130_fd_sc_hd__decap_4
X_4085_ _0951_ _2000_ VGND VGND VPWR VPWR _2001_ sky130_fd_sc_hd__nor2_1
XFILLER_28_429 VGND VGND VPWR VPWR sky130_fd_sc_hd__fill_2
X_3105_ JMPOFF\[13\] _0967_ _1048_ VGND VGND VPWR VPWR _1049_ sky130_fd_sc_hd__a21o_1
X_3036_ _0976_ _0977_ _0979_ VGND VGND VPWR VPWR _0980_ sky130_fd_sc_hd__and3_1
XFILLER_102_15 VPWR VGND VPWR VGND sky130_ef_sc_hd__decap_12
XFILLER_36_462 VPWR VGND VPWR VGND sky130_ef_sc_hd__decap_12
XTAP_TAPCELL_ROW_54_939 VGND VPWR sky130_fd_sc_hd__tapvpwrvgnd_1
X_4987_ _1790_ _2772_ VGND VGND VPWR VPWR _2832_ sky130_fd_sc_hd__nor2_1
XTAP_TAPCELL_ROW_34_685 VGND VPWR sky130_fd_sc_hd__tapvpwrvgnd_1
X_3938_ _1816_ _1826_ VGND VGND VPWR VPWR _1854_ sky130_fd_sc_hd__xnor2_1
XFILLER_109_217 VGND VGND VPWR VPWR sky130_fd_sc_hd__decap_6
X_3869_ reg_file_inst.registry\[9\]\[2\] _1089_ _1091_ reg_file_inst.registry\[3\]\[2\]
+ VGND VGND VPWR VPWR _1788_ sky130_fd_sc_hd__a22o_1
X_5608_ net44 VGND VGND VPWR VPWR _0016_ sky130_fd_sc_hd__inv_2
XFILLER_117_261 VPWR VGND VPWR VGND sky130_ef_sc_hd__decap_12
XFILLER_105_401 VGND VGND VPWR VPWR sky130_fd_sc_hd__fill_2
X_5539_ _2787_ reg_file_inst.registry\[9\]\[24\] _3002_ VGND VGND VPWR VPWR _0527_
+ sky130_fd_sc_hd__mux2_1
XFILLER_3_517 VPWR VGND VPWR VGND sky130_ef_sc_hd__decap_12
XFILLER_78_307 VGND VGND VPWR VPWR sky130_fd_sc_hd__fill_1
XTAP_TAPCELL_ROW_6_344 VGND VPWR sky130_fd_sc_hd__tapvpwrvgnd_1
XTAP_TAPCELL_ROW_6_333 VGND VPWR sky130_fd_sc_hd__tapvpwrvgnd_1
XTAP_TAPCELL_ROW_70_1142 VGND VPWR sky130_fd_sc_hd__tapvpwrvgnd_1
XFILLER_59_532 VPWR VGND VPWR VGND sky130_ef_sc_hd__decap_12
XTAP_TAPCELL_ROW_109_1628 VGND VPWR sky130_fd_sc_hd__tapvpwrvgnd_1
XFILLER_101_673 VPWR VGND VPWR VGND sky130_ef_sc_hd__decap_12
XFILLER_86_373 VGND VGND VPWR VPWR sky130_fd_sc_hd__decap_8
XTAP_TAPCELL_ROW_122_1806 VGND VPWR sky130_fd_sc_hd__tapvpwrvgnd_1
XFILLER_36_53 VPWR VGND VPWR VGND sky130_ef_sc_hd__decap_12
XFILLER_15_613 VGND VGND VPWR VPWR sky130_fd_sc_hd__decap_3
XFILLER_36_97 VPWR VGND VPWR VGND sky130_ef_sc_hd__decap_12
XFILLER_42_410 VGND VGND VPWR VPWR sky130_fd_sc_hd__decap_8
XFILLER_42_421 VPWR VGND VPWR VGND sky130_ef_sc_hd__decap_12
XFILLER_15_657 VGND VGND VPWR VPWR sky130_fd_sc_hd__fill_1
XFILLER_52_41 VGND VGND VPWR VPWR sky130_fd_sc_hd__decap_4
XFILLER_14_167 VPWR VGND VPWR VGND sky130_ef_sc_hd__decap_12
XTAP_TAPCELL_ROW_81_1282 VGND VPWR sky130_fd_sc_hd__tapvpwrvgnd_1
XTAP_TAPCELL_ROW_81_1271 VGND VPWR sky130_fd_sc_hd__tapvpwrvgnd_1
XFILLER_52_85 VPWR VGND VPWR VGND sky130_ef_sc_hd__decap_12
XFILLER_10_362 VGND VGND VPWR VPWR sky130_fd_sc_hd__fill_2
Xinput28 DataMemoryRead[9] VGND VGND VPWR VPWR net28 sky130_fd_sc_hd__buf_1
Xinput17 DataMemoryRead[24] VGND VGND VPWR VPWR net17 sky130_fd_sc_hd__buf_1
Xinput39 instr[5] VGND VGND VPWR VPWR net39 sky130_fd_sc_hd__buf_4
XFILLER_6_344 VGND VGND VPWR VPWR sky130_fd_sc_hd__decap_8
XFILLER_6_377 VGND VGND VPWR VPWR sky130_fd_sc_hd__decap_3
XFILLER_6_399 VPWR VGND VPWR VGND sky130_ef_sc_hd__decap_12
XFILLER_77_71 VPWR VGND VPWR VGND sky130_ef_sc_hd__decap_12
XFILLER_37_204 VGND VGND VPWR VPWR sky130_fd_sc_hd__fill_1
XFILLER_92_321 VGND VGND VPWR VPWR sky130_fd_sc_hd__fill_1
XFILLER_65_546 VPWR VGND VPWR VGND sky130_ef_sc_hd__decap_12
XFILLER_80_516 VGND VGND VPWR VPWR sky130_fd_sc_hd__fill_2
XFILLER_93_92 VPWR VGND VPWR VGND sky130_ef_sc_hd__decap_12
X_5890_ net147 VGND VGND VPWR VPWR _0298_ sky130_fd_sc_hd__inv_2
X_4910_ _2512_ _2764_ net137 VGND VGND VPWR VPWR _2765_ sky130_fd_sc_hd__mux2_1
X_4841_ _1108_ _1151_ _2284_ VGND VGND VPWR VPWR _2700_ sky130_fd_sc_hd__and3_1
X_4772_ _1446_ _2629_ VGND VGND VPWR VPWR _2631_ sky130_fd_sc_hd__xnor2_1
XFILLER_20_148 VGND VGND VPWR VPWR sky130_fd_sc_hd__decap_3
X_3723_ reg_file_inst.registry\[9\]\[7\] _1089_ _1095_ JMPOFF\[7\] VGND VGND VPWR
+ VPWR _1647_ sky130_fd_sc_hd__a22o_1
XTAP_TAPCELL_ROW_31_655 VGND VPWR sky130_fd_sc_hd__tapvpwrvgnd_1
X_6511_ clknet_leaf_57_clk _0919_ _0444_ VGND VGND VPWR VPWR reg_file_inst.registry\[11\]\[4\]
+ sky130_fd_sc_hd__dfrtp_1
XFILLER_119_559 VGND VGND VPWR VPWR sky130_fd_sc_hd__fill_1
X_3654_ _1574_ _1577_ _1578_ _1579_ VGND VGND VPWR VPWR _1580_ sky130_fd_sc_hd__nor4_1
X_6442_ clknet_leaf_60_clk _0850_ _0375_ VGND VGND VPWR VPWR reg_file_inst.registry\[0\]\[3\]
+ sky130_fd_sc_hd__dfrtp_2
XFILLER_106_209 VPWR VGND VPWR VGND sky130_ef_sc_hd__decap_12
XFILLER_115_721 VGND VGND VPWR VPWR sky130_fd_sc_hd__decap_4
X_6373_ clknet_leaf_23_clk _0781_ _0306_ VGND VGND VPWR VPWR reg_file_inst.registry\[2\]\[26\]
+ sky130_fd_sc_hd__dfrtp_1
X_3585_ _1506_ _1511_ _1512_ _1513_ VGND VGND VPWR VPWR _1514_ sky130_fd_sc_hd__or4_1
XFILLER_114_253 VPWR VGND VPWR VGND sky130_ef_sc_hd__decap_12
X_5324_ _2311_ reg_file_inst.registry\[8\]\[7\] _2994_ VGND VGND VPWR VPWR _0734_
+ sky130_fd_sc_hd__mux2_1
X_5255_ reg_file_inst.registry\[14\]\[18\] _2863_ _2992_ VGND VGND VPWR VPWR _0801_
+ sky130_fd_sc_hd__mux2_1
X_4206_ _2101_ net127 net130 VGND VGND VPWR VPWR _0929_ sky130_fd_sc_hd__mux2_1
X_5186_ _2854_ reg_file_inst.registry\[0\]\[19\] _2988_ VGND VGND VPWR VPWR _0866_
+ sky130_fd_sc_hd__mux2_1
XFILLER_56_513 VGND VGND VPWR VPWR sky130_fd_sc_hd__decap_6
XTAP_TAPCELL_ROW_3_303 VGND VPWR sky130_fd_sc_hd__tapvpwrvgnd_1
XFILLER_29_716 VGND VGND VPWR VPWR sky130_fd_sc_hd__decap_8
XFILLER_96_693 VGND VGND VPWR VPWR sky130_fd_sc_hd__decap_6
XFILLER_83_310 VGND VGND VPWR VPWR sky130_fd_sc_hd__decap_3
X_4137_ _0950_ _1880_ _1882_ VGND VGND VPWR VPWR _2053_ sky130_fd_sc_hd__o21bai_1
XFILLER_68_384 VPWR VGND VPWR VGND sky130_ef_sc_hd__decap_12
XFILLER_113_69 VPWR VGND VPWR VGND sky130_ef_sc_hd__decap_12
XFILLER_83_376 VPWR VGND VPWR VGND sky130_ef_sc_hd__decap_12
X_4068_ _1878_ _1983_ VGND VGND VPWR VPWR _1984_ sky130_fd_sc_hd__and2_1
XTAP_TAPCELL_ROW_39_755 VGND VPWR sky130_fd_sc_hd__tapvpwrvgnd_1
XFILLER_43_207 VGND VGND VPWR VPWR sky130_fd_sc_hd__decap_4
XFILLER_71_538 VGND VGND VPWR VPWR sky130_fd_sc_hd__decap_8
XFILLER_24_410 VGND VGND VPWR VPWR sky130_fd_sc_hd__fill_2
XFILLER_24_421 VGND VGND VPWR VPWR sky130_fd_sc_hd__decap_6
X_3019_ _0961_ _0962_ _0963_ VGND VGND VPWR VPWR net130 sky130_fd_sc_hd__and3_4
XTAP_TAPCELL_ROW_104_1558 VGND VPWR sky130_fd_sc_hd__tapvpwrvgnd_1
XFILLER_24_443 VGND VGND VPWR VPWR sky130_fd_sc_hd__decap_8
XTAP_TAPCELL_ROW_104_1569 VGND VPWR sky130_fd_sc_hd__tapvpwrvgnd_1
XFILLER_11_148 VPWR VGND VPWR VGND sky130_ef_sc_hd__decap_12
XFILLER_22_11 VGND VGND VPWR VPWR sky130_fd_sc_hd__decap_3
XTAP_TAPCELL_ROW_59_1004 VGND VPWR sky130_fd_sc_hd__tapvpwrvgnd_1
XFILLER_98_15 VPWR VGND VPWR VGND sky130_ef_sc_hd__decap_12
XFILLER_118_581 VGND VGND VPWR VPWR sky130_fd_sc_hd__decap_6
XFILLER_3_314 VGND VGND VPWR VPWR sky130_fd_sc_hd__fill_1
XTAP_TAPCELL_ROW_115_1698 VGND VPWR sky130_fd_sc_hd__tapvpwrvgnd_1
XFILLER_120_245 VGND VGND VPWR VPWR sky130_fd_sc_hd__decap_6
XFILLER_120_289 VPWR VGND VPWR VGND sky130_ef_sc_hd__decap_12
XFILLER_87_671 VGND VGND VPWR VPWR sky130_fd_sc_hd__fill_1
XFILLER_101_492 VPWR VGND VPWR VGND sky130_ef_sc_hd__decap_12
XFILLER_74_332 VGND VGND VPWR VPWR sky130_fd_sc_hd__decap_8
XFILLER_74_365 VGND VGND VPWR VPWR sky130_fd_sc_hd__decap_4
XFILLER_62_516 VGND VGND VPWR VPWR sky130_fd_sc_hd__decap_3
XFILLER_19_259 VGND VGND VPWR VPWR sky130_fd_sc_hd__decap_4
XFILLER_47_557 VGND VGND VPWR VPWR sky130_fd_sc_hd__decap_3
XTAP_TAPCELL_ROW_83_1300 VGND VPWR sky130_fd_sc_hd__tapvpwrvgnd_1
XFILLER_34_218 VGND VGND VPWR VPWR sky130_fd_sc_hd__fill_1
XFILLER_27_281 VGND VGND VPWR VPWR sky130_fd_sc_hd__decap_8
XFILLER_42_251 VGND VGND VPWR VPWR sky130_fd_sc_hd__fill_1
XFILLER_42_262 VPWR VGND VPWR VGND sky130_ef_sc_hd__decap_12
XFILLER_11_660 VGND VGND VPWR VPWR sky130_fd_sc_hd__decap_3
XFILLER_11_693 VGND VGND VPWR VPWR sky130_fd_sc_hd__decap_3
XFILLER_10_170 VGND VGND VPWR VPWR sky130_fd_sc_hd__decap_8
XFILLER_7_653 VPWR VGND VPWR VGND sky130_ef_sc_hd__decap_12
XFILLER_6_152 VGND VGND VPWR VPWR sky130_fd_sc_hd__fill_1
XTAP_TAPCELL_ROW_94_1440 VGND VPWR sky130_fd_sc_hd__tapvpwrvgnd_1
XFILLER_7_697 VPWR VGND VPWR VGND sky130_ef_sc_hd__decap_12
X_3370_ reg_file_inst.registry\[0\]\[20\] _1076_ _1299_ _1305_ VGND VGND VPWR VPWR
+ _1307_ sky130_fd_sc_hd__o22ai_4
XFILLER_112_713 VPWR VGND VPWR VGND sky130_ef_sc_hd__decap_12
XFILLER_111_223 VGND VGND VPWR VPWR sky130_fd_sc_hd__fill_1
X_5040_ _1382_ _1392_ _2288_ VGND VGND VPWR VPWR _2877_ sky130_fd_sc_hd__o21ai_1
XFILLER_97_479 VGND VGND VPWR VPWR sky130_fd_sc_hd__fill_1
XFILLER_84_107 VGND VGND VPWR VPWR sky130_fd_sc_hd__fill_2
XFILLER_93_641 VPWR VGND VPWR VGND sky130_ef_sc_hd__decap_12
XFILLER_84_129 VGND VGND VPWR VPWR sky130_fd_sc_hd__decap_8
XFILLER_78_693 VGND VGND VPWR VPWR sky130_fd_sc_hd__decap_6
XFILLER_93_685 VPWR VGND VPWR VGND sky130_ef_sc_hd__decap_12
X_5942_ net147 VGND VGND VPWR VPWR _0350_ sky130_fd_sc_hd__inv_2
XTAP_TAPCELL_ROW_36_714 VGND VPWR sky130_fd_sc_hd__tapvpwrvgnd_1
X_5873_ net149 VGND VGND VPWR VPWR _0281_ sky130_fd_sc_hd__inv_2
XTAP_TAPCELL_ROW_16_460 VGND VPWR sky130_fd_sc_hd__tapvpwrvgnd_1
X_4824_ _2568_ _2679_ _2681_ VGND VGND VPWR VPWR _2683_ sky130_fd_sc_hd__or3_1
X_4755_ _1652_ _2127_ _2133_ VGND VGND VPWR VPWR _2614_ sky130_fd_sc_hd__a21o_1
X_3706_ _1626_ _1627_ _1629_ _1421_ VGND VGND VPWR VPWR _1630_ sky130_fd_sc_hd__a31oi_4
XFILLER_107_529 VPWR VGND VPWR VGND sky130_ef_sc_hd__decap_12
X_4686_ _2528_ reg_file_inst.registry\[11\]\[9\] _2118_ VGND VGND VPWR VPWR _0908_
+ sky130_fd_sc_hd__mux2_1
X_6425_ clknet_leaf_36_clk _0833_ _0358_ VGND VGND VPWR VPWR reg_file_inst.registry\[1\]\[22\]
+ sky130_fd_sc_hd__dfrtp_1
X_3637_ reg_file_inst.registry\[11\]\[10\] _1141_ _1559_ _1562_ _1563_ VGND VGND VPWR
+ VPWR _1564_ sky130_fd_sc_hd__a2111o_1
X_6356_ clknet_leaf_26_clk _0764_ _0289_ VGND VGND VPWR VPWR reg_file_inst.registry\[2\]\[9\]
+ sky130_fd_sc_hd__dfrtp_1
X_3568_ MEMOFF\[14\] _1079_ _1089_ reg_file_inst.registry\[9\]\[14\] VGND VGND VPWR
+ VPWR _1497_ sky130_fd_sc_hd__a22o_1
XFILLER_115_573 VPWR VGND VPWR VGND sky130_ef_sc_hd__decap_12
X_5307_ _2787_ reg_file_inst.registry\[8\]\[24\] _2994_ VGND VGND VPWR VPWR _0751_
+ sky130_fd_sc_hd__mux2_1
X_6287_ clknet_leaf_31_clk _0695_ _0220_ VGND VGND VPWR VPWR MEMOFF\[24\] sky130_fd_sc_hd__dfrtp_1
X_3499_ reg_file_inst.registry\[15\]\[12\] _1093_ _1098_ reg_file_inst.registry\[10\]\[12\]
+ VGND VGND VPWR VPWR _1431_ sky130_fd_sc_hd__a22o_1
XFILLER_69_671 VGND VGND VPWR VPWR sky130_fd_sc_hd__fill_1
X_5238_ _2419_ reg_file_inst.registry\[1\]\[5\] _2990_ VGND VGND VPWR VPWR _0816_
+ sky130_fd_sc_hd__mux2_1
XFILLER_29_502 VGND VGND VPWR VPWR sky130_fd_sc_hd__fill_2
XFILLER_56_321 VGND VGND VPWR VPWR sky130_fd_sc_hd__fill_1
XFILLER_29_535 VPWR VGND VPWR VGND sky130_ef_sc_hd__decap_12
X_5169_ reg_file_inst.registry\[7\]\[6\] _2375_ _2553_ VGND VGND VPWR VPWR _0881_
+ sky130_fd_sc_hd__mux2_1
XFILLER_56_343 VPWR VGND VPWR VGND sky130_ef_sc_hd__decap_12
XFILLER_56_398 VPWR VGND VPWR VGND sky130_ef_sc_hd__decap_12
XFILLER_16_207 VGND VGND VPWR VPWR sky130_fd_sc_hd__decap_6
XFILLER_16_229 VPWR VGND VPWR VGND sky130_ef_sc_hd__decap_12
XFILLER_17_44 VPWR VGND VPWR VGND sky130_ef_sc_hd__decap_12
XFILLER_44_538 VGND VGND VPWR VPWR sky130_fd_sc_hd__fill_1
XTAP_TAPCELL_ROW_65_1074 VGND VPWR sky130_fd_sc_hd__tapvpwrvgnd_1
XFILLER_24_251 VGND VGND VPWR VPWR sky130_fd_sc_hd__fill_1
XFILLER_33_32 VGND VGND VPWR VPWR sky130_fd_sc_hd__fill_1
XFILLER_40_722 VGND VGND VPWR VPWR sky130_fd_sc_hd__fill_1
XFILLER_8_417 VGND VGND VPWR VPWR sky130_fd_sc_hd__decap_3
XFILLER_33_54 VGND VGND VPWR VPWR sky130_fd_sc_hd__fill_2
XTAP_TAPCELL_ROW_117_1727 VGND VPWR sky130_fd_sc_hd__tapvpwrvgnd_1
XFILLER_4_601 VPWR VGND VPWR VGND sky130_ef_sc_hd__decap_12
XFILLER_4_645 VPWR VGND VPWR VGND sky130_ef_sc_hd__decap_12
XPHY_EDGE_ROW_18_Left_141 VGND VGND VPWR VPWR sky130_fd_sc_hd__decap_3
XFILLER_3_177 VGND VGND VPWR VPWR sky130_fd_sc_hd__fill_1
XFILLER_3_166 VGND VGND VPWR VPWR sky130_fd_sc_hd__fill_2
XFILLER_66_107 VPWR VGND VPWR VGND sky130_ef_sc_hd__decap_12
XFILLER_75_641 VPWR VGND VPWR VGND sky130_ef_sc_hd__decap_12
XFILLER_75_685 VPWR VGND VPWR VGND sky130_ef_sc_hd__decap_12
XFILLER_74_195 VGND VGND VPWR VPWR sky130_fd_sc_hd__fill_1
XFILLER_74_83 VGND VGND VPWR VPWR sky130_fd_sc_hd__fill_1
XPHY_EDGE_ROW_27_Left_150 VGND VGND VPWR VPWR sky130_fd_sc_hd__decap_3
XFILLER_90_699 VGND VGND VPWR VPWR sky130_fd_sc_hd__fill_1
XFILLER_50_508 VGND VGND VPWR VPWR sky130_fd_sc_hd__fill_1
XFILLER_43_593 VPWR VGND VPWR VGND sky130_ef_sc_hd__decap_12
XTAP_TAPCELL_ROW_13_430 VGND VPWR sky130_fd_sc_hd__tapvpwrvgnd_1
XTAP_TAPCELL_ROW_41_772 VGND VPWR sky130_fd_sc_hd__tapvpwrvgnd_1
Xclkbuf_leaf_10_clk clknet_3_0__leaf_clk VGND VGND VPWR VPWR clknet_leaf_10_clk sky130_fd_sc_hd__clkbuf_8
X_4540_ _1721_ _2203_ _2267_ _1840_ VGND VGND VPWR VPWR _2421_ sky130_fd_sc_hd__a22o_1
X_4471_ _2355_ VGND VGND VPWR VPWR _2356_ sky130_fd_sc_hd__inv_2
Xmax_cap147 net44 VGND VGND VPWR VPWR net147 sky130_fd_sc_hd__clkbuf_16
X_3422_ _1350_ _1356_ reg_file_inst.registry\[0\]\[18\] net138 VGND VGND VPWR VPWR
+ _1357_ sky130_fd_sc_hd__o2bb2a_1
X_6210_ clknet_leaf_59_clk _0618_ _0143_ VGND VGND VPWR VPWR reg_file_inst.registry\[10\]\[3\]
+ sky130_fd_sc_hd__dfrtp_1
Xmax_cap136 _1791_ VGND VGND VPWR VPWR net136 sky130_fd_sc_hd__buf_8
X_6141_ clknet_leaf_14_clk _0549_ _0074_ VGND VGND VPWR VPWR reg_file_inst.registry\[6\]\[18\]
+ sky130_fd_sc_hd__dfrtp_1
X_3353_ reg_file_inst.registry\[2\]\[21\] _1137_ _1283_ _1285_ _1287_ VGND VGND VPWR
+ VPWR _1291_ sky130_fd_sc_hd__a2111o_1
XFILLER_112_587 VGND VGND VPWR VPWR sky130_fd_sc_hd__fill_1
X_3284_ reg_file_inst.registry\[7\]\[23\] _1086_ _1094_ reg_file_inst.registry\[6\]\[23\]
+ VGND VGND VPWR VPWR _1224_ sky130_fd_sc_hd__a22o_1
X_6072_ clknet_leaf_27_clk _0480_ _0005_ VGND VGND VPWR VPWR reg_file_inst.registry\[15\]\[5\]
+ sky130_fd_sc_hd__dfrtp_1
XFILLER_85_427 VGND VGND VPWR VPWR sky130_fd_sc_hd__fill_1
X_5023_ net10 net101 net54 _2308_ VGND VGND VPWR VPWR _2863_ sky130_fd_sc_hd__a22o_4
XFILLER_38_321 VPWR VGND VPWR VGND sky130_ef_sc_hd__decap_12
XFILLER_38_365 VGND VGND VPWR VPWR sky130_fd_sc_hd__fill_1
XTAP_TAPCELL_ROW_49_872 VGND VPWR sky130_fd_sc_hd__tapvpwrvgnd_1
XFILLER_53_346 VGND VGND VPWR VPWR sky130_fd_sc_hd__decap_3
XFILLER_53_335 VGND VGND VPWR VPWR sky130_fd_sc_hd__fill_1
XFILLER_110_15 VPWR VGND VPWR VGND sky130_ef_sc_hd__decap_12
X_5925_ net149 VGND VGND VPWR VPWR _0333_ sky130_fd_sc_hd__inv_2
XFILLER_53_368 VGND VGND VPWR VPWR sky130_fd_sc_hd__decap_6
XFILLER_0_91 VGND VGND VPWR VPWR sky130_fd_sc_hd__decap_6
XFILLER_34_560 VGND VGND VPWR VPWR sky130_fd_sc_hd__fill_2
XTAP_TAPCELL_ROW_101_1528 VGND VPWR sky130_fd_sc_hd__tapvpwrvgnd_1
X_5856_ net147 VGND VGND VPWR VPWR _0264_ sky130_fd_sc_hd__inv_2
X_4807_ _1417_ _2664_ VGND VGND VPWR VPWR _2666_ sky130_fd_sc_hd__nand2_1
XPHY_EDGE_ROW_3_Right_3 VGND VGND VPWR VPWR sky130_fd_sc_hd__decap_3
X_5787_ net44 VGND VGND VPWR VPWR _0195_ sky130_fd_sc_hd__inv_2
X_4738_ _1320_ _2590_ VGND VGND VPWR VPWR _2597_ sky130_fd_sc_hd__nor2_1
XFILLER_21_298 VGND VGND VPWR VPWR sky130_fd_sc_hd__fill_2
XFILLER_119_57 VPWR VGND VPWR VGND sky130_ef_sc_hd__decap_12
XFILLER_107_337 VPWR VGND VPWR VGND sky130_ef_sc_hd__decap_12
X_4669_ net136 _2425_ _2539_ _2541_ net137 VGND VGND VPWR VPWR _2542_ sky130_fd_sc_hd__o221a_1
X_6408_ clknet_leaf_41_clk _0816_ _0341_ VGND VGND VPWR VPWR reg_file_inst.registry\[1\]\[5\]
+ sky130_fd_sc_hd__dfrtp_1
XFILLER_1_615 VGND VGND VPWR VPWR sky130_fd_sc_hd__fill_1
XTAP_TAPCELL_ROW_112_1668 VGND VPWR sky130_fd_sc_hd__tapvpwrvgnd_1
X_6339_ clknet_leaf_30_clk _0747_ _0272_ VGND VGND VPWR VPWR reg_file_inst.registry\[8\]\[20\]
+ sky130_fd_sc_hd__dfrtp_1
XFILLER_95_27 VGND VGND VPWR VPWR sky130_fd_sc_hd__fill_2
XFILLER_88_265 VGND VGND VPWR VPWR sky130_fd_sc_hd__decap_4
XFILLER_0_169 VGND VGND VPWR VPWR sky130_fd_sc_hd__decap_8
XFILLER_95_49 VGND VGND VPWR VPWR sky130_fd_sc_hd__decap_6
XFILLER_29_321 VGND VGND VPWR VPWR sky130_fd_sc_hd__fill_1
XFILLER_57_641 VGND VGND VPWR VPWR sky130_fd_sc_hd__decap_6
XTAP_TAPCELL_ROW_67_1103 VGND VPWR sky130_fd_sc_hd__tapvpwrvgnd_1
XFILLER_57_685 VGND VGND VPWR VPWR sky130_fd_sc_hd__fill_1
XFILLER_56_162 VGND VGND VPWR VPWR sky130_fd_sc_hd__decap_6
XFILLER_17_505 VGND VGND VPWR VPWR sky130_fd_sc_hd__decap_4
XFILLER_28_98 VPWR VGND VPWR VGND sky130_ef_sc_hd__decap_12
XFILLER_44_302 VGND VGND VPWR VPWR sky130_fd_sc_hd__decap_6
XFILLER_56_195 VGND VGND VPWR VPWR sky130_fd_sc_hd__fill_1
XFILLER_72_699 VGND VGND VPWR VPWR sky130_fd_sc_hd__fill_1
XFILLER_32_508 VPWR VGND VPWR VGND sky130_ef_sc_hd__decap_12
XFILLER_44_368 VGND VGND VPWR VPWR sky130_fd_sc_hd__decap_6
XTAP_TAPCELL_ROW_27_599 VGND VPWR sky130_fd_sc_hd__tapvpwrvgnd_1
XFILLER_44_64 VGND VGND VPWR VPWR sky130_fd_sc_hd__decap_4
XFILLER_12_243 VGND VGND VPWR VPWR sky130_fd_sc_hd__decap_8
XFILLER_100_81 VGND VGND VPWR VPWR sky130_fd_sc_hd__decap_3
XFILLER_12_287 VPWR VGND VPWR VGND sky130_ef_sc_hd__decap_12
XFILLER_12_265 VGND VGND VPWR VPWR sky130_fd_sc_hd__decap_4
XFILLER_60_52 VPWR VGND VPWR VGND sky130_ef_sc_hd__decap_12
XTAP_TAPCELL_ROW_78_1243 VGND VPWR sky130_fd_sc_hd__tapvpwrvgnd_1
XFILLER_113_329 VGND VGND VPWR VPWR sky130_fd_sc_hd__decap_6
XFILLER_121_373 VPWR VGND VPWR VGND sky130_ef_sc_hd__decap_12
XFILLER_39_129 VPWR VGND VPWR VGND sky130_ef_sc_hd__decap_12
XFILLER_48_630 VGND VGND VPWR VPWR sky130_fd_sc_hd__decap_8
XFILLER_94_246 VGND VGND VPWR VPWR sky130_fd_sc_hd__decap_6
XFILLER_48_663 VGND VGND VPWR VPWR sky130_fd_sc_hd__fill_1
Xclkbuf_leaf_59_clk clknet_3_1__leaf_clk VGND VGND VPWR VPWR clknet_leaf_59_clk sky130_fd_sc_hd__clkbuf_8
XTAP_TAPCELL_ROW_89_1372 VGND VPWR sky130_fd_sc_hd__tapvpwrvgnd_1
XFILLER_75_493 VGND VGND VPWR VPWR sky130_fd_sc_hd__fill_2
XFILLER_63_655 VPWR VGND VPWR VGND sky130_ef_sc_hd__decap_12
XFILLER_63_633 VGND VGND VPWR VPWR sky130_fd_sc_hd__fill_1
XFILLER_35_335 VGND VGND VPWR VPWR sky130_fd_sc_hd__fill_1
XTAP_TAPCELL_ROW_46_842 VGND VPWR sky130_fd_sc_hd__tapvpwrvgnd_1
X_3971_ _1044_ _1049_ _1885_ VGND VGND VPWR VPWR _1887_ sky130_fd_sc_hd__or3_1
X_5710_ net148 VGND VGND VPWR VPWR _0118_ sky130_fd_sc_hd__inv_2
XFILLER_93_3 VPWR VGND VPWR VGND sky130_ef_sc_hd__decap_12
XFILLER_31_530 VGND VGND VPWR VPWR sky130_fd_sc_hd__fill_1
X_5641_ net146 VGND VGND VPWR VPWR _0049_ sky130_fd_sc_hd__inv_2
XFILLER_31_585 VGND VGND VPWR VPWR sky130_fd_sc_hd__decap_8
XFILLER_31_596 VGND VGND VPWR VPWR sky130_fd_sc_hd__decap_8
X_5572_ reg_file_inst.registry\[15\]\[20\] _2842_ _3003_ VGND VGND VPWR VPWR _0495_
+ sky130_fd_sc_hd__mux2_1
X_4523_ _2403_ _2405_ _1790_ VGND VGND VPWR VPWR _2406_ sky130_fd_sc_hd__mux2_1
XFILLER_116_189 VGND VGND VPWR VPWR sky130_fd_sc_hd__decap_6
XFILLER_104_307 VGND VGND VPWR VPWR sky130_fd_sc_hd__fill_1
X_4454_ _2337_ _2338_ net134 VGND VGND VPWR VPWR _2339_ sky130_fd_sc_hd__mux2_1
X_3405_ reg_file_inst.registry\[4\]\[19\] _1134_ _1138_ reg_file_inst.registry\[14\]\[19\]
+ VGND VGND VPWR VPWR _1341_ sky130_fd_sc_hd__a22o_1
X_4385_ _2269_ _2272_ net133 VGND VGND VPWR VPWR _2273_ sky130_fd_sc_hd__mux2_1
XFILLER_105_15 VPWR VGND VPWR VGND sky130_ef_sc_hd__decap_12
XFILLER_86_725 VGND VGND VPWR VPWR sky130_fd_sc_hd__fill_1
X_3336_ reg_file_inst.registry\[9\]\[21\] _1089_ _1094_ reg_file_inst.registry\[6\]\[21\]
+ VGND VGND VPWR VPWR _1274_ sky130_fd_sc_hd__a22o_1
X_6124_ clknet_leaf_44_clk _0532_ _0057_ VGND VGND VPWR VPWR reg_file_inst.registry\[6\]\[1\]
+ sky130_fd_sc_hd__dfrtp_1
X_6055_ net146 VGND VGND VPWR VPWR _0463_ sky130_fd_sc_hd__inv_2
XFILLER_100_568 VPWR VGND VPWR VGND sky130_ef_sc_hd__decap_12
X_3267_ _1207_ VGND VGND VPWR VPWR _1208_ sky130_fd_sc_hd__inv_2
X_5006_ _1333_ _1345_ _2289_ _2848_ VGND VGND VPWR VPWR _2849_ sky130_fd_sc_hd__a2bb2o_1
XFILLER_85_279 VGND VGND VPWR VPWR sky130_fd_sc_hd__fill_1
X_3198_ _1116_ _1127_ VGND VGND VPWR VPWR _1142_ sky130_fd_sc_hd__and2_4
XFILLER_54_600 VGND VGND VPWR VPWR sky130_fd_sc_hd__decap_6
XFILLER_39_685 VPWR VGND VPWR VGND sky130_ef_sc_hd__decap_12
XFILLER_121_69 VPWR VGND VPWR VGND sky130_ef_sc_hd__decap_12
XFILLER_81_485 VGND VGND VPWR VPWR sky130_fd_sc_hd__fill_1
XFILLER_41_349 VPWR VGND VPWR VGND sky130_ef_sc_hd__decap_12
XTAP_TAPCELL_ROW_62_1044 VGND VPWR sky130_fd_sc_hd__tapvpwrvgnd_1
XTAP_TAPCELL_ROW_62_1033 VGND VPWR sky130_fd_sc_hd__tapvpwrvgnd_1
X_5908_ net149 VGND VGND VPWR VPWR _0316_ sky130_fd_sc_hd__inv_2
XTAP_TAPCELL_ROW_24_558 VGND VPWR sky130_fd_sc_hd__tapvpwrvgnd_1
XTAP_TAPCELL_ROW_24_569 VGND VPWR sky130_fd_sc_hd__tapvpwrvgnd_1
X_5839_ net146 VGND VGND VPWR VPWR _0247_ sky130_fd_sc_hd__inv_2
XFILLER_108_613 VPWR VGND VPWR VGND sky130_ef_sc_hd__decap_12
XFILLER_5_206 VGND VGND VPWR VPWR sky130_fd_sc_hd__decap_3
XFILLER_108_657 VPWR VGND VPWR VGND sky130_ef_sc_hd__decap_12
XFILLER_107_167 VGND VGND VPWR VPWR sky130_fd_sc_hd__fill_1
XFILLER_1_401 VGND VGND VPWR VPWR sky130_fd_sc_hd__decap_6
XFILLER_122_137 VGND VGND VPWR VPWR sky130_fd_sc_hd__decap_3
XTAP_TAPCELL_ROW_73_1173 VGND VPWR sky130_fd_sc_hd__tapvpwrvgnd_1
XFILLER_39_53 VGND VGND VPWR VPWR sky130_fd_sc_hd__decap_3
XFILLER_49_449 VGND VGND VPWR VPWR sky130_fd_sc_hd__decap_6
XFILLER_17_335 VGND VGND VPWR VPWR sky130_fd_sc_hd__fill_1
XFILLER_29_184 VGND VGND VPWR VPWR sky130_fd_sc_hd__decap_8
XFILLER_45_655 VPWR VGND VPWR VGND sky130_ef_sc_hd__decap_12
XFILLER_72_474 VGND VGND VPWR VPWR sky130_fd_sc_hd__fill_2
XTAP_TAPCELL_ROW_43_801 VGND VPWR sky130_fd_sc_hd__tapvpwrvgnd_1
XFILLER_32_316 VGND VGND VPWR VPWR sky130_fd_sc_hd__decap_6
XFILLER_9_501 VGND VGND VPWR VPWR sky130_fd_sc_hd__decap_3
XFILLER_71_95 VPWR VGND VPWR VGND sky130_ef_sc_hd__decap_12
XFILLER_9_556 VGND VGND VPWR VPWR sky130_fd_sc_hd__decap_4
XFILLER_4_250 VGND VGND VPWR VPWR sky130_fd_sc_hd__fill_2
XFILLER_113_137 VPWR VGND VPWR VGND sky130_ef_sc_hd__decap_12
X_4170_ _2074_ _2077_ VGND VGND VPWR VPWR _2078_ sky130_fd_sc_hd__nor2_1
X_3121_ JMPOFF\[18\] net141 net41 VGND VGND VPWR VPWR _1065_ sky130_fd_sc_hd__a21o_1
XFILLER_121_181 VPWR VGND VPWR VGND sky130_ef_sc_hd__decap_12
X_3052_ JMPOFF\[6\] net141 net40 VGND VGND VPWR VPWR _0996_ sky130_fd_sc_hd__a21o_1
XFILLER_48_460 VGND VGND VPWR VPWR sky130_fd_sc_hd__decap_4
XFILLER_75_290 VPWR VGND VPWR VGND sky130_ef_sc_hd__decap_12
XFILLER_35_154 VPWR VGND VPWR VGND sky130_ef_sc_hd__decap_12
XFILLER_36_699 VGND VGND VPWR VPWR sky130_fd_sc_hd__fill_1
XFILLER_16_390 VPWR VGND VPWR VGND sky130_ef_sc_hd__decap_12
XFILLER_23_349 VGND VGND VPWR VPWR sky130_fd_sc_hd__decap_4
X_3954_ _1695_ _1723_ _1753_ _1869_ VGND VGND VPWR VPWR _1870_ sky130_fd_sc_hd__and4_1
XFILLER_50_135 VGND VGND VPWR VPWR sky130_fd_sc_hd__decap_4
XTAP_TAPCELL_ROW_21_528 VGND VPWR sky130_fd_sc_hd__tapvpwrvgnd_1
XFILLER_31_360 VGND VGND VPWR VPWR sky130_fd_sc_hd__fill_1
X_3885_ net136 _1802_ VGND VGND VPWR VPWR _1803_ sky130_fd_sc_hd__xnor2_1
XFILLER_31_393 VPWR VGND VPWR VGND sky130_ef_sc_hd__decap_12
X_5624_ net146 VGND VGND VPWR VPWR _0032_ sky130_fd_sc_hd__inv_2
X_5555_ _2986_ reg_file_inst.registry\[9\]\[8\] _3002_ VGND VGND VPWR VPWR _0511_
+ sky130_fd_sc_hd__mux2_1
X_5486_ JMPOFF\[19\] _2854_ _3000_ VGND VGND VPWR VPWR _0578_ sky130_fd_sc_hd__mux2_1
X_4506_ _1816_ _2298_ _2388_ VGND VGND VPWR VPWR _2389_ sky130_fd_sc_hd__a21boi_1
X_4437_ _2320_ _2321_ net135 VGND VGND VPWR VPWR _2322_ sky130_fd_sc_hd__mux2_1
XFILLER_113_671 VGND VGND VPWR VPWR sky130_fd_sc_hd__fill_1
XFILLER_86_533 VGND VGND VPWR VPWR sky130_fd_sc_hd__decap_3
XFILLER_76_29 VGND VGND VPWR VPWR sky130_fd_sc_hd__fill_1
X_6107_ clknet_leaf_4_clk _0515_ _0040_ VGND VGND VPWR VPWR reg_file_inst.registry\[9\]\[12\]
+ sky130_fd_sc_hd__dfrtp_1
X_4368_ _1708_ _2192_ _2235_ _2250_ _2255_ VGND VGND VPWR VPWR _2256_ sky130_fd_sc_hd__o311a_1
XFILLER_100_321 VGND VGND VPWR VPWR sky130_fd_sc_hd__decap_8
X_3319_ reg_file_inst.registry\[6\]\[22\] _1123_ _1132_ VGND VGND VPWR VPWR _1258_
+ sky130_fd_sc_hd__and3_1
X_4299_ _1652_ _1679_ VGND VGND VPWR VPWR _2187_ sky130_fd_sc_hd__or2_1
X_6038_ net148 VGND VGND VPWR VPWR _0446_ sky130_fd_sc_hd__inv_2
XFILLER_27_600 VGND VGND VPWR VPWR sky130_fd_sc_hd__fill_1
XTAP_TAPCELL_ROW_29_628 VGND VPWR sky130_fd_sc_hd__tapvpwrvgnd_1
XTAP_TAPCELL_ROW_1_275 VGND VPWR sky130_fd_sc_hd__tapvpwrvgnd_1
XFILLER_25_11 VGND VGND VPWR VPWR sky130_fd_sc_hd__fill_1
XFILLER_26_154 VPWR VGND VPWR VGND sky130_ef_sc_hd__decap_12
XFILLER_25_33 VGND VGND VPWR VPWR sky130_fd_sc_hd__decap_6
XFILLER_25_66 VPWR VGND VPWR VGND sky130_ef_sc_hd__decap_12
XTAP_TAPCELL_ROW_120_1767 VGND VPWR sky130_fd_sc_hd__tapvpwrvgnd_1
XFILLER_6_515 VPWR VGND VPWR VGND sky130_ef_sc_hd__decap_12
XFILLER_108_421 VPWR VGND VPWR VGND sky130_ef_sc_hd__decap_12
XTAP_TAPCELL_ROW_75_1202 VGND VPWR sky130_fd_sc_hd__tapvpwrvgnd_1
XFILLER_41_98 VPWR VGND VPWR VGND sky130_ef_sc_hd__decap_12
XTAP_TAPCELL_ROW_9_375 VGND VPWR sky130_fd_sc_hd__tapvpwrvgnd_1
XFILLER_104_693 VGND VGND VPWR VPWR sky130_fd_sc_hd__decap_6
XFILLER_1_264 VGND VGND VPWR VPWR sky130_fd_sc_hd__fill_2
XFILLER_2_15 VPWR VGND VPWR VGND sky130_ef_sc_hd__decap_12
XFILLER_1_297 VGND VGND VPWR VPWR sky130_fd_sc_hd__decap_4
XFILLER_92_503 VPWR VGND VPWR VGND sky130_ef_sc_hd__decap_12
XFILLER_64_238 VPWR VGND VPWR VGND sky130_ef_sc_hd__decap_12
XFILLER_17_110 VGND VGND VPWR VPWR sky130_fd_sc_hd__fill_2
XFILLER_17_121 VGND VGND VPWR VPWR sky130_fd_sc_hd__fill_2
XTAP_TAPCELL_ROW_86_1342 VGND VPWR sky130_fd_sc_hd__tapvpwrvgnd_1
XTAP_TAPCELL_ROW_56_970 VGND VPWR sky130_fd_sc_hd__tapvpwrvgnd_1
XFILLER_17_165 VGND VGND VPWR VPWR sky130_fd_sc_hd__decap_3
XFILLER_18_699 VGND VGND VPWR VPWR sky130_fd_sc_hd__fill_1
XFILLER_82_83 VGND VGND VPWR VPWR sky130_fd_sc_hd__fill_1
XFILLER_82_61 VGND VGND VPWR VPWR sky130_fd_sc_hd__decap_3
XFILLER_33_647 VPWR VGND VPWR VGND sky130_ef_sc_hd__decap_12
XFILLER_32_157 VGND VGND VPWR VPWR sky130_fd_sc_hd__fill_1
X_3670_ MEMOFF\[8\] _1079_ _1091_ reg_file_inst.registry\[3\]\[8\] VGND VGND VPWR
+ VPWR _1595_ sky130_fd_sc_hd__a22o_1
XTAP_TAPCELL_ROW_97_1482 VGND VPWR sky130_fd_sc_hd__tapvpwrvgnd_1
XTAP_TAPCELL_ROW_97_1471 VGND VPWR sky130_fd_sc_hd__tapvpwrvgnd_1
X_5340_ _2842_ reg_file_inst.registry\[3\]\[20\] _2995_ VGND VGND VPWR VPWR _0719_
+ sky130_fd_sc_hd__mux2_1
Xoutput116 net116 VGND VGND VPWR VPWR IC[22] sky130_fd_sc_hd__buf_1
Xoutput105 net105 VGND VGND VPWR VPWR IC[12] sky130_fd_sc_hd__buf_1
XFILLER_114_413 VGND VGND VPWR VPWR sky130_fd_sc_hd__decap_6
XFILLER_99_135 VGND VGND VPWR VPWR sky130_fd_sc_hd__fill_1
XFILLER_99_113 VPWR VGND VPWR VGND sky130_ef_sc_hd__decap_12
X_5271_ reg_file_inst.registry\[14\]\[2\] _2501_ _2992_ VGND VGND VPWR VPWR _0785_
+ sky130_fd_sc_hd__mux2_1
Xoutput127 net127 VGND VGND VPWR VPWR IC[7] sky130_fd_sc_hd__buf_1
XFILLER_114_457 VPWR VGND VPWR VGND sky130_ef_sc_hd__decap_12
X_4222_ net113 _2111_ VGND VGND VPWR VPWR _0923_ sky130_fd_sc_hd__xnor2_1
X_4153_ net119 net130 _2065_ _2066_ VGND VGND VPWR VPWR _0947_ sky130_fd_sc_hd__a22o_1
XFILLER_68_533 VPWR VGND VPWR VGND sky130_ef_sc_hd__decap_12
X_4084_ _1053_ _1058_ _1060_ _1999_ VGND VGND VPWR VPWR _2000_ sky130_fd_sc_hd__a31o_1
X_3104_ JMPOFF\[13\] net141 net41 VGND VGND VPWR VPWR _1048_ sky130_fd_sc_hd__a21oi_1
X_3035_ JMPOFF\[23\] JMPOFF\[22\] _0967_ VGND VGND VPWR VPWR _0979_ sky130_fd_sc_hd__o21ai_1
XFILLER_102_27 VGND VGND VPWR VPWR sky130_fd_sc_hd__fill_1
XFILLER_23_113 VGND VGND VPWR VPWR sky130_fd_sc_hd__decap_6
XFILLER_36_474 VGND VGND VPWR VPWR sky130_fd_sc_hd__fill_2
X_4986_ _2129_ _2452_ _2721_ VGND VGND VPWR VPWR _2831_ sky130_fd_sc_hd__o21ai_1
XTAP_TAPCELL_ROW_34_686 VGND VPWR sky130_fd_sc_hd__tapvpwrvgnd_1
X_3937_ net135 _1826_ _1841_ _1852_ VGND VGND VPWR VPWR _1853_ sky130_fd_sc_hd__a22o_1
X_3868_ reg_file_inst.registry\[4\]\[2\] _1092_ _1096_ reg_file_inst.registry\[11\]\[2\]
+ VGND VGND VPWR VPWR _1787_ sky130_fd_sc_hd__a22o_1
X_5607_ net44 VGND VGND VPWR VPWR _0015_ sky130_fd_sc_hd__inv_2
X_3799_ reg_file_inst.registry\[0\]\[4\] _1118_ _1716_ _1720_ VGND VGND VPWR VPWR
+ net95 sky130_fd_sc_hd__o22a_2
X_5538_ _2767_ reg_file_inst.registry\[9\]\[25\] _3002_ VGND VGND VPWR VPWR _0528_
+ sky130_fd_sc_hd__mux2_1
XFILLER_11_57 VPWR VGND VPWR VGND sky130_ef_sc_hd__decap_12
XFILLER_117_273 VGND VGND VPWR VPWR sky130_fd_sc_hd__decap_6
XFILLER_3_529 VPWR VGND VPWR VGND sky130_ef_sc_hd__decap_12
XFILLER_87_39 VPWR VGND VPWR VGND sky130_ef_sc_hd__decap_12
X_5469_ reg_file_inst.registry\[5\]\[7\] _2311_ _2999_ VGND VGND VPWR VPWR _0594_
+ sky130_fd_sc_hd__mux2_1
XTAP_TAPCELL_ROW_6_334 VGND VPWR sky130_fd_sc_hd__tapvpwrvgnd_1
XFILLER_101_641 VPWR VGND VPWR VGND sky130_ef_sc_hd__decap_12
XFILLER_86_341 VGND VGND VPWR VPWR sky130_fd_sc_hd__fill_2
XTAP_TAPCELL_ROW_70_1143 VGND VPWR sky130_fd_sc_hd__tapvpwrvgnd_1
XFILLER_59_544 VPWR VGND VPWR VGND sky130_ef_sc_hd__decap_12
XTAP_TAPCELL_ROW_6_345 VGND VPWR sky130_fd_sc_hd__tapvpwrvgnd_1
XFILLER_101_685 VPWR VGND VPWR VGND sky130_ef_sc_hd__decap_12
XFILLER_86_363 VGND VGND VPWR VPWR sky130_fd_sc_hd__fill_1
XTAP_TAPCELL_ROW_109_1629 VGND VPWR sky130_fd_sc_hd__tapvpwrvgnd_1
XTAP_TAPCELL_ROW_122_1807 VGND VPWR sky130_fd_sc_hd__tapvpwrvgnd_1
XFILLER_36_65 VGND VGND VPWR VPWR sky130_fd_sc_hd__decap_8
XFILLER_42_433 VPWR VGND VPWR VGND sky130_ef_sc_hd__decap_12
XFILLER_14_157 VGND VGND VPWR VPWR sky130_fd_sc_hd__decap_6
XFILLER_14_179 VPWR VGND VPWR VGND sky130_ef_sc_hd__decap_12
XTAP_TAPCELL_ROW_81_1272 VGND VPWR sky130_fd_sc_hd__tapvpwrvgnd_1
Xinput18 DataMemoryRead[25] VGND VGND VPWR VPWR net18 sky130_fd_sc_hd__dlymetal6s2s_1
XFILLER_22_190 VGND VGND VPWR VPWR sky130_fd_sc_hd__decap_6
Xinput29 instr[0] VGND VGND VPWR VPWR net29 sky130_fd_sc_hd__buf_6
XFILLER_6_323 VGND VGND VPWR VPWR sky130_fd_sc_hd__decap_8
XFILLER_108_251 VGND VGND VPWR VPWR sky130_fd_sc_hd__fill_1
XFILLER_97_617 VPWR VGND VPWR VGND sky130_ef_sc_hd__decap_12
XFILLER_111_405 VPWR VGND VPWR VGND sky130_ef_sc_hd__decap_12
XFILLER_111_449 VPWR VGND VPWR VGND sky130_ef_sc_hd__decap_12
XFILLER_77_83 VGND VGND VPWR VPWR sky130_fd_sc_hd__decap_6
XFILLER_65_558 VGND VGND VPWR VPWR sky130_fd_sc_hd__fill_2
XFILLER_61_720 VGND VGND VPWR VPWR sky130_fd_sc_hd__decap_6
X_4840_ _1109_ _2124_ _2282_ _1151_ _2254_ VGND VGND VPWR VPWR _2699_ sky130_fd_sc_hd__o221a_1
XFILLER_21_617 VGND VGND VPWR VPWR sky130_fd_sc_hd__fill_1
XTAP_TAPCELL_ROW_99_1500 VGND VPWR sky130_fd_sc_hd__tapvpwrvgnd_1
X_6510_ clknet_leaf_5_clk _0918_ _0443_ VGND VGND VPWR VPWR reg_file_inst.registry\[11\]\[3\]
+ sky130_fd_sc_hd__dfrtp_1
X_4771_ _2629_ _1446_ VGND VGND VPWR VPWR _2630_ sky130_fd_sc_hd__nand2b_1
XFILLER_119_505 VPWR VGND VPWR VGND sky130_ef_sc_hd__decap_12
X_3722_ reg_file_inst.registry\[11\]\[7\] _1096_ _1643_ _1644_ _1075_ VGND VGND VPWR
+ VPWR _1646_ sky130_fd_sc_hd__a2111o_1
XTAP_TAPCELL_ROW_31_656 VGND VPWR sky130_fd_sc_hd__tapvpwrvgnd_1
X_3653_ MEMOFF\[9\] _1079_ _1096_ reg_file_inst.registry\[11\]\[9\] _1571_ VGND VGND
+ VPWR VPWR _1579_ sky130_fd_sc_hd__a221o_1
X_6441_ clknet_leaf_62_clk _0849_ _0374_ VGND VGND VPWR VPWR reg_file_inst.registry\[0\]\[2\]
+ sky130_fd_sc_hd__dfrtp_2
X_6372_ clknet_leaf_22_clk _0780_ _0305_ VGND VGND VPWR VPWR reg_file_inst.registry\[2\]\[25\]
+ sky130_fd_sc_hd__dfrtp_1
X_3584_ reg_file_inst.registry\[9\]\[14\] _1131_ _1141_ reg_file_inst.registry\[11\]\[14\]
+ _1507_ VGND VGND VPWR VPWR _1513_ sky130_fd_sc_hd__a221o_1
X_5323_ _2986_ reg_file_inst.registry\[8\]\[8\] _2994_ VGND VGND VPWR VPWR _0735_
+ sky130_fd_sc_hd__mux2_1
XFILLER_114_221 VPWR VGND VPWR VGND sky130_ef_sc_hd__decap_12
XFILLER_114_265 VPWR VGND VPWR VGND sky130_ef_sc_hd__decap_12
X_5254_ reg_file_inst.registry\[14\]\[19\] _2854_ _2992_ VGND VGND VPWR VPWR _0802_
+ sky130_fd_sc_hd__mux2_1
XFILLER_87_116 VGND VGND VPWR VPWR sky130_fd_sc_hd__decap_3
X_5185_ _2842_ reg_file_inst.registry\[0\]\[20\] _2988_ VGND VGND VPWR VPWR _0867_
+ sky130_fd_sc_hd__mux2_1
X_4205_ _1937_ _1973_ VGND VGND VPWR VPWR _2101_ sky130_fd_sc_hd__xor2_1
X_4136_ _2036_ _2046_ _2047_ _2050_ _1884_ VGND VGND VPWR VPWR _2052_ sky130_fd_sc_hd__a311oi_2
XTAP_TAPCELL_ROW_3_304 VGND VPWR sky130_fd_sc_hd__tapvpwrvgnd_1
XFILLER_113_15 VPWR VGND VPWR VGND sky130_ef_sc_hd__decap_12
XFILLER_95_182 VPWR VGND VPWR VGND sky130_ef_sc_hd__decap_12
XFILLER_68_396 VPWR VGND VPWR VGND sky130_ef_sc_hd__decap_12
X_4067_ _1032_ _1982_ VGND VGND VPWR VPWR _1983_ sky130_fd_sc_hd__xnor2_1
XTAP_TAPCELL_ROW_39_756 VGND VPWR sky130_fd_sc_hd__tapvpwrvgnd_1
XFILLER_83_388 VGND VGND VPWR VPWR sky130_fd_sc_hd__decap_4
X_3018_ net34 net33 VGND VGND VPWR VPWR _0963_ sky130_fd_sc_hd__nor2_1
XFILLER_43_219 VGND VGND VPWR VPWR sky130_fd_sc_hd__decap_4
XFILLER_36_293 VGND VGND VPWR VPWR sky130_fd_sc_hd__decap_3
XTAP_TAPCELL_ROW_104_1559 VGND VPWR sky130_fd_sc_hd__tapvpwrvgnd_1
X_4969_ net15 net101 net59 _2308_ VGND VGND VPWR VPWR _2817_ sky130_fd_sc_hd__a22o_4
XTAP_TAPCELL_ROW_59_1005 VGND VPWR sky130_fd_sc_hd__tapvpwrvgnd_1
XFILLER_98_27 VGND VGND VPWR VPWR sky130_fd_sc_hd__fill_1
XFILLER_121_725 VGND VGND VPWR VPWR sky130_fd_sc_hd__fill_1
XTAP_TAPCELL_ROW_115_1699 VGND VPWR sky130_fd_sc_hd__tapvpwrvgnd_1
XPHY_EDGE_ROW_110_Right_110 VGND VGND VPWR VPWR sky130_fd_sc_hd__decap_3
XFILLER_47_503 VGND VGND VPWR VPWR sky130_fd_sc_hd__fill_1
XFILLER_86_171 VPWR VGND VPWR VGND sky130_ef_sc_hd__decap_12
XFILLER_47_86 VPWR VGND VPWR VGND sky130_ef_sc_hd__decap_12
XFILLER_47_569 VGND VGND VPWR VPWR sky130_fd_sc_hd__fill_2
XTAP_TAPCELL_ROW_83_1301 VGND VPWR sky130_fd_sc_hd__tapvpwrvgnd_1
XFILLER_43_720 VGND VGND VPWR VPWR sky130_fd_sc_hd__decap_3
XFILLER_103_81 VPWR VGND VPWR VGND sky130_ef_sc_hd__decap_12
XFILLER_63_30 VPWR VGND VPWR VGND sky130_ef_sc_hd__decap_12
XFILLER_42_274 VPWR VGND VPWR VGND sky130_ef_sc_hd__decap_12
XFILLER_10_160 VGND VGND VPWR VPWR sky130_fd_sc_hd__decap_6
XFILLER_7_665 VGND VGND VPWR VPWR sky130_fd_sc_hd__decap_6
XTAP_TAPCELL_ROW_94_1441 VGND VPWR sky130_fd_sc_hd__tapvpwrvgnd_1
XFILLER_6_197 VGND VGND VPWR VPWR sky130_fd_sc_hd__decap_6
XFILLER_40_6 VPWR VGND VPWR VGND sky130_ef_sc_hd__decap_12
XFILLER_112_725 VGND VGND VPWR VPWR sky130_fd_sc_hd__fill_1
XFILLER_88_93 VPWR VGND VPWR VGND sky130_ef_sc_hd__decap_12
XFILLER_111_279 VGND VGND VPWR VPWR sky130_fd_sc_hd__fill_1
XFILLER_19_3 VPWR VGND VPWR VGND sky130_ef_sc_hd__decap_12
XFILLER_93_653 VPWR VGND VPWR VGND sky130_ef_sc_hd__decap_12
XFILLER_92_141 VGND VGND VPWR VPWR sky130_fd_sc_hd__decap_4
XFILLER_93_697 VPWR VGND VPWR VGND sky130_ef_sc_hd__decap_12
X_5941_ net147 VGND VGND VPWR VPWR _0349_ sky130_fd_sc_hd__inv_2
XTAP_TAPCELL_ROW_36_715 VGND VPWR sky130_fd_sc_hd__tapvpwrvgnd_1
XFILLER_61_561 VGND VGND VPWR VPWR sky130_fd_sc_hd__fill_1
X_5872_ net149 VGND VGND VPWR VPWR _0280_ sky130_fd_sc_hd__inv_2
X_4823_ _2568_ _2679_ _2681_ VGND VGND VPWR VPWR _2682_ sky130_fd_sc_hd__o21ai_1
XTAP_TAPCELL_ROW_16_461 VGND VPWR sky130_fd_sc_hd__tapvpwrvgnd_1
XFILLER_33_296 VPWR VGND VPWR VGND sky130_ef_sc_hd__decap_12
XFILLER_21_447 VGND VGND VPWR VPWR sky130_fd_sc_hd__fill_1
X_4754_ _1594_ _2611_ VGND VGND VPWR VPWR _2613_ sky130_fd_sc_hd__nand2_1
XFILLER_119_335 VGND VGND VPWR VPWR sky130_fd_sc_hd__fill_1
X_3705_ _1494_ _1518_ _1628_ VGND VGND VPWR VPWR _1629_ sky130_fd_sc_hd__or3_1
X_4685_ _2501_ reg_file_inst.registry\[11\]\[10\] _2118_ VGND VGND VPWR VPWR _0909_
+ sky130_fd_sc_hd__mux2_1
XFILLER_108_26 VGND VGND VPWR VPWR sky130_fd_sc_hd__fill_2
X_6424_ clknet_leaf_37_clk _0832_ _0357_ VGND VGND VPWR VPWR reg_file_inst.registry\[1\]\[21\]
+ sky130_fd_sc_hd__dfrtp_1
X_3636_ reg_file_inst.registry\[6\]\[10\] _1135_ _1554_ _1555_ _1558_ VGND VGND VPWR
+ VPWR _1563_ sky130_fd_sc_hd__a2111o_1
XFILLER_115_541 VPWR VGND VPWR VGND sky130_ef_sc_hd__decap_12
X_3567_ reg_file_inst.registry\[14\]\[14\] _1081_ _1087_ reg_file_inst.registry\[1\]\[14\]
+ _1495_ VGND VGND VPWR VPWR _1496_ sky130_fd_sc_hd__a221o_1
X_6355_ clknet_leaf_46_clk _0763_ _0288_ VGND VGND VPWR VPWR reg_file_inst.registry\[2\]\[8\]
+ sky130_fd_sc_hd__dfrtp_1
XFILLER_115_585 VPWR VGND VPWR VGND sky130_ef_sc_hd__decap_12
X_5306_ _2767_ reg_file_inst.registry\[8\]\[25\] _2994_ VGND VGND VPWR VPWR _0752_
+ sky130_fd_sc_hd__mux2_1
X_6286_ clknet_leaf_30_clk _0694_ _0219_ VGND VGND VPWR VPWR MEMOFF\[23\] sky130_fd_sc_hd__dfrtp_1
X_3498_ reg_file_inst.registry\[9\]\[12\] _1089_ _1097_ reg_file_inst.registry\[5\]\[12\]
+ _1422_ VGND VGND VPWR VPWR _1430_ sky130_fd_sc_hd__a221o_1
X_5237_ _2375_ reg_file_inst.registry\[1\]\[6\] _2990_ VGND VGND VPWR VPWR _0817_
+ sky130_fd_sc_hd__mux2_1
XFILLER_69_694 VPWR VGND VPWR VGND sky130_ef_sc_hd__decap_12
XFILLER_68_160 VPWR VGND VPWR VGND sky130_ef_sc_hd__decap_12
XFILLER_56_300 VGND VGND VPWR VPWR sky130_fd_sc_hd__decap_8
X_5168_ reg_file_inst.registry\[7\]\[7\] _2311_ _2553_ VGND VGND VPWR VPWR _0882_
+ sky130_fd_sc_hd__mux2_1
X_4119_ _2026_ _2027_ _2034_ VGND VGND VPWR VPWR _2035_ sky130_fd_sc_hd__or3_1
XFILLER_56_355 VGND VGND VPWR VPWR sky130_fd_sc_hd__decap_8
X_5099_ _1447_ _2286_ _2371_ _2721_ _2927_ VGND VGND VPWR VPWR _2928_ sky130_fd_sc_hd__a221o_1
XFILLER_29_547 VPWR VGND VPWR VGND sky130_ef_sc_hd__decap_12
XFILLER_83_163 VGND VGND VPWR VPWR sky130_fd_sc_hd__decap_4
XFILLER_83_185 VPWR VGND VPWR VGND sky130_ef_sc_hd__decap_12
XFILLER_71_358 VGND VGND VPWR VPWR sky130_fd_sc_hd__decap_6
XFILLER_37_580 VGND VGND VPWR VPWR sky130_fd_sc_hd__fill_2
XTAP_TAPCELL_ROW_65_1075 VGND VPWR sky130_fd_sc_hd__tapvpwrvgnd_1
XFILLER_33_11 VGND VGND VPWR VPWR sky130_fd_sc_hd__fill_1
XTAP_TAPCELL_ROW_117_1728 VGND VPWR sky130_fd_sc_hd__tapvpwrvgnd_1
XFILLER_4_613 VPWR VGND VPWR VGND sky130_ef_sc_hd__decap_12
XFILLER_4_657 VPWR VGND VPWR VGND sky130_ef_sc_hd__decap_12
XFILLER_3_134 VPWR VGND VPWR VGND sky130_ef_sc_hd__decap_12
XFILLER_67_609 VGND VGND VPWR VPWR sky130_fd_sc_hd__decap_6
XFILLER_66_119 VPWR VGND VPWR VGND sky130_ef_sc_hd__decap_12
XFILLER_58_85 VPWR VGND VPWR VGND sky130_ef_sc_hd__decap_12
XFILLER_75_653 VPWR VGND VPWR VGND sky130_ef_sc_hd__decap_12
XFILLER_74_141 VPWR VGND VPWR VGND sky130_ef_sc_hd__decap_12
XFILLER_47_333 VGND VGND VPWR VPWR sky130_fd_sc_hd__decap_3
XFILLER_90_601 VPWR VGND VPWR VGND sky130_ef_sc_hd__decap_12
XFILLER_75_697 VPWR VGND VPWR VGND sky130_ef_sc_hd__decap_12
XFILLER_90_645 VPWR VGND VPWR VGND sky130_ef_sc_hd__decap_12
XFILLER_43_561 VGND VGND VPWR VPWR sky130_fd_sc_hd__decap_8
XFILLER_88_6 VPWR VGND VPWR VGND sky130_ef_sc_hd__decap_12
XTAP_TAPCELL_ROW_13_431 VGND VPWR sky130_fd_sc_hd__tapvpwrvgnd_1
XFILLER_90_83 VGND VGND VPWR VPWR sky130_fd_sc_hd__fill_1
XTAP_TAPCELL_ROW_41_773 VGND VPWR sky130_fd_sc_hd__tapvpwrvgnd_1
X_4470_ _2353_ _2354_ VGND VGND VPWR VPWR _2355_ sky130_fd_sc_hd__or2_1
X_3421_ _1351_ _1353_ _1354_ _1355_ VGND VGND VPWR VPWR _1356_ sky130_fd_sc_hd__nor4_1
Xmax_cap137 _1765_ VGND VGND VPWR VPWR net137 sky130_fd_sc_hd__buf_12
XFILLER_98_701 VPWR VGND VPWR VGND sky130_ef_sc_hd__decap_12
X_6140_ clknet_leaf_25_clk _0548_ _0073_ VGND VGND VPWR VPWR reg_file_inst.registry\[6\]\[17\]
+ sky130_fd_sc_hd__dfrtp_1
X_3352_ MEMOFF\[21\] _1129_ _1130_ JMPOFF\[21\] _1289_ VGND VGND VPWR VPWR _1290_
+ sky130_fd_sc_hd__a221o_1
XFILLER_112_533 VPWR VGND VPWR VGND sky130_ef_sc_hd__decap_12
X_3283_ MEMOFF\[23\] _1079_ _1095_ JMPOFF\[23\] _1222_ VGND VGND VPWR VPWR _1223_
+ sky130_fd_sc_hd__a221o_1
X_6071_ clknet_leaf_54_clk _0479_ _0004_ VGND VGND VPWR VPWR reg_file_inst.registry\[15\]\[4\]
+ sky130_fd_sc_hd__dfrtp_1
XFILLER_97_299 VPWR VGND VPWR VGND sky130_ef_sc_hd__decap_12
XFILLER_66_631 VGND VGND VPWR VPWR sky130_fd_sc_hd__decap_3
X_5022_ _2176_ _2844_ _2855_ _2862_ VGND VGND VPWR VPWR net54 sky130_fd_sc_hd__a31o_1
XFILLER_78_491 VGND VGND VPWR VPWR sky130_fd_sc_hd__fill_1
XFILLER_66_642 VGND VGND VPWR VPWR sky130_fd_sc_hd__fill_2
XFILLER_38_333 VPWR VGND VPWR VGND sky130_ef_sc_hd__decap_12
XFILLER_66_686 VPWR VGND VPWR VGND sky130_ef_sc_hd__decap_12
XTAP_TAPCELL_ROW_49_873 VGND VPWR sky130_fd_sc_hd__tapvpwrvgnd_1
X_5924_ net149 VGND VGND VPWR VPWR _0332_ sky130_fd_sc_hd__inv_2
XFILLER_80_155 VGND VGND VPWR VPWR sky130_fd_sc_hd__fill_1
XFILLER_22_701 VGND VGND VPWR VPWR sky130_fd_sc_hd__decap_3
XFILLER_110_27 VGND VGND VPWR VPWR sky130_fd_sc_hd__fill_1
XTAP_TAPCELL_ROW_101_1529 VGND VPWR sky130_fd_sc_hd__tapvpwrvgnd_1
X_5855_ net147 VGND VGND VPWR VPWR _0263_ sky130_fd_sc_hd__inv_2
X_4806_ _1417_ _2664_ VGND VGND VPWR VPWR _2665_ sky130_fd_sc_hd__or2_1
XFILLER_21_233 VGND VGND VPWR VPWR sky130_fd_sc_hd__fill_1
X_5786_ net44 VGND VGND VPWR VPWR _0194_ sky130_fd_sc_hd__inv_2
XFILLER_9_90 VPWR VGND VPWR VGND sky130_ef_sc_hd__decap_12
X_4737_ _2595_ VGND VGND VPWR VPWR _2596_ sky130_fd_sc_hd__inv_2
XFILLER_119_69 VPWR VGND VPWR VGND sky130_ef_sc_hd__decap_12
XFILLER_107_305 VPWR VGND VPWR VGND sky130_ef_sc_hd__decap_12
X_4668_ _1816_ _2479_ _1790_ VGND VGND VPWR VPWR _2541_ sky130_fd_sc_hd__a21o_1
XFILLER_107_349 VPWR VGND VPWR VGND sky130_ef_sc_hd__decap_12
X_3619_ reg_file_inst.registry\[2\]\[10\] _1083_ _1092_ reg_file_inst.registry\[4\]\[10\]
+ VGND VGND VPWR VPWR _1546_ sky130_fd_sc_hd__a22o_1
X_6407_ clknet_leaf_50_clk _0815_ _0340_ VGND VGND VPWR VPWR reg_file_inst.registry\[1\]\[4\]
+ sky130_fd_sc_hd__dfrtp_1
X_4599_ net37 _2117_ net101 net22 VGND VGND VPWR VPWR _2477_ sky130_fd_sc_hd__a22o_1
XFILLER_115_393 VPWR VGND VPWR VGND sky130_ef_sc_hd__decap_12
XTAP_TAPCELL_ROW_112_1669 VGND VPWR sky130_fd_sc_hd__tapvpwrvgnd_1
XTAP_TAPCELL_ROW_112_1658 VGND VPWR sky130_fd_sc_hd__tapvpwrvgnd_1
X_6338_ clknet_leaf_20_clk _0746_ _0271_ VGND VGND VPWR VPWR reg_file_inst.registry\[8\]\[19\]
+ sky130_fd_sc_hd__dfrtp_1
X_6269_ clknet_leaf_3_clk _0677_ _0202_ VGND VGND VPWR VPWR MEMOFF\[6\] sky130_fd_sc_hd__dfrtp_1
XFILLER_69_480 VGND VGND VPWR VPWR sky130_fd_sc_hd__fill_1
XFILLER_29_300 VGND VGND VPWR VPWR sky130_fd_sc_hd__decap_8
XFILLER_57_653 VPWR VGND VPWR VGND sky130_ef_sc_hd__decap_12
XFILLER_28_66 VGND VGND VPWR VPWR sky130_fd_sc_hd__fill_2
XFILLER_72_623 VPWR VGND VPWR VGND sky130_ef_sc_hd__decap_12
XTAP_TAPCELL_ROW_67_1104 VGND VPWR sky130_fd_sc_hd__tapvpwrvgnd_1
XFILLER_72_645 VPWR VGND VPWR VGND sky130_ef_sc_hd__decap_12
XFILLER_71_111 VGND VGND VPWR VPWR sky130_fd_sc_hd__fill_1
XFILLER_25_561 VGND VGND VPWR VPWR sky130_fd_sc_hd__decap_8
XFILLER_12_222 VGND VGND VPWR VPWR sky130_fd_sc_hd__fill_2
XFILLER_60_64 VPWR VGND VPWR VGND sky130_ef_sc_hd__decap_12
XFILLER_12_299 VGND VGND VPWR VPWR sky130_fd_sc_hd__decap_4
XTAP_TAPCELL_ROW_78_1244 VGND VPWR sky130_fd_sc_hd__tapvpwrvgnd_1
XTAP_TAPCELL_ROW_78_1233 VGND VPWR sky130_fd_sc_hd__tapvpwrvgnd_1
XFILLER_5_15 VPWR VGND VPWR VGND sky130_ef_sc_hd__decap_12
XTAP_TAPCELL_ROW_91_1400 VGND VPWR sky130_fd_sc_hd__tapvpwrvgnd_1
XFILLER_4_465 VGND VGND VPWR VPWR sky130_fd_sc_hd__fill_1
XFILLER_69_73 VGND VGND VPWR VPWR sky130_fd_sc_hd__fill_2
XFILLER_121_385 VGND VGND VPWR VPWR sky130_fd_sc_hd__decap_6
XPHY_EDGE_ROW_13_Right_13 VGND VGND VPWR VPWR sky130_fd_sc_hd__decap_3
XFILLER_48_642 VGND VGND VPWR VPWR sky130_fd_sc_hd__fill_2
XTAP_TAPCELL_ROW_89_1373 VGND VPWR sky130_fd_sc_hd__tapvpwrvgnd_1
XFILLER_75_461 VPWR VGND VPWR VGND sky130_ef_sc_hd__decap_12
XFILLER_62_122 VPWR VGND VPWR VGND sky130_ef_sc_hd__decap_12
XTAP_TAPCELL_ROW_46_843 VGND VPWR sky130_fd_sc_hd__tapvpwrvgnd_1
XFILLER_63_667 VGND VGND VPWR VPWR sky130_fd_sc_hd__fill_1
XFILLER_16_550 VGND VGND VPWR VPWR sky130_fd_sc_hd__fill_1
X_3970_ _1044_ _1885_ VGND VGND VPWR VPWR _1886_ sky130_fd_sc_hd__or2_1
XFILLER_16_572 VGND VGND VPWR VPWR sky130_fd_sc_hd__fill_1
XFILLER_50_317 VGND VGND VPWR VPWR sky130_fd_sc_hd__fill_2
XFILLER_86_3 VPWR VGND VPWR VGND sky130_ef_sc_hd__decap_12
X_5640_ net146 VGND VGND VPWR VPWR _0048_ sky130_fd_sc_hd__inv_2
X_5571_ reg_file_inst.registry\[15\]\[21\] _2829_ _3003_ VGND VGND VPWR VPWR _0496_
+ sky130_fd_sc_hd__mux2_1
XPHY_EDGE_ROW_22_Right_22 VGND VGND VPWR VPWR sky130_fd_sc_hd__decap_3
X_4522_ net135 _2260_ VGND VGND VPWR VPWR _2405_ sky130_fd_sc_hd__nand2_1
XFILLER_7_292 VPWR VGND VPWR VGND sky130_ef_sc_hd__decap_12
XFILLER_7_270 VGND VGND VPWR VPWR sky130_fd_sc_hd__decap_4
X_4453_ _2193_ _2206_ _1840_ VGND VGND VPWR VPWR _2338_ sky130_fd_sc_hd__mux2_1
X_3404_ MEMOFF\[19\] _1129_ _1130_ JMPOFF\[19\] _1339_ VGND VGND VPWR VPWR _1340_
+ sky130_fd_sc_hd__a221o_1
X_4384_ _2271_ VGND VGND VPWR VPWR _2272_ sky130_fd_sc_hd__inv_2
X_3335_ reg_file_inst.registry\[3\]\[21\] _1091_ _1270_ _1272_ VGND VGND VPWR VPWR
+ _1273_ sky130_fd_sc_hd__a211oi_1
X_6123_ clknet_leaf_55_clk _0531_ _0056_ VGND VGND VPWR VPWR reg_file_inst.registry\[6\]\[0\]
+ sky130_fd_sc_hd__dfrtp_1
XFILLER_112_363 VGND VGND VPWR VPWR sky130_fd_sc_hd__fill_1
XFILLER_105_27 VPWR VGND VPWR VGND sky130_ef_sc_hd__decap_12
XFILLER_98_586 VGND VGND VPWR VPWR sky130_fd_sc_hd__fill_2
X_3266_ reg_file_inst.registry\[0\]\[24\] _1076_ _1199_ _1206_ VGND VGND VPWR VPWR
+ _1207_ sky130_fd_sc_hd__o22a_4
XFILLER_85_225 VPWR VGND VPWR VGND sky130_ef_sc_hd__decap_12
XPHY_EDGE_ROW_0_Left_123 VGND VGND VPWR VPWR sky130_fd_sc_hd__decap_3
XPHY_EDGE_ROW_31_Right_31 VGND VGND VPWR VPWR sky130_fd_sc_hd__decap_3
X_6054_ net146 VGND VGND VPWR VPWR _0462_ sky130_fd_sc_hd__inv_2
X_5005_ _1346_ _2286_ _2124_ _1334_ VGND VGND VPWR VPWR _2848_ sky130_fd_sc_hd__o2bb2a_1
X_3197_ _1119_ net144 VGND VGND VPWR VPWR _1141_ sky130_fd_sc_hd__and2_4
XFILLER_121_15 VPWR VGND VPWR VGND sky130_ef_sc_hd__decap_12
XFILLER_93_291 VGND VGND VPWR VPWR sky130_fd_sc_hd__decap_4
XFILLER_54_645 VGND VGND VPWR VPWR sky130_fd_sc_hd__fill_1
XFILLER_39_697 VGND VGND VPWR VPWR sky130_fd_sc_hd__decap_6
XFILLER_81_464 VGND VGND VPWR VPWR sky130_fd_sc_hd__fill_1
XFILLER_53_166 VGND VGND VPWR VPWR sky130_fd_sc_hd__fill_2
XFILLER_53_133 VGND VGND VPWR VPWR sky130_fd_sc_hd__fill_2
X_5907_ net149 VGND VGND VPWR VPWR _0315_ sky130_fd_sc_hd__inv_2
XTAP_TAPCELL_ROW_62_1045 VGND VPWR sky130_fd_sc_hd__tapvpwrvgnd_1
XTAP_TAPCELL_ROW_62_1034 VGND VPWR sky130_fd_sc_hd__tapvpwrvgnd_1
XFILLER_22_531 VGND VGND VPWR VPWR sky130_fd_sc_hd__fill_1
XTAP_TAPCELL_ROW_24_559 VGND VPWR sky130_fd_sc_hd__tapvpwrvgnd_1
X_5838_ net146 VGND VGND VPWR VPWR _0246_ sky130_fd_sc_hd__inv_2
XPHY_EDGE_ROW_40_Right_40 VGND VGND VPWR VPWR sky130_fd_sc_hd__decap_3
XPHY_EDGE_ROW_46_Left_169 VGND VGND VPWR VPWR sky130_fd_sc_hd__decap_3
X_5769_ net148 VGND VGND VPWR VPWR _0177_ sky130_fd_sc_hd__inv_2
XFILLER_108_625 VPWR VGND VPWR VGND sky130_ef_sc_hd__decap_12
XFILLER_5_218 VGND VGND VPWR VPWR sky130_fd_sc_hd__decap_6
XFILLER_30_23 VGND VGND VPWR VPWR sky130_fd_sc_hd__decap_4
XFILLER_108_669 VPWR VGND VPWR VGND sky130_ef_sc_hd__decap_12
XFILLER_107_113 VPWR VGND VPWR VGND sky130_ef_sc_hd__decap_12
XFILLER_30_45 VGND VGND VPWR VPWR sky130_fd_sc_hd__fill_2
XFILLER_77_715 VGND VGND VPWR VPWR sky130_fd_sc_hd__fill_2
XTAP_TAPCELL_ROW_73_1174 VGND VPWR sky130_fd_sc_hd__tapvpwrvgnd_1
XPHY_EDGE_ROW_55_Left_178 VGND VGND VPWR VPWR sky130_fd_sc_hd__decap_3
XFILLER_49_439 VGND VGND VPWR VPWR sky130_fd_sc_hd__decap_8
XFILLER_39_76 VGND VGND VPWR VPWR sky130_fd_sc_hd__decap_8
XFILLER_45_601 VPWR VGND VPWR VGND sky130_ef_sc_hd__decap_12
XTAP_TAPCELL_ROW_43_802 VGND VPWR sky130_fd_sc_hd__tapvpwrvgnd_1
XFILLER_44_144 VGND VGND VPWR VPWR sky130_fd_sc_hd__decap_4
XFILLER_45_667 VGND VGND VPWR VPWR sky130_fd_sc_hd__decap_4
XFILLER_45_689 VGND VGND VPWR VPWR sky130_fd_sc_hd__fill_1
XFILLER_111_81 VPWR VGND VPWR VGND sky130_ef_sc_hd__decap_12
XPHY_EDGE_ROW_64_Left_187 VGND VGND VPWR VPWR sky130_fd_sc_hd__decap_3
XFILLER_25_391 VGND VGND VPWR VPWR sky130_fd_sc_hd__fill_1
XFILLER_113_105 VGND VGND VPWR VPWR sky130_fd_sc_hd__decap_6
XPHY_EDGE_ROW_73_Left_196 VGND VGND VPWR VPWR sky130_fd_sc_hd__decap_3
XFILLER_4_273 VGND VGND VPWR VPWR sky130_fd_sc_hd__fill_2
XFILLER_113_149 VPWR VGND VPWR VGND sky130_ef_sc_hd__decap_12
XFILLER_96_71 VPWR VGND VPWR VGND sky130_ef_sc_hd__decap_12
X_3120_ _0975_ _1063_ VGND VGND VPWR VPWR _1064_ sky130_fd_sc_hd__nand2_1
XFILLER_121_193 VPWR VGND VPWR VGND sky130_ef_sc_hd__decap_12
X_3051_ JMPOFF\[6\] net40 net141 VGND VGND VPWR VPWR _0995_ sky130_fd_sc_hd__and3_1
XFILLER_48_472 VGND VGND VPWR VPWR sky130_fd_sc_hd__decap_4
XFILLER_36_645 VPWR VGND VPWR VGND sky130_ef_sc_hd__decap_12
XFILLER_35_166 VGND VGND VPWR VPWR sky130_fd_sc_hd__fill_2
X_3953_ _1779_ _1803_ _1854_ _1868_ VGND VGND VPWR VPWR _1869_ sky130_fd_sc_hd__and4bb_1
X_3884_ MEMOFF\[2\] net93 _1113_ VGND VGND VPWR VPWR _1802_ sky130_fd_sc_hd__mux2_4
XTAP_TAPCELL_ROW_21_529 VGND VPWR sky130_fd_sc_hd__tapvpwrvgnd_1
X_5623_ net148 VGND VGND VPWR VPWR _0031_ sky130_fd_sc_hd__inv_2
X_5554_ _2974_ reg_file_inst.registry\[9\]\[9\] _3002_ VGND VGND VPWR VPWR _0512_
+ sky130_fd_sc_hd__mux2_1
XFILLER_105_617 VPWR VGND VPWR VGND sky130_ef_sc_hd__decap_12
X_5485_ JMPOFF\[20\] _2842_ _3000_ VGND VGND VPWR VPWR _0579_ sky130_fd_sc_hd__mux2_1
X_4505_ net134 _2241_ VGND VGND VPWR VPWR _2388_ sky130_fd_sc_hd__nand2_1
X_4436_ _1692_ _2203_ _2267_ _1840_ VGND VGND VPWR VPWR _2321_ sky130_fd_sc_hd__a22o_1
XFILLER_116_26 VGND VGND VPWR VPWR sky130_fd_sc_hd__fill_2
X_4367_ _1151_ _1736_ _2253_ VGND VGND VPWR VPWR _2255_ sky130_fd_sc_hd__o21a_2
X_3318_ reg_file_inst.registry\[1\]\[22\] _1116_ _1127_ VGND VGND VPWR VPWR _1257_
+ sky130_fd_sc_hd__and3_1
X_6106_ clknet_leaf_0_clk _0514_ _0039_ VGND VGND VPWR VPWR reg_file_inst.registry\[9\]\[11\]
+ sky130_fd_sc_hd__dfrtp_1
XFILLER_86_545 VGND VGND VPWR VPWR sky130_fd_sc_hd__decap_4
X_4298_ _1529_ _1552_ VGND VGND VPWR VPWR _2186_ sky130_fd_sc_hd__and2_1
X_3249_ reg_file_inst.registry\[7\]\[25\] _1133_ _1134_ reg_file_inst.registry\[4\]\[25\]
+ _1189_ VGND VGND VPWR VPWR _1191_ sky130_fd_sc_hd__a221o_1
XFILLER_86_589 VPWR VGND VPWR VGND sky130_ef_sc_hd__decap_12
X_6037_ net149 VGND VGND VPWR VPWR _0445_ sky130_fd_sc_hd__inv_2
XFILLER_92_18 VGND VGND VPWR VPWR sky130_fd_sc_hd__decap_8
XTAP_TAPCELL_ROW_29_629 VGND VPWR sky130_fd_sc_hd__tapvpwrvgnd_1
XFILLER_92_29 VGND VGND VPWR VPWR sky130_fd_sc_hd__decap_8
XFILLER_54_431 VPWR VGND VPWR VGND sky130_ef_sc_hd__decap_12
XTAP_TAPCELL_ROW_1_276 VGND VPWR sky130_fd_sc_hd__tapvpwrvgnd_1
XFILLER_26_166 VPWR VGND VPWR VGND sky130_ef_sc_hd__decap_12
XFILLER_27_689 VPWR VGND VPWR VGND sky130_ef_sc_hd__decap_12
XFILLER_25_78 VGND VGND VPWR VPWR sky130_fd_sc_hd__decap_8
XTAP_TAPCELL_ROW_120_1768 VGND VPWR sky130_fd_sc_hd__tapvpwrvgnd_1
XFILLER_22_361 VGND VGND VPWR VPWR sky130_fd_sc_hd__decap_3
XFILLER_41_169 VPWR VGND VPWR VGND sky130_ef_sc_hd__decap_12
XFILLER_50_681 VPWR VGND VPWR VGND sky130_ef_sc_hd__decap_12
XFILLER_10_545 VPWR VGND VPWR VGND sky130_ef_sc_hd__decap_12
XFILLER_6_527 VGND VGND VPWR VPWR sky130_fd_sc_hd__decap_4
XFILLER_108_433 VPWR VGND VPWR VGND sky130_ef_sc_hd__decap_12
XFILLER_10_589 VPWR VGND VPWR VGND sky130_ef_sc_hd__decap_12
XFILLER_108_477 VPWR VGND VPWR VGND sky130_ef_sc_hd__decap_12
XTAP_TAPCELL_ROW_75_1203 VGND VPWR sky130_fd_sc_hd__tapvpwrvgnd_1
XFILLER_1_210 VPWR VGND VPWR VGND sky130_ef_sc_hd__decap_12
XFILLER_111_609 VGND VGND VPWR VPWR sky130_fd_sc_hd__decap_6
XTAP_TAPCELL_ROW_9_376 VGND VPWR sky130_fd_sc_hd__tapvpwrvgnd_1
XFILLER_89_361 VGND VGND VPWR VPWR sky130_fd_sc_hd__fill_1
XFILLER_77_534 VGND VGND VPWR VPWR sky130_fd_sc_hd__fill_2
XFILLER_2_27 VGND VGND VPWR VPWR sky130_fd_sc_hd__fill_1
XFILLER_49_225 VPWR VGND VPWR VGND sky130_ef_sc_hd__decap_12
XFILLER_92_515 VPWR VGND VPWR VGND sky130_ef_sc_hd__decap_12
XFILLER_18_601 VPWR VGND VPWR VGND sky130_ef_sc_hd__decap_12
XFILLER_66_85 VGND VGND VPWR VPWR sky130_fd_sc_hd__decap_6
XFILLER_18_645 VPWR VGND VPWR VGND sky130_ef_sc_hd__decap_12
XTAP_TAPCELL_ROW_86_1343 VGND VPWR sky130_fd_sc_hd__tapvpwrvgnd_1
XTAP_TAPCELL_ROW_56_960 VGND VPWR sky130_fd_sc_hd__tapvpwrvgnd_1
XFILLER_45_475 VGND VGND VPWR VPWR sky130_fd_sc_hd__fill_1
XFILLER_45_497 VGND VGND VPWR VPWR sky130_fd_sc_hd__decap_6
XFILLER_32_136 VGND VGND VPWR VPWR sky130_fd_sc_hd__fill_1
XFILLER_33_659 VPWR VGND VPWR VGND sky130_ef_sc_hd__decap_12
XFILLER_20_309 VGND VGND VPWR VPWR sky130_fd_sc_hd__decap_6
XFILLER_119_709 VPWR VGND VPWR VGND sky130_ef_sc_hd__decap_12
XTAP_TAPCELL_ROW_97_1472 VGND VPWR sky130_fd_sc_hd__tapvpwrvgnd_1
XPHY_EDGE_ROW_81_Left_204 VGND VGND VPWR VPWR sky130_fd_sc_hd__decap_3
Xoutput106 net106 VGND VGND VPWR VPWR IC[13] sky130_fd_sc_hd__buf_1
XFILLER_99_125 VGND VGND VPWR VPWR sky130_fd_sc_hd__fill_1
Xoutput117 net117 VGND VGND VPWR VPWR IC[23] sky130_fd_sc_hd__buf_1
Xoutput128 net128 VGND VGND VPWR VPWR IC[8] sky130_fd_sc_hd__buf_1
X_5270_ reg_file_inst.registry\[14\]\[3\] _2478_ _2992_ VGND VGND VPWR VPWR _0786_
+ sky130_fd_sc_hd__mux2_1
XFILLER_114_469 VGND VGND VPWR VPWR sky130_fd_sc_hd__decap_6
X_4221_ _1878_ _1957_ net130 VGND VGND VPWR VPWR _2111_ sky130_fd_sc_hd__a21o_1
XFILLER_49_3 VGND VGND VPWR VPWR sky130_fd_sc_hd__decap_8
XFILLER_101_108 VGND VGND VPWR VPWR sky130_fd_sc_hd__decap_4
X_4152_ net130 _2052_ VGND VGND VPWR VPWR _2066_ sky130_fd_sc_hd__nor2_1
XFILLER_68_545 VPWR VGND VPWR VGND sky130_ef_sc_hd__decap_12
XFILLER_55_206 VGND VGND VPWR VPWR sky130_fd_sc_hd__decap_8
X_4083_ _1061_ net131 VGND VGND VPWR VPWR _1999_ sky130_fd_sc_hd__nand2_1
X_3103_ _1045_ _1046_ VGND VGND VPWR VPWR _1047_ sky130_fd_sc_hd__nand2_1
X_3034_ JMPOFF\[22\] _0967_ VGND VGND VPWR VPWR _0978_ sky130_fd_sc_hd__nand2_1
XFILLER_55_217 VGND VGND VPWR VPWR sky130_fd_sc_hd__decap_6
XPHY_EDGE_ROW_90_Left_213 VGND VGND VPWR VPWR sky130_fd_sc_hd__decap_3
XFILLER_83_559 VGND VGND VPWR VPWR sky130_fd_sc_hd__fill_1
XFILLER_91_581 VPWR VGND VPWR VGND sky130_ef_sc_hd__decap_12
XFILLER_23_103 VGND VGND VPWR VPWR sky130_fd_sc_hd__decap_8
XTAP_TAPCELL_ROW_106_1590 VGND VPWR sky130_fd_sc_hd__tapvpwrvgnd_1
X_4985_ _2598_ _2673_ VGND VGND VPWR VPWR _2830_ sky130_fd_sc_hd__or2_1
XFILLER_51_489 VPWR VGND VPWR VGND sky130_ef_sc_hd__decap_12
XFILLER_23_169 VPWR VGND VPWR VGND sky130_ef_sc_hd__decap_12
X_3936_ MEMOFF\[0\] net73 _1113_ VGND VGND VPWR VPWR _1852_ sky130_fd_sc_hd__mux2_2
XTAP_TAPCELL_ROW_34_687 VGND VPWR sky130_fd_sc_hd__tapvpwrvgnd_1
X_3867_ reg_file_inst.registry\[2\]\[2\] _1083_ _1098_ reg_file_inst.registry\[10\]\[2\]
+ VGND VGND VPWR VPWR _1786_ sky130_fd_sc_hd__a22o_1
X_5606_ net147 VGND VGND VPWR VPWR _0014_ sky130_fd_sc_hd__inv_2
X_3798_ _1710_ _1717_ _1718_ _1719_ VGND VGND VPWR VPWR _1720_ sky130_fd_sc_hd__or4_1
X_5537_ _2747_ reg_file_inst.registry\[9\]\[26\] _3002_ VGND VGND VPWR VPWR _0529_
+ sky130_fd_sc_hd__mux2_1
XFILLER_105_414 VGND VGND VPWR VPWR sky130_fd_sc_hd__decap_3
XFILLER_11_69 VPWR VGND VPWR VGND sky130_ef_sc_hd__decap_12
X_5468_ reg_file_inst.registry\[5\]\[8\] _2986_ _2999_ VGND VGND VPWR VPWR _0595_
+ sky130_fd_sc_hd__mux2_1
X_5399_ reg_file_inst.registry\[4\]\[19\] _2854_ _2997_ VGND VGND VPWR VPWR _0662_
+ sky130_fd_sc_hd__mux2_1
XTAP_TAPCELL_ROW_6_335 VGND VPWR sky130_fd_sc_hd__tapvpwrvgnd_1
X_4419_ _2179_ _2256_ _2293_ _2303_ VGND VGND VPWR VPWR net70 sky130_fd_sc_hd__or4_4
XTAP_TAPCELL_ROW_70_1144 VGND VPWR sky130_fd_sc_hd__tapvpwrvgnd_1
XTAP_TAPCELL_ROW_70_1133 VGND VPWR sky130_fd_sc_hd__tapvpwrvgnd_1
XFILLER_59_556 VGND VGND VPWR VPWR sky130_fd_sc_hd__decap_4
XFILLER_101_653 VPWR VGND VPWR VGND sky130_ef_sc_hd__decap_12
XFILLER_100_141 VGND VGND VPWR VPWR sky130_fd_sc_hd__decap_8
XFILLER_101_697 VPWR VGND VPWR VGND sky130_ef_sc_hd__decap_12
XFILLER_100_174 VGND VGND VPWR VPWR sky130_fd_sc_hd__decap_8
XFILLER_27_420 VPWR VGND VPWR VGND sky130_ef_sc_hd__decap_12
XTAP_TAPCELL_ROW_53_930 VGND VPWR sky130_fd_sc_hd__tapvpwrvgnd_1
XFILLER_42_445 VGND VGND VPWR VPWR sky130_fd_sc_hd__decap_8
XTAP_TAPCELL_ROW_81_1273 VGND VPWR sky130_fd_sc_hd__tapvpwrvgnd_1
XFILLER_52_54 VGND VGND VPWR VPWR sky130_fd_sc_hd__decap_6
Xinput19 DataMemoryRead[26] VGND VGND VPWR VPWR net19 sky130_fd_sc_hd__clkbuf_2
XFILLER_6_335 VGND VGND VPWR VPWR sky130_fd_sc_hd__decap_4
XFILLER_111_417 VPWR VGND VPWR VGND sky130_ef_sc_hd__decap_12
XFILLER_97_629 VPWR VGND VPWR VGND sky130_ef_sc_hd__decap_12
XFILLER_96_106 VPWR VGND VPWR VGND sky130_ef_sc_hd__decap_12
XFILLER_96_139 VGND VGND VPWR VPWR sky130_fd_sc_hd__fill_1
XFILLER_28_8 VPWR VGND VPWR VGND sky130_ef_sc_hd__decap_12
XFILLER_37_239 VGND VGND VPWR VPWR sky130_fd_sc_hd__fill_2
XFILLER_60_253 VGND VGND VPWR VPWR sky130_fd_sc_hd__decap_3
XFILLER_21_607 VGND VGND VPWR VPWR sky130_fd_sc_hd__decap_8
XFILLER_21_629 VGND VGND VPWR VPWR sky130_fd_sc_hd__decap_6
XTAP_TAPCELL_ROW_99_1501 VGND VPWR sky130_fd_sc_hd__tapvpwrvgnd_1
X_4770_ _1433_ _2628_ VGND VGND VPWR VPWR _2629_ sky130_fd_sc_hd__xnor2_1
XFILLER_20_139 VGND VGND VPWR VPWR sky130_fd_sc_hd__fill_1
XFILLER_119_517 VPWR VGND VPWR VGND sky130_ef_sc_hd__decap_12
X_3721_ reg_file_inst.registry\[14\]\[7\] _1081_ _1094_ reg_file_inst.registry\[6\]\[7\]
+ _1642_ VGND VGND VPWR VPWR _1645_ sky130_fd_sc_hd__a221o_1
XFILLER_9_151 VGND VGND VPWR VPWR sky130_fd_sc_hd__decap_6
XFILLER_13_180 VGND VGND VPWR VPWR sky130_fd_sc_hd__decap_3
XTAP_TAPCELL_ROW_31_646 VGND VPWR sky130_fd_sc_hd__tapvpwrvgnd_1
XTAP_TAPCELL_ROW_31_657 VGND VPWR sky130_fd_sc_hd__tapvpwrvgnd_1
X_3652_ reg_file_inst.registry\[2\]\[9\] _1083_ _1086_ reg_file_inst.registry\[7\]\[9\]
+ VGND VGND VPWR VPWR _1578_ sky130_fd_sc_hd__a22o_1
X_6440_ clknet_leaf_57_clk _0848_ _0373_ VGND VGND VPWR VPWR reg_file_inst.registry\[0\]\[1\]
+ sky130_fd_sc_hd__dfrtp_2
X_6371_ clknet_leaf_32_clk _0779_ _0304_ VGND VGND VPWR VPWR reg_file_inst.registry\[2\]\[24\]
+ sky130_fd_sc_hd__dfrtp_1
X_3583_ JMPOFF\[14\] _1130_ _1134_ reg_file_inst.registry\[4\]\[14\] _1117_ VGND VGND
+ VPWR VPWR _1512_ sky130_fd_sc_hd__a221o_1
X_5322_ _2974_ reg_file_inst.registry\[8\]\[9\] _2994_ VGND VGND VPWR VPWR _0736_
+ sky130_fd_sc_hd__mux2_1
XFILLER_114_233 VPWR VGND VPWR VGND sky130_ef_sc_hd__decap_12
XFILLER_5_390 VGND VGND VPWR VPWR sky130_fd_sc_hd__fill_2
XFILLER_114_277 VPWR VGND VPWR VGND sky130_ef_sc_hd__decap_12
XFILLER_102_417 VGND VGND VPWR VPWR sky130_fd_sc_hd__decap_3
X_5253_ reg_file_inst.registry\[14\]\[20\] _2842_ _2992_ VGND VGND VPWR VPWR _0803_
+ sky130_fd_sc_hd__mux2_1
X_5184_ _2829_ reg_file_inst.registry\[0\]\[21\] _2988_ VGND VGND VPWR VPWR _0868_
+ sky130_fd_sc_hd__mux2_1
X_4204_ _2100_ net128 net130 VGND VGND VPWR VPWR _0930_ sky130_fd_sc_hd__mux2_1
X_4135_ _2036_ _2046_ _2047_ _2050_ VGND VGND VPWR VPWR _2051_ sky130_fd_sc_hd__a31o_1
XTAP_TAPCELL_ROW_3_305 VGND VPWR sky130_fd_sc_hd__tapvpwrvgnd_1
XFILLER_3_81 VPWR VGND VPWR VGND sky130_ef_sc_hd__decap_12
XFILLER_113_27 VPWR VGND VPWR VGND sky130_ef_sc_hd__decap_12
XFILLER_95_194 VPWR VGND VPWR VGND sky130_ef_sc_hd__decap_12
X_4066_ _1025_ _1029_ VGND VGND VPWR VPWR _1982_ sky130_fd_sc_hd__and2_1
XTAP_TAPCELL_ROW_39_746 VGND VPWR sky130_fd_sc_hd__tapvpwrvgnd_1
XTAP_TAPCELL_ROW_39_757 VGND VPWR sky130_fd_sc_hd__tapvpwrvgnd_1
X_3017_ net31 net30 net32 VGND VGND VPWR VPWR _0962_ sky130_fd_sc_hd__nor3_1
XFILLER_36_283 VGND VGND VPWR VPWR sky130_fd_sc_hd__fill_2
XFILLER_11_117 VGND VGND VPWR VPWR sky130_fd_sc_hd__fill_1
X_4968_ _2176_ _2807_ _2816_ _2721_ _2815_ VGND VGND VPWR VPWR net59 sky130_fd_sc_hd__a221o_1
X_4899_ _1195_ _2283_ _2284_ _1196_ _2753_ VGND VGND VPWR VPWR _2754_ sky130_fd_sc_hd__a221o_1
X_3919_ reg_file_inst.registry\[2\]\[0\] _1083_ _1096_ reg_file_inst.registry\[11\]\[0\]
+ VGND VGND VPWR VPWR _1836_ sky130_fd_sc_hd__a22o_1
XFILLER_20_684 VGND VGND VPWR VPWR sky130_fd_sc_hd__decap_8
XFILLER_106_701 VPWR VGND VPWR VGND sky130_ef_sc_hd__decap_12
XTAP_TAPCELL_ROW_59_1006 VGND VPWR sky130_fd_sc_hd__tapvpwrvgnd_1
XFILLER_3_327 VGND VGND VPWR VPWR sky130_fd_sc_hd__decap_8
XFILLER_79_629 VGND VGND VPWR VPWR sky130_fd_sc_hd__decap_4
XFILLER_78_139 VGND VGND VPWR VPWR sky130_fd_sc_hd__fill_1
XFILLER_87_673 VPWR VGND VPWR VGND sky130_ef_sc_hd__decap_12
XFILLER_101_461 VPWR VGND VPWR VGND sky130_ef_sc_hd__decap_12
XFILLER_86_183 VPWR VGND VPWR VGND sky130_ef_sc_hd__decap_12
XFILLER_47_537 VGND VGND VPWR VPWR sky130_fd_sc_hd__decap_3
XFILLER_47_98 VPWR VGND VPWR VGND sky130_ef_sc_hd__decap_12
XTAP_TAPCELL_ROW_83_1302 VGND VPWR sky130_fd_sc_hd__tapvpwrvgnd_1
XFILLER_74_378 VGND VGND VPWR VPWR sky130_fd_sc_hd__decap_8
XFILLER_103_93 VPWR VGND VPWR VGND sky130_ef_sc_hd__decap_12
XFILLER_63_42 VPWR VGND VPWR VGND sky130_ef_sc_hd__decap_12
XFILLER_15_445 VGND VGND VPWR VPWR sky130_fd_sc_hd__decap_3
XPHY_EDGE_ROW_69_Right_69 VGND VGND VPWR VPWR sky130_fd_sc_hd__decap_3
XFILLER_30_404 VGND VGND VPWR VPWR sky130_fd_sc_hd__decap_6
XFILLER_42_286 VGND VGND VPWR VPWR sky130_fd_sc_hd__fill_2
XFILLER_11_673 VPWR VGND VPWR VGND sky130_ef_sc_hd__decap_12
XFILLER_109_561 VPWR VGND VPWR VGND sky130_ef_sc_hd__decap_12
XTAP_TAPCELL_ROW_94_1442 VGND VPWR sky130_fd_sc_hd__tapvpwrvgnd_1
XPHY_EDGE_ROW_78_Right_78 VGND VGND VPWR VPWR sky130_fd_sc_hd__decap_3
XFILLER_111_225 VPWR VGND VPWR VGND sky130_ef_sc_hd__decap_12
XFILLER_88_83 VGND VGND VPWR VPWR sky130_fd_sc_hd__fill_1
XFILLER_69_139 VGND VGND VPWR VPWR sky130_fd_sc_hd__decap_4
XFILLER_2_371 VGND VGND VPWR VPWR sky130_fd_sc_hd__fill_1
XFILLER_38_526 VGND VGND VPWR VPWR sky130_fd_sc_hd__decap_6
XFILLER_93_665 VGND VGND VPWR VPWR sky130_fd_sc_hd__decap_6
XFILLER_80_315 VGND VGND VPWR VPWR sky130_fd_sc_hd__fill_1
X_5940_ net147 VGND VGND VPWR VPWR _0348_ sky130_fd_sc_hd__inv_2
XTAP_TAPCELL_ROW_36_716 VGND VPWR sky130_fd_sc_hd__tapvpwrvgnd_1
XPHY_EDGE_ROW_87_Right_87 VGND VGND VPWR VPWR sky130_fd_sc_hd__decap_3
X_5871_ net44 VGND VGND VPWR VPWR _0279_ sky130_fd_sc_hd__inv_2
XTAP_TAPCELL_ROW_16_462 VGND VPWR sky130_fd_sc_hd__tapvpwrvgnd_1
X_4822_ _1152_ _2680_ VGND VGND VPWR VPWR _2681_ sky130_fd_sc_hd__xnor2_1
XFILLER_21_437 VGND VGND VPWR VPWR sky130_fd_sc_hd__fill_2
XFILLER_33_275 VGND VGND VPWR VPWR sky130_fd_sc_hd__decap_4
X_4753_ _1594_ _2611_ VGND VGND VPWR VPWR _2612_ sky130_fd_sc_hd__nor2_1
X_3704_ _1433_ _1446_ _1470_ _1469_ _1457_ VGND VGND VPWR VPWR _1628_ sky130_fd_sc_hd__o32a_1
X_6423_ clknet_leaf_42_clk _0831_ _0356_ VGND VGND VPWR VPWR reg_file_inst.registry\[1\]\[20\]
+ sky130_fd_sc_hd__dfrtp_1
X_4684_ _2478_ reg_file_inst.registry\[11\]\[11\] _2118_ VGND VGND VPWR VPWR _0910_
+ sky130_fd_sc_hd__mux2_1
XPHY_EDGE_ROW_96_Right_96 VGND VGND VPWR VPWR sky130_fd_sc_hd__decap_3
X_3635_ reg_file_inst.registry\[14\]\[10\] _1138_ _1553_ _1556_ _1557_ VGND VGND VPWR
+ VPWR _1562_ sky130_fd_sc_hd__a2111o_1
X_6354_ clknet_leaf_41_clk _0762_ _0287_ VGND VGND VPWR VPWR reg_file_inst.registry\[2\]\[7\]
+ sky130_fd_sc_hd__dfrtp_1
X_3566_ reg_file_inst.registry\[3\]\[14\] _1091_ _1097_ reg_file_inst.registry\[5\]\[14\]
+ VGND VGND VPWR VPWR _1495_ sky130_fd_sc_hd__a22o_1
XFILLER_115_553 VGND VGND VPWR VPWR sky130_fd_sc_hd__decap_6
X_5305_ _2747_ reg_file_inst.registry\[8\]\[26\] _2994_ VGND VGND VPWR VPWR _0753_
+ sky130_fd_sc_hd__mux2_1
X_6285_ clknet_leaf_34_clk _0693_ _0218_ VGND VGND VPWR VPWR MEMOFF\[22\] sky130_fd_sc_hd__dfrtp_1
X_3497_ _1425_ _1426_ _1427_ _1428_ VGND VGND VPWR VPWR _1429_ sky130_fd_sc_hd__or4_1
XFILLER_115_597 VPWR VGND VPWR VGND sky130_ef_sc_hd__decap_12
X_5236_ _2311_ reg_file_inst.registry\[1\]\[7\] _2990_ VGND VGND VPWR VPWR _0818_
+ sky130_fd_sc_hd__mux2_1
XFILLER_69_673 VPWR VGND VPWR VGND sky130_ef_sc_hd__decap_12
XFILLER_68_172 VGND VGND VPWR VPWR sky130_fd_sc_hd__fill_2
X_5167_ reg_file_inst.registry\[7\]\[8\] _2986_ _2553_ VGND VGND VPWR VPWR _0883_
+ sky130_fd_sc_hd__mux2_1
XFILLER_68_183 VPWR VGND VPWR VGND sky130_ef_sc_hd__decap_12
X_4118_ _2032_ _2033_ VGND VGND VPWR VPWR _2034_ sky130_fd_sc_hd__or2_1
X_5098_ _1434_ _1446_ _2284_ _2924_ _2926_ VGND VGND VPWR VPWR _2927_ sky130_fd_sc_hd__a311o_1
XFILLER_29_559 VGND VGND VPWR VPWR sky130_fd_sc_hd__fill_1
XFILLER_83_175 VGND VGND VPWR VPWR sky130_fd_sc_hd__fill_1
X_4049_ _1951_ _1964_ VGND VGND VPWR VPWR _1965_ sky130_fd_sc_hd__or2_1
XFILLER_44_507 VGND VGND VPWR VPWR sky130_fd_sc_hd__decap_8
XFILLER_83_197 VPWR VGND VPWR VGND sky130_ef_sc_hd__decap_12
XFILLER_71_337 VPWR VGND VPWR VGND sky130_ef_sc_hd__decap_12
XFILLER_17_57 VGND VGND VPWR VPWR sky130_fd_sc_hd__decap_4
XFILLER_24_253 VGND VGND VPWR VPWR sky130_fd_sc_hd__fill_2
XTAP_TAPCELL_ROW_65_1076 VGND VPWR sky130_fd_sc_hd__tapvpwrvgnd_1
XFILLER_33_89 VGND VGND VPWR VPWR sky130_fd_sc_hd__decap_3
XTAP_TAPCELL_ROW_117_1729 VGND VPWR sky130_fd_sc_hd__tapvpwrvgnd_1
XFILLER_4_625 VPWR VGND VPWR VGND sky130_ef_sc_hd__decap_12
XFILLER_106_531 VGND VGND VPWR VPWR sky130_fd_sc_hd__fill_1
XFILLER_3_113 VPWR VGND VPWR VGND sky130_ef_sc_hd__decap_12
XFILLER_4_669 VPWR VGND VPWR VGND sky130_ef_sc_hd__decap_12
XFILLER_3_146 VPWR VGND VPWR VGND sky130_ef_sc_hd__decap_12
XFILLER_94_418 VGND VGND VPWR VPWR sky130_fd_sc_hd__fill_2
XFILLER_87_481 VGND VGND VPWR VPWR sky130_fd_sc_hd__decap_3
XFILLER_75_610 VGND VGND VPWR VPWR sky130_fd_sc_hd__decap_6
XFILLER_58_97 VGND VGND VPWR VPWR sky130_fd_sc_hd__decap_4
XFILLER_47_301 VPWR VGND VPWR VGND sky130_ef_sc_hd__decap_12
XFILLER_75_665 VGND VGND VPWR VPWR sky130_fd_sc_hd__decap_6
XFILLER_90_613 VPWR VGND VPWR VGND sky130_ef_sc_hd__decap_12
XFILLER_74_153 VGND VGND VPWR VPWR sky130_fd_sc_hd__decap_6
XFILLER_74_41 VPWR VGND VPWR VGND sky130_ef_sc_hd__decap_12
XFILLER_90_657 VPWR VGND VPWR VGND sky130_ef_sc_hd__decap_12
XFILLER_74_197 VGND VGND VPWR VPWR sky130_fd_sc_hd__decap_4
XFILLER_62_348 VGND VGND VPWR VPWR sky130_fd_sc_hd__fill_2
XFILLER_16_721 VGND VGND VPWR VPWR sky130_fd_sc_hd__decap_4
XFILLER_70_370 VGND VGND VPWR VPWR sky130_fd_sc_hd__decap_4
XTAP_TAPCELL_ROW_13_421 VGND VPWR sky130_fd_sc_hd__tapvpwrvgnd_1
XTAP_TAPCELL_ROW_13_432 VGND VPWR sky130_fd_sc_hd__tapvpwrvgnd_1
XTAP_TAPCELL_ROW_41_774 VGND VPWR sky130_fd_sc_hd__tapvpwrvgnd_1
XFILLER_7_452 VGND VGND VPWR VPWR sky130_fd_sc_hd__decap_6
XFILLER_109_391 VGND VGND VPWR VPWR sky130_fd_sc_hd__fill_1
Xmax_cap149 net44 VGND VGND VPWR VPWR net149 sky130_fd_sc_hd__clkbuf_16
X_3420_ reg_file_inst.registry\[7\]\[18\] _1086_ _1089_ reg_file_inst.registry\[9\]\[18\]
+ VGND VGND VPWR VPWR _1355_ sky130_fd_sc_hd__a22o_1
Xmax_cap138 _1076_ VGND VGND VPWR VPWR net138 sky130_fd_sc_hd__buf_12
XFILLER_112_501 VPWR VGND VPWR VGND sky130_ef_sc_hd__decap_12
XFILLER_98_713 VGND VGND VPWR VPWR sky130_fd_sc_hd__decap_6
X_3351_ reg_file_inst.registry\[15\]\[21\] _1122_ _1142_ reg_file_inst.registry\[1\]\[21\]
+ _1117_ VGND VGND VPWR VPWR _1289_ sky130_fd_sc_hd__a221o_1
XFILLER_31_3 VGND VGND VPWR VPWR sky130_fd_sc_hd__decap_8
XFILLER_112_545 VPWR VGND VPWR VGND sky130_ef_sc_hd__decap_12
XFILLER_97_245 VGND VGND VPWR VPWR sky130_fd_sc_hd__decap_8
X_3282_ reg_file_inst.registry\[3\]\[23\] _1091_ _1097_ reg_file_inst.registry\[5\]\[23\]
+ VGND VGND VPWR VPWR _1222_ sky130_fd_sc_hd__a22o_1
X_6070_ clknet_leaf_59_clk _0478_ _0003_ VGND VGND VPWR VPWR reg_file_inst.registry\[15\]\[3\]
+ sky130_fd_sc_hd__dfrtp_1
XFILLER_112_589 VPWR VGND VPWR VGND sky130_ef_sc_hd__decap_12
X_5021_ _2296_ _2498_ _2856_ _2861_ VGND VGND VPWR VPWR _2862_ sky130_fd_sc_hd__a211o_1
XFILLER_38_345 VPWR VGND VPWR VGND sky130_ef_sc_hd__decap_12
XFILLER_66_698 VGND VGND VPWR VPWR sky130_fd_sc_hd__fill_2
XTAP_TAPCELL_ROW_49_874 VGND VPWR sky130_fd_sc_hd__tapvpwrvgnd_1
XFILLER_0_71 VGND VGND VPWR VPWR sky130_fd_sc_hd__fill_2
X_5923_ net146 VGND VGND VPWR VPWR _0331_ sky130_fd_sc_hd__inv_2
X_5854_ net148 VGND VGND VPWR VPWR _0262_ sky130_fd_sc_hd__inv_2
XFILLER_21_201 VPWR VGND VPWR VGND sky130_ef_sc_hd__decap_12
X_4805_ _1404_ _2559_ VGND VGND VPWR VPWR _2664_ sky130_fd_sc_hd__xnor2_1
XFILLER_119_111 VGND VGND VPWR VPWR sky130_fd_sc_hd__fill_1
X_5785_ net44 VGND VGND VPWR VPWR _0193_ sky130_fd_sc_hd__inv_2
XFILLER_21_278 VGND VGND VPWR VPWR sky130_fd_sc_hd__fill_2
XFILLER_119_15 VPWR VGND VPWR VGND sky130_ef_sc_hd__decap_12
X_4736_ _2585_ _2589_ _2593_ _2594_ _2579_ VGND VGND VPWR VPWR _2595_ sky130_fd_sc_hd__o311a_1
XFILLER_107_317 VPWR VGND VPWR VGND sky130_ef_sc_hd__decap_12
X_4667_ _2420_ _2423_ _1790_ VGND VGND VPWR VPWR _2540_ sky130_fd_sc_hd__mux2_1
X_3618_ MEMOFF\[10\] _1079_ _1096_ reg_file_inst.registry\[11\]\[10\] _1544_ VGND
+ VGND VPWR VPWR _1545_ sky130_fd_sc_hd__a221o_1
X_6406_ clknet_leaf_6_clk _0814_ _0339_ VGND VGND VPWR VPWR reg_file_inst.registry\[1\]\[3\]
+ sky130_fd_sc_hd__dfrtp_1
XFILLER_122_309 VPWR VGND VPWR VGND sky130_ef_sc_hd__decap_12
XFILLER_115_361 VPWR VGND VPWR VGND sky130_ef_sc_hd__decap_12
X_6337_ clknet_leaf_14_clk _0745_ _0270_ VGND VGND VPWR VPWR reg_file_inst.registry\[8\]\[18\]
+ sky130_fd_sc_hd__dfrtp_1
X_4598_ _2473_ _2475_ _2476_ VGND VGND VPWR VPWR net66 sky130_fd_sc_hd__or3_4
XFILLER_1_617 VPWR VGND VPWR VGND sky130_ef_sc_hd__decap_12
XTAP_TAPCELL_ROW_112_1659 VGND VPWR sky130_fd_sc_hd__tapvpwrvgnd_1
X_3549_ _1474_ _1476_ _1478_ VGND VGND VPWR VPWR _1479_ sky130_fd_sc_hd__or3_1
XFILLER_0_116 VGND VGND VPWR VPWR sky130_fd_sc_hd__decap_8
X_6268_ clknet_leaf_57_clk _0676_ _0201_ VGND VGND VPWR VPWR MEMOFF\[5\] sky130_fd_sc_hd__dfrtp_2
X_5219_ _2787_ reg_file_inst.registry\[1\]\[24\] _2990_ VGND VGND VPWR VPWR _0835_
+ sky130_fd_sc_hd__mux2_1
X_6199_ clknet_leaf_43_clk _0607_ _0132_ VGND VGND VPWR VPWR reg_file_inst.registry\[5\]\[20\]
+ sky130_fd_sc_hd__dfrtp_1
XFILLER_28_45 VGND VGND VPWR VPWR sky130_fd_sc_hd__fill_1
XFILLER_29_334 VGND VGND VPWR VPWR sky130_fd_sc_hd__fill_2
XTAP_TAPCELL_ROW_67_1105 VGND VPWR sky130_fd_sc_hd__tapvpwrvgnd_1
XFILLER_57_665 VGND VGND VPWR VPWR sky130_fd_sc_hd__decap_6
XFILLER_17_518 VPWR VGND VPWR VGND sky130_ef_sc_hd__decap_12
XFILLER_72_657 VPWR VGND VPWR VGND sky130_ef_sc_hd__decap_12
XFILLER_72_635 VGND VGND VPWR VPWR sky130_fd_sc_hd__fill_2
XFILLER_56_197 VPWR VGND VPWR VGND sky130_ef_sc_hd__decap_12
XFILLER_29_389 VGND VGND VPWR VPWR sky130_fd_sc_hd__decap_3
XFILLER_71_167 VGND VGND VPWR VPWR sky130_fd_sc_hd__fill_1
XFILLER_71_189 VGND VGND VPWR VPWR sky130_fd_sc_hd__fill_2
XFILLER_40_510 VGND VGND VPWR VPWR sky130_fd_sc_hd__fill_2
XFILLER_40_587 VGND VGND VPWR VPWR sky130_fd_sc_hd__fill_1
XTAP_TAPCELL_ROW_78_1245 VGND VPWR sky130_fd_sc_hd__tapvpwrvgnd_1
XTAP_TAPCELL_ROW_78_1234 VGND VPWR sky130_fd_sc_hd__tapvpwrvgnd_1
XFILLER_60_76 VGND VGND VPWR VPWR sky130_fd_sc_hd__decap_8
XFILLER_5_27 VPWR VGND VPWR VGND sky130_ef_sc_hd__decap_12
XFILLER_109_81 VPWR VGND VPWR VGND sky130_ef_sc_hd__decap_12
XTAP_TAPCELL_ROW_91_1401 VGND VPWR sky130_fd_sc_hd__tapvpwrvgnd_1
XFILLER_4_477 VGND VGND VPWR VPWR sky130_fd_sc_hd__decap_6
XFILLER_79_223 VGND VGND VPWR VPWR sky130_fd_sc_hd__fill_1
XFILLER_79_201 VGND VGND VPWR VPWR sky130_fd_sc_hd__fill_1
XFILLER_0_661 VGND VGND VPWR VPWR sky130_fd_sc_hd__decap_8
XFILLER_85_51 VGND VGND VPWR VPWR sky130_fd_sc_hd__decap_4
XTAP_TAPCELL_ROW_89_1374 VGND VPWR sky130_fd_sc_hd__tapvpwrvgnd_1
XFILLER_75_473 VPWR VGND VPWR VGND sky130_ef_sc_hd__decap_12
XFILLER_35_315 VPWR VGND VPWR VGND sky130_ef_sc_hd__decap_12
XFILLER_35_337 VPWR VGND VPWR VGND sky130_ef_sc_hd__decap_12
XTAP_TAPCELL_ROW_46_833 VGND VPWR sky130_fd_sc_hd__tapvpwrvgnd_1
XFILLER_90_454 VGND VGND VPWR VPWR sky130_fd_sc_hd__fill_1
XFILLER_62_134 VGND VGND VPWR VPWR sky130_fd_sc_hd__decap_6
XTAP_TAPCELL_ROW_46_844 VGND VPWR sky130_fd_sc_hd__tapvpwrvgnd_1
XFILLER_50_307 VGND VGND VPWR VPWR sky130_fd_sc_hd__fill_1
XTAP_TAPCELL_ROW_26_590 VGND VPWR sky130_fd_sc_hd__tapvpwrvgnd_1
X_5570_ reg_file_inst.registry\[15\]\[22\] _2817_ _3003_ VGND VGND VPWR VPWR _0497_
+ sky130_fd_sc_hd__mux2_1
XFILLER_117_615 VGND VGND VPWR VPWR sky130_fd_sc_hd__fill_1
X_4521_ _2403_ VGND VGND VPWR VPWR _2404_ sky130_fd_sc_hd__inv_2
X_4452_ _2205_ _2231_ _1840_ VGND VGND VPWR VPWR _2337_ sky130_fd_sc_hd__mux2_1
XFILLER_104_309 VPWR VGND VPWR VGND sky130_ef_sc_hd__decap_12
X_3403_ reg_file_inst.registry\[15\]\[19\] _1122_ _1137_ reg_file_inst.registry\[2\]\[19\]
+ _1117_ VGND VGND VPWR VPWR _1339_ sky130_fd_sc_hd__a221o_1
X_4383_ _2224_ _2270_ _1840_ VGND VGND VPWR VPWR _2271_ sky130_fd_sc_hd__mux2_1
X_6122_ clknet_leaf_18_clk _0530_ _0055_ VGND VGND VPWR VPWR reg_file_inst.registry\[9\]\[27\]
+ sky130_fd_sc_hd__dfrtp_1
X_3334_ MEMOFF\[21\] _1079_ _1092_ reg_file_inst.registry\[4\]\[21\] VGND VGND VPWR
+ VPWR _1272_ sky130_fd_sc_hd__a22o_1
XFILLER_105_39 VPWR VGND VPWR VGND sky130_ef_sc_hd__decap_12
X_3265_ _1200_ _1202_ _1204_ _1205_ VGND VGND VPWR VPWR _1206_ sky130_fd_sc_hd__or4_1
XFILLER_58_418 VGND VGND VPWR VPWR sky130_fd_sc_hd__fill_2
X_6053_ net146 VGND VGND VPWR VPWR _0461_ sky130_fd_sc_hd__inv_2
XFILLER_85_237 VGND VGND VPWR VPWR sky130_fd_sc_hd__decap_6
X_5004_ _2129_ _2474_ VGND VGND VPWR VPWR _2847_ sky130_fd_sc_hd__or2_1
X_3196_ net145 _1119_ VGND VGND VPWR VPWR _1140_ sky130_fd_sc_hd__and2_4
XFILLER_93_281 VGND VGND VPWR VPWR sky130_fd_sc_hd__decap_3
XFILLER_38_186 VGND VGND VPWR VPWR sky130_fd_sc_hd__decap_8
XFILLER_38_197 VGND VGND VPWR VPWR sky130_fd_sc_hd__decap_8
XFILLER_121_27 VPWR VGND VPWR VGND sky130_ef_sc_hd__decap_12
XFILLER_81_443 VGND VGND VPWR VPWR sky130_fd_sc_hd__decap_4
X_5906_ net148 VGND VGND VPWR VPWR _0314_ sky130_fd_sc_hd__inv_2
XTAP_TAPCELL_ROW_62_1035 VGND VPWR sky130_fd_sc_hd__tapvpwrvgnd_1
X_5837_ net149 VGND VGND VPWR VPWR _0245_ sky130_fd_sc_hd__inv_2
XFILLER_22_587 VGND VGND VPWR VPWR sky130_fd_sc_hd__fill_1
XPHY_EDGE_ROW_101_Left_224 VGND VGND VPWR VPWR sky130_fd_sc_hd__decap_3
X_5768_ net146 VGND VGND VPWR VPWR _0176_ sky130_fd_sc_hd__inv_2
X_4719_ _1231_ _2577_ VGND VGND VPWR VPWR _2578_ sky130_fd_sc_hd__xnor2_1
XFILLER_108_637 VGND VGND VPWR VPWR sky130_fd_sc_hd__decap_6
XFILLER_107_125 VPWR VGND VPWR VGND sky130_ef_sc_hd__decap_12
X_5699_ net146 VGND VGND VPWR VPWR _0107_ sky130_fd_sc_hd__inv_2
XFILLER_107_169 VPWR VGND VPWR VGND sky130_ef_sc_hd__decap_12
XFILLER_116_681 VPWR VGND VPWR VGND sky130_ef_sc_hd__decap_12
XFILLER_89_510 VPWR VGND VPWR VGND sky130_ef_sc_hd__decap_12
XTAP_TAPCELL_ROW_73_1175 VGND VPWR sky130_fd_sc_hd__tapvpwrvgnd_1
XFILLER_1_436 VGND VGND VPWR VPWR sky130_fd_sc_hd__fill_1
XPHY_EDGE_ROW_110_Left_233 VGND VGND VPWR VPWR sky130_fd_sc_hd__decap_3
XFILLER_76_259 VGND VGND VPWR VPWR sky130_fd_sc_hd__decap_8
XFILLER_76_226 VGND VGND VPWR VPWR sky130_fd_sc_hd__decap_4
XFILLER_91_218 VGND VGND VPWR VPWR sky130_fd_sc_hd__decap_6
XFILLER_57_462 VPWR VGND VPWR VGND sky130_ef_sc_hd__decap_12
XFILLER_45_613 VGND VGND VPWR VPWR sky130_fd_sc_hd__decap_3
XFILLER_72_421 VPWR VGND VPWR VGND sky130_ef_sc_hd__decap_12
XFILLER_55_43 VGND VGND VPWR VPWR sky130_fd_sc_hd__fill_1
XFILLER_17_337 VPWR VGND VPWR VGND sky130_ef_sc_hd__decap_12
XFILLER_29_175 VGND VGND VPWR VPWR sky130_fd_sc_hd__fill_1
XFILLER_72_443 VPWR VGND VPWR VGND sky130_ef_sc_hd__decap_12
XPHY_EDGE_ROW_105_Right_105 VGND VGND VPWR VPWR sky130_fd_sc_hd__decap_3
XTAP_TAPCELL_ROW_43_803 VGND VPWR sky130_fd_sc_hd__tapvpwrvgnd_1
XFILLER_111_93 VPWR VGND VPWR VGND sky130_ef_sc_hd__decap_12
XFILLER_71_42 VPWR VGND VPWR VGND sky130_ef_sc_hd__decap_12
XFILLER_4_241 VGND VGND VPWR VPWR sky130_fd_sc_hd__decap_3
XFILLER_68_705 VGND VGND VPWR VPWR sky130_fd_sc_hd__fill_1
XFILLER_122_673 VPWR VGND VPWR VGND sky130_ef_sc_hd__decap_12
XFILLER_121_161 VGND VGND VPWR VPWR sky130_fd_sc_hd__decap_6
XFILLER_95_502 VGND VGND VPWR VPWR sky130_fd_sc_hd__fill_2
XFILLER_96_94 VPWR VGND VPWR VGND sky130_ef_sc_hd__decap_12
XFILLER_96_83 VGND VGND VPWR VPWR sky130_fd_sc_hd__fill_1
XFILLER_0_480 VGND VGND VPWR VPWR sky130_fd_sc_hd__decap_6
X_3050_ JMPOFF\[7\] _0967_ VGND VGND VPWR VPWR _0994_ sky130_fd_sc_hd__nand2_1
XFILLER_36_657 VGND VGND VPWR VPWR sky130_fd_sc_hd__decap_8
XFILLER_36_679 VGND VGND VPWR VPWR sky130_fd_sc_hd__fill_2
XFILLER_90_251 VGND VGND VPWR VPWR sky130_fd_sc_hd__fill_1
XFILLER_51_649 VPWR VGND VPWR VGND sky130_ef_sc_hd__decap_12
X_3952_ _1840_ _1852_ VGND VGND VPWR VPWR _1868_ sky130_fd_sc_hd__xnor2_1
XFILLER_44_690 VGND VGND VPWR VPWR sky130_fd_sc_hd__decap_8
X_3883_ _1795_ _1797_ _1801_ _1118_ reg_file_inst.registry\[0\]\[2\] VGND VGND VPWR
+ VPWR net93 sky130_fd_sc_hd__o32a_1
X_5622_ net147 VGND VGND VPWR VPWR _0030_ sky130_fd_sc_hd__inv_2
X_5553_ _2960_ reg_file_inst.registry\[9\]\[10\] _3002_ VGND VGND VPWR VPWR _0513_
+ sky130_fd_sc_hd__mux2_1
X_4504_ net137 _2384_ _2386_ _1709_ VGND VGND VPWR VPWR _2387_ sky130_fd_sc_hd__o211a_1
X_5484_ JMPOFF\[21\] _2829_ _3000_ VGND VGND VPWR VPWR _0580_ sky130_fd_sc_hd__mux2_1
XFILLER_105_629 VPWR VGND VPWR VGND sky130_ef_sc_hd__decap_12
XFILLER_104_117 VGND VGND VPWR VPWR sky130_fd_sc_hd__decap_3
XFILLER_6_81 VGND VGND VPWR VPWR sky130_fd_sc_hd__decap_3
X_4435_ _1721_ _2203_ _2319_ VGND VGND VPWR VPWR _2320_ sky130_fd_sc_hd__a21o_1
XFILLER_59_705 VGND VGND VPWR VPWR sky130_fd_sc_hd__fill_1
X_4366_ _1151_ _2253_ VGND VGND VPWR VPWR _2254_ sky130_fd_sc_hd__nand2_1
XFILLER_113_673 VPWR VGND VPWR VGND sky130_ef_sc_hd__decap_12
X_3317_ reg_file_inst.registry\[0\]\[22\] _1076_ _1246_ _1254_ VGND VGND VPWR VPWR
+ _1256_ sky130_fd_sc_hd__a2bb2o_2
X_6105_ clknet_leaf_26_clk _0513_ _0038_ VGND VGND VPWR VPWR reg_file_inst.registry\[9\]\[10\]
+ sky130_fd_sc_hd__dfrtp_1
X_4297_ _1433_ _1457_ _1504_ VGND VGND VPWR VPWR _2185_ sky130_fd_sc_hd__and3_1
X_3248_ reg_file_inst.registry\[10\]\[25\] _1126_ _1136_ reg_file_inst.registry\[8\]\[25\]
+ VGND VGND VPWR VPWR _1190_ sky130_fd_sc_hd__a22o_1
X_6036_ net149 VGND VGND VPWR VPWR _0444_ sky130_fd_sc_hd__inv_2
X_3179_ net29 net35 VGND VGND VPWR VPWR _1123_ sky130_fd_sc_hd__and2b_4
XFILLER_39_495 VGND VGND VPWR VPWR sky130_fd_sc_hd__fill_2
XFILLER_54_443 VGND VGND VPWR VPWR sky130_fd_sc_hd__decap_3
XFILLER_26_123 VPWR VGND VPWR VGND sky130_ef_sc_hd__decap_12
XFILLER_26_145 VGND VGND VPWR VPWR sky130_fd_sc_hd__fill_1
XTAP_TAPCELL_ROW_1_277 VGND VPWR sky130_fd_sc_hd__tapvpwrvgnd_1
XFILLER_26_178 VPWR VGND VPWR VGND sky130_ef_sc_hd__decap_12
XTAP_TAPCELL_ROW_120_1769 VGND VPWR sky130_fd_sc_hd__tapvpwrvgnd_1
XTAP_TAPCELL_ROW_120_1758 VGND VPWR sky130_fd_sc_hd__tapvpwrvgnd_1
XFILLER_50_693 VGND VGND VPWR VPWR sky130_fd_sc_hd__decap_6
XFILLER_10_524 VGND VGND VPWR VPWR sky130_fd_sc_hd__decap_8
XFILLER_108_401 VPWR VGND VPWR VGND sky130_ef_sc_hd__decap_12
XFILLER_10_557 VPWR VGND VPWR VGND sky130_ef_sc_hd__decap_12
XFILLER_108_445 VPWR VGND VPWR VGND sky130_ef_sc_hd__decap_12
XTAP_TAPCELL_ROW_75_1204 VGND VPWR sky130_fd_sc_hd__tapvpwrvgnd_1
XFILLER_108_489 VPWR VGND VPWR VGND sky130_ef_sc_hd__decap_12
XFILLER_2_701 VPWR VGND VPWR VGND sky130_ef_sc_hd__decap_12
XTAP_TAPCELL_ROW_9_377 VGND VPWR sky130_fd_sc_hd__tapvpwrvgnd_1
XFILLER_9_3 VPWR VGND VPWR VGND sky130_ef_sc_hd__decap_12
XFILLER_1_222 VGND VGND VPWR VPWR sky130_fd_sc_hd__fill_2
XFILLER_110_109 VPWR VGND VPWR VGND sky130_ef_sc_hd__decap_12
XFILLER_77_524 VGND VGND VPWR VPWR sky130_fd_sc_hd__fill_1
XFILLER_1_288 VGND VGND VPWR VPWR sky130_fd_sc_hd__fill_1
XFILLER_49_237 VGND VGND VPWR VPWR sky130_fd_sc_hd__decap_3
XFILLER_92_527 VGND VGND VPWR VPWR sky130_fd_sc_hd__decap_4
XFILLER_85_590 VGND VGND VPWR VPWR sky130_fd_sc_hd__decap_3
XFILLER_57_281 VPWR VGND VPWR VGND sky130_ef_sc_hd__decap_12
XFILLER_18_613 VGND VGND VPWR VPWR sky130_fd_sc_hd__decap_8
XTAP_TAPCELL_ROW_86_1344 VGND VPWR sky130_fd_sc_hd__tapvpwrvgnd_1
XTAP_TAPCELL_ROW_86_1333 VGND VPWR sky130_fd_sc_hd__tapvpwrvgnd_1
XFILLER_18_657 VPWR VGND VPWR VGND sky130_ef_sc_hd__decap_12
XFILLER_45_432 VGND VGND VPWR VPWR sky130_fd_sc_hd__fill_2
XFILLER_45_454 VGND VGND VPWR VPWR sky130_fd_sc_hd__fill_1
XFILLER_122_81 VGND VGND VPWR VPWR sky130_fd_sc_hd__decap_3
XFILLER_82_41 VPWR VGND VPWR VGND sky130_ef_sc_hd__decap_12
XTAP_TAPCELL_ROW_56_961 VGND VPWR sky130_fd_sc_hd__tapvpwrvgnd_1
XFILLER_33_605 VGND VGND VPWR VPWR sky130_fd_sc_hd__decap_8
XFILLER_13_384 VGND VGND VPWR VPWR sky130_fd_sc_hd__decap_8
XFILLER_15_90 VPWR VGND VPWR VGND sky130_ef_sc_hd__decap_12
XFILLER_41_671 VGND VGND VPWR VPWR sky130_fd_sc_hd__fill_1
XFILLER_118_209 VPWR VGND VPWR VGND sky130_ef_sc_hd__decap_12
XFILLER_63_6 VPWR VGND VPWR VGND sky130_ef_sc_hd__decap_12
XTAP_TAPCELL_ROW_97_1473 VGND VPWR sky130_fd_sc_hd__tapvpwrvgnd_1
Xoutput107 net107 VGND VGND VPWR VPWR IC[14] sky130_fd_sc_hd__buf_1
Xoutput118 net118 VGND VGND VPWR VPWR IC[24] sky130_fd_sc_hd__buf_1
XFILLER_5_561 VPWR VGND VPWR VGND sky130_ef_sc_hd__decap_12
Xoutput129 net129 VGND VGND VPWR VPWR IC[9] sky130_fd_sc_hd__buf_1
X_4220_ _2110_ net122 net130 VGND VGND VPWR VPWR _0924_ sky130_fd_sc_hd__mux2_1
XFILLER_110_643 VGND VGND VPWR VPWR sky130_fd_sc_hd__fill_1
X_4151_ _1884_ _2051_ VGND VGND VPWR VPWR _2065_ sky130_fd_sc_hd__nand2_1
XFILLER_68_557 VGND VGND VPWR VPWR sky130_fd_sc_hd__fill_2
X_4082_ _1996_ _1997_ VGND VGND VPWR VPWR _1998_ sky130_fd_sc_hd__nand2b_1
X_3102_ JMPOFF\[14\] net141 net41 VGND VGND VPWR VPWR _1046_ sky130_fd_sc_hd__a21o_1
X_3033_ JMPOFF\[21\] JMPOFF\[20\] _0967_ VGND VGND VPWR VPWR _0977_ sky130_fd_sc_hd__o21ai_1
XFILLER_36_421 VGND VGND VPWR VPWR sky130_fd_sc_hd__decap_8
XFILLER_102_29 VPWR VGND VPWR VGND sky130_ef_sc_hd__decap_12
XFILLER_51_413 VPWR VGND VPWR VGND sky130_ef_sc_hd__decap_12
XFILLER_24_627 VGND VGND VPWR VPWR sky130_fd_sc_hd__fill_2
XFILLER_91_593 VPWR VGND VPWR VGND sky130_ef_sc_hd__decap_12
X_4984_ reg_file_inst.registry\[7\]\[21\] _2829_ _2553_ VGND VGND VPWR VPWR _0896_
+ sky130_fd_sc_hd__mux2_1
XTAP_TAPCELL_ROW_106_1591 VGND VPWR sky130_fd_sc_hd__tapvpwrvgnd_1
XFILLER_32_660 VPWR VGND VPWR VGND sky130_ef_sc_hd__decap_12
X_3935_ _1847_ _1848_ _1851_ _1118_ reg_file_inst.registry\[0\]\[0\] VGND VGND VPWR
+ VPWR net73 sky130_fd_sc_hd__o32a_4
XTAP_TAPCELL_ROW_34_688 VGND VPWR sky130_fd_sc_hd__tapvpwrvgnd_1
XFILLER_31_181 VGND VGND VPWR VPWR sky130_fd_sc_hd__decap_6
XFILLER_31_192 VPWR VGND VPWR VGND sky130_ef_sc_hd__decap_12
X_3866_ reg_file_inst.registry\[15\]\[2\] _1093_ _1097_ reg_file_inst.registry\[5\]\[2\]
+ VGND VGND VPWR VPWR _1785_ sky130_fd_sc_hd__a22o_1
X_5605_ net147 VGND VGND VPWR VPWR _0013_ sky130_fd_sc_hd__inv_2
XFILLER_11_15 VPWR VGND VPWR VGND sky130_ef_sc_hd__decap_12
X_3797_ reg_file_inst.registry\[1\]\[4\] _1142_ _1711_ _1712_ _1713_ VGND VGND VPWR
+ VPWR _1719_ sky130_fd_sc_hd__a2111o_1
X_5536_ _2715_ reg_file_inst.registry\[9\]\[27\] _3002_ VGND VGND VPWR VPWR _0530_
+ sky130_fd_sc_hd__mux2_1
X_5467_ reg_file_inst.registry\[5\]\[9\] _2974_ _2999_ VGND VGND VPWR VPWR _0596_
+ sky130_fd_sc_hd__mux2_1
X_4418_ _1840_ _2305_ VGND VGND VPWR VPWR _2306_ sky130_fd_sc_hd__or2_1
XFILLER_99_671 VGND VGND VPWR VPWR sky130_fd_sc_hd__fill_1
X_5398_ reg_file_inst.registry\[4\]\[20\] _2842_ _2997_ VGND VGND VPWR VPWR _0663_
+ sky130_fd_sc_hd__mux2_1
XTAP_TAPCELL_ROW_70_1145 VGND VPWR sky130_fd_sc_hd__tapvpwrvgnd_1
XTAP_TAPCELL_ROW_70_1134 VGND VPWR sky130_fd_sc_hd__tapvpwrvgnd_1
XTAP_TAPCELL_ROW_6_336 VGND VPWR sky130_fd_sc_hd__tapvpwrvgnd_1
X_4349_ _1151_ net137 VGND VGND VPWR VPWR _2237_ sky130_fd_sc_hd__or2_2
XFILLER_101_665 VGND VGND VPWR VPWR sky130_fd_sc_hd__decap_6
XFILLER_47_719 VGND VGND VPWR VPWR sky130_fd_sc_hd__decap_6
XFILLER_100_153 VPWR VGND VPWR VGND sky130_ef_sc_hd__decap_12
X_6019_ net44 VGND VGND VPWR VPWR _0427_ sky130_fd_sc_hd__inv_2
XFILLER_39_270 VGND VGND VPWR VPWR sky130_fd_sc_hd__decap_8
XFILLER_100_197 VGND VGND VPWR VPWR sky130_fd_sc_hd__decap_6
XFILLER_27_432 VPWR VGND VPWR VGND sky130_ef_sc_hd__decap_12
XFILLER_36_23 VGND VGND VPWR VPWR sky130_fd_sc_hd__decap_4
XFILLER_39_281 VPWR VGND VPWR VGND sky130_ef_sc_hd__decap_12
XFILLER_82_571 VPWR VGND VPWR VGND sky130_ef_sc_hd__decap_12
XFILLER_14_104 VGND VGND VPWR VPWR sky130_fd_sc_hd__decap_6
XFILLER_42_402 VGND VGND VPWR VPWR sky130_fd_sc_hd__fill_1
XTAP_TAPCELL_ROW_53_931 VGND VPWR sky130_fd_sc_hd__tapvpwrvgnd_1
XFILLER_15_649 VGND VGND VPWR VPWR sky130_fd_sc_hd__decap_8
XTAP_TAPCELL_ROW_81_1274 VGND VPWR sky130_fd_sc_hd__tapvpwrvgnd_1
XFILLER_22_170 VGND VGND VPWR VPWR sky130_fd_sc_hd__decap_4
XFILLER_10_321 VGND VGND VPWR VPWR sky130_fd_sc_hd__fill_1
XFILLER_109_721 VGND VGND VPWR VPWR sky130_fd_sc_hd__decap_4
XFILLER_108_253 VPWR VGND VPWR VGND sky130_ef_sc_hd__decap_12
XFILLER_117_81 VPWR VGND VPWR VGND sky130_ef_sc_hd__decap_12
XFILLER_96_118 VGND VGND VPWR VPWR sky130_fd_sc_hd__decap_8
XFILLER_111_429 VPWR VGND VPWR VGND sky130_ef_sc_hd__decap_12
XFILLER_77_63 VGND VGND VPWR VPWR sky130_fd_sc_hd__fill_1
XFILLER_77_96 VGND VGND VPWR VPWR sky130_fd_sc_hd__fill_1
XFILLER_65_505 VPWR VGND VPWR VGND sky130_ef_sc_hd__decap_12
XFILLER_38_719 VGND VGND VPWR VPWR sky130_fd_sc_hd__decap_4
XFILLER_60_243 VGND VGND VPWR VPWR sky130_fd_sc_hd__fill_1
XTAP_TAPCELL_ROW_99_1502 VGND VPWR sky130_fd_sc_hd__tapvpwrvgnd_1
X_3720_ MEMOFF\[7\] _1077_ _1078_ VGND VGND VPWR VPWR _1644_ sky130_fd_sc_hd__and3_1
Xclkbuf_leaf_40_clk clknet_3_7__leaf_clk VGND VGND VPWR VPWR clknet_leaf_40_clk sky130_fd_sc_hd__clkbuf_8
XTAP_TAPCELL_ROW_31_647 VGND VPWR sky130_fd_sc_hd__tapvpwrvgnd_1
XFILLER_119_529 VPWR VGND VPWR VGND sky130_ef_sc_hd__decap_12
X_3651_ reg_file_inst.registry\[3\]\[9\] _1091_ _1572_ _1573_ net139 VGND VGND VPWR
+ VPWR _1577_ sky130_fd_sc_hd__a2111o_1
XFILLER_9_185 VGND VGND VPWR VPWR sky130_fd_sc_hd__decap_3
XFILLER_9_163 VGND VGND VPWR VPWR sky130_fd_sc_hd__fill_2
X_6370_ clknet_leaf_33_clk _0778_ _0303_ VGND VGND VPWR VPWR reg_file_inst.registry\[2\]\[23\]
+ sky130_fd_sc_hd__dfrtp_1
X_3582_ reg_file_inst.registry\[15\]\[14\] _1122_ _1129_ MEMOFF\[14\] VGND VGND VPWR
+ VPWR _1511_ sky130_fd_sc_hd__a22o_1
XFILLER_61_3 VPWR VGND VPWR VGND sky130_ef_sc_hd__decap_12
X_5321_ _2960_ reg_file_inst.registry\[8\]\[10\] _2994_ VGND VGND VPWR VPWR _0737_
+ sky130_fd_sc_hd__mux2_1
XFILLER_114_245 VGND VGND VPWR VPWR sky130_fd_sc_hd__decap_6
X_5252_ reg_file_inst.registry\[14\]\[21\] _2829_ _2992_ VGND VGND VPWR VPWR _0804_
+ sky130_fd_sc_hd__mux2_1
XFILLER_114_289 VPWR VGND VPWR VGND sky130_ef_sc_hd__decap_12
X_5183_ _2817_ reg_file_inst.registry\[0\]\[22\] _2988_ VGND VGND VPWR VPWR _0869_
+ sky130_fd_sc_hd__mux2_1
XFILLER_68_321 VPWR VGND VPWR VGND sky130_ef_sc_hd__decap_12
X_4203_ _1935_ _2099_ VGND VGND VPWR VPWR _2100_ sky130_fd_sc_hd__xnor2_1
X_4134_ _2048_ _2049_ _2047_ VGND VGND VPWR VPWR _2050_ sky130_fd_sc_hd__a21boi_1
XFILLER_56_505 VGND VGND VPWR VPWR sky130_fd_sc_hd__decap_3
XTAP_TAPCELL_ROW_3_306 VGND VPWR sky130_fd_sc_hd__tapvpwrvgnd_1
XFILLER_83_302 VGND VGND VPWR VPWR sky130_fd_sc_hd__decap_8
XFILLER_56_527 VGND VGND VPWR VPWR sky130_fd_sc_hd__decap_4
XFILLER_113_39 VPWR VGND VPWR VGND sky130_ef_sc_hd__decap_12
XTAP_TAPCELL_ROW_108_1620 VGND VPWR sky130_fd_sc_hd__tapvpwrvgnd_1
X_4065_ _1979_ _1980_ VGND VGND VPWR VPWR _1981_ sky130_fd_sc_hd__nand2_1
XTAP_TAPCELL_ROW_39_747 VGND VPWR sky130_fd_sc_hd__tapvpwrvgnd_1
X_3016_ net43 net42 VGND VGND VPWR VPWR _0961_ sky130_fd_sc_hd__nor2_2
XFILLER_91_390 VGND VGND VPWR VPWR sky130_fd_sc_hd__fill_2
XFILLER_51_210 VGND VGND VPWR VPWR sky130_fd_sc_hd__decap_8
XFILLER_36_273 VGND VGND VPWR VPWR sky130_fd_sc_hd__fill_2
X_4967_ _2129_ _2370_ VGND VGND VPWR VPWR _2816_ sky130_fd_sc_hd__or2_1
Xclkbuf_leaf_31_clk clknet_3_6__leaf_clk VGND VGND VPWR VPWR clknet_leaf_31_clk sky130_fd_sc_hd__clkbuf_8
XFILLER_22_25 VGND VGND VPWR VPWR sky130_fd_sc_hd__decap_3
X_4898_ _1185_ _1195_ _2752_ VGND VGND VPWR VPWR _2753_ sky130_fd_sc_hd__a21oi_1
X_3918_ reg_file_inst.registry\[8\]\[0\] _1090_ _1831_ _1832_ _1833_ VGND VGND VPWR
+ VPWR _1835_ sky130_fd_sc_hd__a2111o_1
XFILLER_20_674 VGND VGND VPWR VPWR sky130_fd_sc_hd__decap_4
X_3849_ reg_file_inst.registry\[9\]\[3\] net143 _1127_ VGND VGND VPWR VPWR _1769_
+ sky130_fd_sc_hd__and3_1
XTAP_TAPCELL_ROW_59_1007 VGND VPWR sky130_fd_sc_hd__tapvpwrvgnd_1
XFILLER_106_713 VPWR VGND VPWR VGND sky130_ef_sc_hd__decap_12
XFILLER_98_29 VPWR VGND VPWR VGND sky130_ef_sc_hd__decap_12
X_5519_ reg_file_inst.registry\[6\]\[15\] _2897_ _3001_ VGND VGND VPWR VPWR _0546_
+ sky130_fd_sc_hd__mux2_1
XFILLER_105_223 VGND VGND VPWR VPWR sky130_fd_sc_hd__fill_1
X_6499_ clknet_leaf_45_clk _0907_ _0432_ VGND VGND VPWR VPWR reg_file_inst.registry\[11\]\[8\]
+ sky130_fd_sc_hd__dfrtp_1
XFILLER_59_321 VPWR VGND VPWR VGND sky130_ef_sc_hd__decap_12
XFILLER_87_641 VPWR VGND VPWR VGND sky130_ef_sc_hd__decap_12
XFILLER_47_11 VGND VGND VPWR VPWR sky130_fd_sc_hd__fill_1
XFILLER_47_505 VPWR VGND VPWR VGND sky130_ef_sc_hd__decap_12
XFILLER_101_473 VPWR VGND VPWR VGND sky130_ef_sc_hd__decap_12
XFILLER_87_685 VPWR VGND VPWR VGND sky130_ef_sc_hd__decap_12
XFILLER_47_55 VGND VGND VPWR VPWR sky130_fd_sc_hd__fill_1
XFILLER_86_195 VGND VGND VPWR VPWR sky130_fd_sc_hd__fill_1
XFILLER_74_357 VGND VGND VPWR VPWR sky130_fd_sc_hd__decap_6
XTAP_TAPCELL_ROW_83_1303 VGND VPWR sky130_fd_sc_hd__tapvpwrvgnd_1
XFILLER_15_402 VGND VGND VPWR VPWR sky130_fd_sc_hd__decap_8
XFILLER_43_700 VPWR VGND VPWR VGND sky130_ef_sc_hd__decap_12
XFILLER_70_530 VGND VGND VPWR VPWR sky130_fd_sc_hd__fill_2
XFILLER_63_54 VGND VGND VPWR VPWR sky130_fd_sc_hd__fill_2
XFILLER_63_87 VPWR VGND VPWR VGND sky130_ef_sc_hd__decap_12
Xclkbuf_leaf_22_clk clknet_3_3__leaf_clk VGND VGND VPWR VPWR clknet_leaf_22_clk sky130_fd_sc_hd__clkbuf_8
XFILLER_11_641 VGND VGND VPWR VPWR sky130_fd_sc_hd__decap_8
XFILLER_11_685 VGND VGND VPWR VPWR sky130_fd_sc_hd__decap_8
XFILLER_109_573 VPWR VGND VPWR VGND sky130_ef_sc_hd__decap_12
XTAP_TAPCELL_ROW_94_1443 VGND VPWR sky130_fd_sc_hd__tapvpwrvgnd_1
XFILLER_88_40 VGND VGND VPWR VPWR sky130_fd_sc_hd__fill_1
XFILLER_97_416 VPWR VGND VPWR VGND sky130_ef_sc_hd__decap_12
XFILLER_69_107 VGND VGND VPWR VPWR sky130_fd_sc_hd__decap_4
XFILLER_111_237 VPWR VGND VPWR VGND sky130_ef_sc_hd__decap_12
XFILLER_97_449 VPWR VGND VPWR VGND sky130_ef_sc_hd__decap_12
XFILLER_92_121 VPWR VGND VPWR VGND sky130_ef_sc_hd__decap_12
XFILLER_65_335 VGND VGND VPWR VPWR sky130_fd_sc_hd__fill_1
XFILLER_92_154 VPWR VGND VPWR VGND sky130_ef_sc_hd__decap_12
XFILLER_65_368 VGND VGND VPWR VPWR sky130_fd_sc_hd__fill_2
XFILLER_18_251 VGND VGND VPWR VPWR sky130_fd_sc_hd__fill_1
XTAP_TAPCELL_ROW_36_717 VGND VPWR sky130_fd_sc_hd__tapvpwrvgnd_1
X_5870_ net44 VGND VGND VPWR VPWR _0278_ sky130_fd_sc_hd__inv_2
XFILLER_46_582 VGND VGND VPWR VPWR sky130_fd_sc_hd__fill_1
X_4821_ _2126_ _2182_ _2563_ VGND VGND VPWR VPWR _2680_ sky130_fd_sc_hd__o21ai_1
XFILLER_33_254 VGND VGND VPWR VPWR sky130_fd_sc_hd__fill_1
XTAP_TAPCELL_ROW_103_1550 VGND VPWR sky130_fd_sc_hd__tapvpwrvgnd_1
XFILLER_61_596 VGND VGND VPWR VPWR sky130_fd_sc_hd__decap_8
XFILLER_61_585 VGND VGND VPWR VPWR sky130_fd_sc_hd__fill_2
XTAP_TAPCELL_ROW_16_463 VGND VPWR sky130_fd_sc_hd__tapvpwrvgnd_1
XFILLER_33_287 VGND VGND VPWR VPWR sky130_fd_sc_hd__fill_1
Xclkbuf_leaf_13_clk clknet_3_2__leaf_clk VGND VGND VPWR VPWR clknet_leaf_13_clk sky130_fd_sc_hd__clkbuf_8
XFILLER_21_449 VPWR VGND VPWR VGND sky130_ef_sc_hd__decap_12
X_4752_ _1582_ _2610_ VGND VGND VPWR VPWR _2611_ sky130_fd_sc_hd__xnor2_1
XFILLER_119_337 VPWR VGND VPWR VGND sky130_ef_sc_hd__decap_12
X_4683_ _2455_ reg_file_inst.registry\[11\]\[12\] _2118_ VGND VGND VPWR VPWR _0911_
+ sky130_fd_sc_hd__mux2_1
X_3703_ _1494_ _1504_ _1515_ _1491_ _1480_ VGND VGND VPWR VPWR _1627_ sky130_fd_sc_hd__o32a_1
X_6422_ clknet_leaf_20_clk _0830_ _0355_ VGND VGND VPWR VPWR reg_file_inst.registry\[1\]\[19\]
+ sky130_fd_sc_hd__dfrtp_1
X_3634_ MEMOFF\[10\] _1129_ _1130_ JMPOFF\[10\] _1560_ VGND VGND VPWR VPWR _1561_
+ sky130_fd_sc_hd__a221o_1
X_3565_ _1480_ _1491_ VGND VGND VPWR VPWR _1494_ sky130_fd_sc_hd__xnor2_1
X_6353_ clknet_leaf_3_clk _0761_ _0286_ VGND VGND VPWR VPWR reg_file_inst.registry\[2\]\[6\]
+ sky130_fd_sc_hd__dfrtp_1
X_5304_ _2715_ reg_file_inst.registry\[8\]\[27\] _2994_ VGND VGND VPWR VPWR _0754_
+ sky130_fd_sc_hd__mux2_1
X_6284_ clknet_leaf_30_clk _0692_ _0217_ VGND VGND VPWR VPWR MEMOFF\[21\] sky130_fd_sc_hd__dfrtp_1
X_3496_ reg_file_inst.registry\[7\]\[12\] _1086_ _1094_ reg_file_inst.registry\[6\]\[12\]
+ VGND VGND VPWR VPWR _1428_ sky130_fd_sc_hd__a22o_1
XTAP_TAPCELL_ROW_114_1690 VGND VPWR sky130_fd_sc_hd__tapvpwrvgnd_1
X_5235_ _2986_ reg_file_inst.registry\[1\]\[8\] _2990_ VGND VGND VPWR VPWR _0819_
+ sky130_fd_sc_hd__mux2_1
XFILLER_69_685 VGND VGND VPWR VPWR sky130_fd_sc_hd__decap_4
X_5166_ net27 net101 net71 _2308_ VGND VGND VPWR VPWR _2986_ sky130_fd_sc_hd__a22o_4
XFILLER_29_505 VPWR VGND VPWR VGND sky130_ef_sc_hd__decap_12
XFILLER_83_110 VGND VGND VPWR VPWR sky130_fd_sc_hd__fill_2
XFILLER_68_195 VGND VGND VPWR VPWR sky130_fd_sc_hd__fill_1
X_4117_ net115 _2031_ VGND VGND VPWR VPWR _2033_ sky130_fd_sc_hd__nor2_1
X_5097_ _1434_ _1446_ _2288_ _2925_ VGND VGND VPWR VPWR _2926_ sky130_fd_sc_hd__o22a_1
XFILLER_84_699 VGND VGND VPWR VPWR sky130_fd_sc_hd__fill_1
X_4048_ _1961_ _1963_ VGND VGND VPWR VPWR _1964_ sky130_fd_sc_hd__nor2_1
XFILLER_71_349 VGND VGND VPWR VPWR sky130_fd_sc_hd__fill_2
XFILLER_25_722 VGND VGND VPWR VPWR sky130_fd_sc_hd__fill_1
XFILLER_24_221 VPWR VGND VPWR VGND sky130_ef_sc_hd__decap_12
XTAP_TAPCELL_ROW_65_1077 VGND VPWR sky130_fd_sc_hd__tapvpwrvgnd_1
X_5999_ net146 VGND VGND VPWR VPWR _0407_ sky130_fd_sc_hd__inv_2
XFILLER_24_287 VPWR VGND VPWR VGND sky130_ef_sc_hd__decap_12
XFILLER_33_24 VGND VGND VPWR VPWR sky130_fd_sc_hd__decap_8
XFILLER_33_57 VPWR VGND VPWR VGND sky130_ef_sc_hd__decap_12
XFILLER_109_3 VPWR VGND VPWR VGND sky130_ef_sc_hd__decap_12
XFILLER_4_637 VGND VGND VPWR VPWR sky130_fd_sc_hd__decap_6
XFILLER_3_125 VGND VGND VPWR VPWR sky130_fd_sc_hd__fill_2
XFILLER_79_405 VPWR VGND VPWR VGND sky130_ef_sc_hd__decap_12
XFILLER_3_158 VGND VGND VPWR VPWR sky130_fd_sc_hd__decap_8
XFILLER_106_587 VGND VGND VPWR VPWR sky130_fd_sc_hd__fill_1
XFILLER_79_449 VGND VGND VPWR VPWR sky130_fd_sc_hd__decap_6
XFILLER_58_43 VGND VGND VPWR VPWR sky130_fd_sc_hd__decap_3
XFILLER_59_151 VGND VGND VPWR VPWR sky130_fd_sc_hd__fill_1
XFILLER_47_313 VPWR VGND VPWR VGND sky130_ef_sc_hd__decap_12
XFILLER_101_281 VGND VGND VPWR VPWR sky130_fd_sc_hd__decap_8
XFILLER_90_625 VPWR VGND VPWR VGND sky130_ef_sc_hd__decap_12
XFILLER_74_53 VPWR VGND VPWR VGND sky130_ef_sc_hd__decap_12
XFILLER_28_582 VGND VGND VPWR VPWR sky130_fd_sc_hd__decap_6
XFILLER_90_669 VPWR VGND VPWR VGND sky130_ef_sc_hd__decap_12
XFILLER_55_390 VGND VGND VPWR VPWR sky130_fd_sc_hd__fill_2
XFILLER_70_382 VGND VGND VPWR VPWR sky130_fd_sc_hd__fill_2
XTAP_TAPCELL_ROW_13_422 VGND VPWR sky130_fd_sc_hd__tapvpwrvgnd_1
XFILLER_90_85 VGND VGND VPWR VPWR sky130_fd_sc_hd__decap_8
XFILLER_30_257 VGND VGND VPWR VPWR sky130_fd_sc_hd__decap_4
XTAP_TAPCELL_ROW_41_775 VGND VPWR sky130_fd_sc_hd__tapvpwrvgnd_1
XFILLER_116_307 VGND VGND VPWR VPWR sky130_fd_sc_hd__fill_1
Xmax_cap139 net140 VGND VGND VPWR VPWR net139 sky130_fd_sc_hd__buf_6
X_3350_ reg_file_inst.registry\[8\]\[21\] _1136_ _1140_ reg_file_inst.registry\[3\]\[21\]
+ VGND VGND VPWR VPWR _1288_ sky130_fd_sc_hd__a22o_1
XFILLER_112_513 VPWR VGND VPWR VGND sky130_ef_sc_hd__decap_12
XFILLER_112_557 VPWR VGND VPWR VGND sky130_ef_sc_hd__decap_12
X_5020_ _2279_ _2729_ _2745_ _2711_ _2860_ VGND VGND VPWR VPWR _2861_ sky130_fd_sc_hd__a221o_1
X_3281_ _1175_ _1197_ _1220_ VGND VGND VPWR VPWR _1221_ sky130_fd_sc_hd__nor3_1
XFILLER_97_279 VGND VGND VPWR VPWR sky130_fd_sc_hd__fill_1
Xclkbuf_leaf_2_clk clknet_3_0__leaf_clk VGND VGND VPWR VPWR clknet_leaf_2_clk sky130_fd_sc_hd__clkbuf_8
XPHY_EDGE_ROW_119_Right_119 VGND VGND VPWR VPWR sky130_fd_sc_hd__decap_3
XFILLER_38_357 VGND VGND VPWR VPWR sky130_fd_sc_hd__decap_6
XTAP_TAPCELL_ROW_49_875 VGND VPWR sky130_fd_sc_hd__tapvpwrvgnd_1
XFILLER_53_316 VGND VGND VPWR VPWR sky130_fd_sc_hd__decap_8
XFILLER_0_50 VGND VGND VPWR VPWR sky130_fd_sc_hd__decap_6
X_5922_ net146 VGND VGND VPWR VPWR _0330_ sky130_fd_sc_hd__inv_2
XFILLER_46_390 VPWR VGND VPWR VGND sky130_ef_sc_hd__decap_12
XFILLER_110_29 VPWR VGND VPWR VGND sky130_ef_sc_hd__decap_12
X_5853_ net148 VGND VGND VPWR VPWR _0261_ sky130_fd_sc_hd__inv_2
XFILLER_34_574 VPWR VGND VPWR VGND sky130_ef_sc_hd__decap_12
X_5784_ net146 VGND VGND VPWR VPWR _0192_ sky130_fd_sc_hd__inv_2
X_4804_ _2658_ _2662_ VGND VGND VPWR VPWR _2663_ sky130_fd_sc_hd__nor2_1
XFILLER_21_213 VGND VGND VPWR VPWR sky130_fd_sc_hd__decap_3
X_4735_ _1242_ _2578_ _2582_ VGND VGND VPWR VPWR _2594_ sky130_fd_sc_hd__o21ai_1
XFILLER_119_27 VPWR VGND VPWR VGND sky130_ef_sc_hd__decap_12
XFILLER_119_167 VGND VGND VPWR VPWR sky130_fd_sc_hd__fill_1
X_4666_ _2314_ _2317_ _1816_ VGND VGND VPWR VPWR _2539_ sky130_fd_sc_hd__a21oi_1
XFILLER_107_329 VGND VGND VPWR VPWR sky130_fd_sc_hd__decap_6
X_3617_ reg_file_inst.registry\[14\]\[10\] _1081_ _1089_ reg_file_inst.registry\[9\]\[10\]
+ VGND VGND VPWR VPWR _1544_ sky130_fd_sc_hd__a22o_1
X_4597_ _1709_ _2458_ _2465_ _2295_ VGND VGND VPWR VPWR _2476_ sky130_fd_sc_hd__o211a_1
X_6405_ clknet_leaf_0_clk _0813_ _0338_ VGND VGND VPWR VPWR reg_file_inst.registry\[1\]\[2\]
+ sky130_fd_sc_hd__dfrtp_1
X_3548_ reg_file_inst.registry\[4\]\[15\] _1092_ _1093_ reg_file_inst.registry\[15\]\[15\]
+ _1477_ VGND VGND VPWR VPWR _1478_ sky130_fd_sc_hd__a221o_1
X_6336_ clknet_leaf_8_clk _0744_ _0269_ VGND VGND VPWR VPWR reg_file_inst.registry\[8\]\[17\]
+ sky130_fd_sc_hd__dfrtp_1
XFILLER_115_373 VPWR VGND VPWR VGND sky130_ef_sc_hd__decap_12
XFILLER_103_502 VGND VGND VPWR VPWR sky130_fd_sc_hd__fill_2
XFILLER_89_725 VGND VGND VPWR VPWR sky130_fd_sc_hd__fill_1
XFILLER_1_629 VPWR VGND VPWR VGND sky130_ef_sc_hd__decap_12
X_3479_ reg_file_inst.registry\[15\]\[17\] _1122_ _1130_ JMPOFF\[17\] _1411_ VGND
+ VGND VPWR VPWR _1412_ sky130_fd_sc_hd__a221o_1
XFILLER_0_128 VPWR VGND VPWR VGND sky130_ef_sc_hd__decap_12
X_6267_ clknet_leaf_54_clk _0675_ _0200_ VGND VGND VPWR VPWR MEMOFF\[4\] sky130_fd_sc_hd__dfrtp_2
X_5218_ _2767_ reg_file_inst.registry\[1\]\[25\] _2990_ VGND VGND VPWR VPWR _0836_
+ sky130_fd_sc_hd__mux2_1
X_6198_ clknet_leaf_21_clk _0606_ _0131_ VGND VGND VPWR VPWR reg_file_inst.registry\[5\]\[19\]
+ sky130_fd_sc_hd__dfrtp_1
X_5149_ _2970_ _2971_ VGND VGND VPWR VPWR _2972_ sky130_fd_sc_hd__or2_1
XTAP_TAPCELL_ROW_67_1106 VGND VPWR sky130_fd_sc_hd__tapvpwrvgnd_1
XFILLER_29_357 VPWR VGND VPWR VGND sky130_ef_sc_hd__decap_12
XFILLER_71_113 VPWR VGND VPWR VGND sky130_ef_sc_hd__decap_12
XFILLER_72_669 VPWR VGND VPWR VGND sky130_ef_sc_hd__decap_12
XFILLER_13_703 VGND VGND VPWR VPWR sky130_fd_sc_hd__decap_3
XFILLER_25_596 VPWR VGND VPWR VGND sky130_ef_sc_hd__decap_12
XFILLER_40_533 VPWR VGND VPWR VGND sky130_ef_sc_hd__decap_12
XFILLER_44_89 VGND VGND VPWR VPWR sky130_fd_sc_hd__fill_1
XTAP_TAPCELL_ROW_78_1235 VGND VPWR sky130_fd_sc_hd__tapvpwrvgnd_1
XTAP_TAPCELL_ROW_91_1402 VGND VPWR sky130_fd_sc_hd__tapvpwrvgnd_1
XFILLER_5_39 VPWR VGND VPWR VGND sky130_ef_sc_hd__decap_12
XFILLER_109_93 VPWR VGND VPWR VGND sky130_ef_sc_hd__decap_12
XFILLER_69_53 VGND VGND VPWR VPWR sky130_fd_sc_hd__decap_3
XFILLER_87_290 VPWR VGND VPWR VGND sky130_ef_sc_hd__decap_12
XFILLER_47_110 VGND VGND VPWR VPWR sky130_fd_sc_hd__fill_2
XFILLER_47_121 VGND VGND VPWR VPWR sky130_fd_sc_hd__fill_1
XFILLER_75_441 VGND VGND VPWR VPWR sky130_fd_sc_hd__decap_6
XFILLER_35_305 VGND VGND VPWR VPWR sky130_fd_sc_hd__decap_4
XTAP_TAPCELL_ROW_89_1375 VGND VPWR sky130_fd_sc_hd__tapvpwrvgnd_1
XFILLER_75_485 VGND VGND VPWR VPWR sky130_fd_sc_hd__decap_8
XFILLER_35_327 VGND VGND VPWR VPWR sky130_fd_sc_hd__decap_8
XTAP_TAPCELL_ROW_46_834 VGND VPWR sky130_fd_sc_hd__tapvpwrvgnd_1
XFILLER_35_349 VPWR VGND VPWR VGND sky130_ef_sc_hd__decap_12
XTAP_TAPCELL_ROW_46_845 VGND VPWR sky130_fd_sc_hd__tapvpwrvgnd_1
XFILLER_90_477 VGND VGND VPWR VPWR sky130_fd_sc_hd__fill_1
XFILLER_16_585 VGND VGND VPWR VPWR sky130_fd_sc_hd__decap_3
XFILLER_31_500 VGND VGND VPWR VPWR sky130_fd_sc_hd__fill_1
XTAP_TAPCELL_ROW_26_591 VGND VPWR sky130_fd_sc_hd__tapvpwrvgnd_1
XFILLER_43_382 VGND VGND VPWR VPWR sky130_fd_sc_hd__fill_1
XFILLER_43_393 VGND VGND VPWR VPWR sky130_fd_sc_hd__fill_2
XTAP_TAPCELL_ROW_100_1520 VGND VPWR sky130_fd_sc_hd__tapvpwrvgnd_1
X_4520_ _2264_ _2269_ net135 VGND VGND VPWR VPWR _2403_ sky130_fd_sc_hd__mux2_1
X_4451_ _1840_ _2225_ _2335_ VGND VGND VPWR VPWR _2336_ sky130_fd_sc_hd__o21ba_1
X_3402_ reg_file_inst.registry\[7\]\[19\] _1133_ _1136_ reg_file_inst.registry\[8\]\[19\]
+ VGND VGND VPWR VPWR _1338_ sky130_fd_sc_hd__a22o_1
XFILLER_98_533 VPWR VGND VPWR VGND sky130_ef_sc_hd__decap_12
X_6121_ clknet_leaf_20_clk _0529_ _0054_ VGND VGND VPWR VPWR reg_file_inst.registry\[9\]\[26\]
+ sky130_fd_sc_hd__dfrtp_1
X_4382_ _1692_ _2190_ VGND VGND VPWR VPWR _2270_ sky130_fd_sc_hd__and2_1
XFILLER_112_321 VPWR VGND VPWR VGND sky130_ef_sc_hd__decap_12
XFILLER_98_566 VPWR VGND VPWR VGND sky130_ef_sc_hd__decap_12
X_3333_ reg_file_inst.registry\[7\]\[21\] _1084_ _1085_ VGND VGND VPWR VPWR _1271_
+ sky130_fd_sc_hd__and3_1
XFILLER_112_365 VPWR VGND VPWR VGND sky130_ef_sc_hd__decap_12
X_3264_ reg_file_inst.registry\[14\]\[24\] _1081_ _1097_ reg_file_inst.registry\[5\]\[24\]
+ _1198_ VGND VGND VPWR VPWR _1205_ sky130_fd_sc_hd__a221o_1
XPHY_EDGE_ROW_7_Right_7 VGND VGND VPWR VPWR sky130_fd_sc_hd__decap_3
X_6052_ net146 VGND VGND VPWR VPWR _0460_ sky130_fd_sc_hd__inv_2
X_5003_ _2660_ _2844_ _2658_ VGND VGND VPWR VPWR _2846_ sky130_fd_sc_hd__a21o_1
X_3195_ _1127_ net142 VGND VGND VPWR VPWR _1139_ sky130_fd_sc_hd__and2_4
XFILLER_121_39 VPWR VGND VPWR VGND sky130_ef_sc_hd__decap_12
X_5905_ net146 VGND VGND VPWR VPWR _0313_ sky130_fd_sc_hd__inv_2
XTAP_TAPCELL_ROW_62_1036 VGND VPWR sky130_fd_sc_hd__tapvpwrvgnd_1
XFILLER_14_15 VPWR VGND VPWR VGND sky130_ef_sc_hd__decap_12
XFILLER_22_533 VPWR VGND VPWR VGND sky130_ef_sc_hd__decap_12
X_5836_ net149 VGND VGND VPWR VPWR _0244_ sky130_fd_sc_hd__inv_2
XFILLER_61_190 VPWR VGND VPWR VGND sky130_ef_sc_hd__decap_12
X_5767_ net146 VGND VGND VPWR VPWR _0175_ sky130_fd_sc_hd__inv_2
X_5698_ net146 VGND VGND VPWR VPWR _0106_ sky130_fd_sc_hd__inv_2
X_4718_ _1256_ _2126_ _2563_ VGND VGND VPWR VPWR _2577_ sky130_fd_sc_hd__o21ai_1
XFILLER_107_137 VPWR VGND VPWR VGND sky130_ef_sc_hd__decap_12
X_4649_ _2449_ _2519_ _2523_ net137 VGND VGND VPWR VPWR _2524_ sky130_fd_sc_hd__o22a_1
XFILLER_116_693 VGND VGND VPWR VPWR sky130_fd_sc_hd__decap_6
XFILLER_89_522 VGND VGND VPWR VPWR sky130_fd_sc_hd__fill_2
XFILLER_115_181 VPWR VGND VPWR VGND sky130_ef_sc_hd__decap_12
X_6319_ clknet_leaf_46_clk _0727_ _0252_ VGND VGND VPWR VPWR reg_file_inst.registry\[8\]\[0\]
+ sky130_fd_sc_hd__dfrtp_1
XTAP_TAPCELL_ROW_73_1176 VGND VPWR sky130_fd_sc_hd__tapvpwrvgnd_1
XFILLER_39_45 VGND VGND VPWR VPWR sky130_fd_sc_hd__decap_8
XFILLER_39_67 VGND VGND VPWR VPWR sky130_fd_sc_hd__fill_1
XFILLER_91_208 VGND VGND VPWR VPWR sky130_fd_sc_hd__decap_3
XFILLER_69_290 VGND VGND VPWR VPWR sky130_fd_sc_hd__decap_4
XFILLER_72_411 VGND VGND VPWR VPWR sky130_fd_sc_hd__decap_3
XFILLER_57_474 VGND VGND VPWR VPWR sky130_fd_sc_hd__decap_4
XFILLER_72_455 VGND VGND VPWR VPWR sky130_fd_sc_hd__fill_2
XFILLER_72_433 VGND VGND VPWR VPWR sky130_fd_sc_hd__fill_1
XFILLER_17_349 VPWR VGND VPWR VGND sky130_ef_sc_hd__decap_12
XFILLER_72_499 VGND VGND VPWR VPWR sky130_fd_sc_hd__decap_4
XFILLER_72_477 VGND VGND VPWR VPWR sky130_fd_sc_hd__decap_3
XFILLER_72_466 VGND VGND VPWR VPWR sky130_fd_sc_hd__decap_8
XTAP_TAPCELL_ROW_43_804 VGND VPWR sky130_fd_sc_hd__tapvpwrvgnd_1
XFILLER_71_21 VGND VGND VPWR VPWR sky130_fd_sc_hd__fill_1
XFILLER_25_371 VGND VGND VPWR VPWR sky130_fd_sc_hd__decap_3
XFILLER_71_65 VGND VGND VPWR VPWR sky130_fd_sc_hd__fill_1
XFILLER_71_54 VGND VGND VPWR VPWR sky130_fd_sc_hd__fill_2
XTAP_TAPCELL_ROW_23_550 VGND VPWR sky130_fd_sc_hd__tapvpwrvgnd_1
XFILLER_40_352 VPWR VGND VPWR VGND sky130_ef_sc_hd__decap_12
XFILLER_5_721 VGND VGND VPWR VPWR sky130_fd_sc_hd__decap_4
XFILLER_107_671 VGND VGND VPWR VPWR sky130_fd_sc_hd__fill_1
XFILLER_4_253 VPWR VGND VPWR VGND sky130_ef_sc_hd__decap_12
XFILLER_20_91 VPWR VGND VPWR VGND sky130_ef_sc_hd__decap_12
XFILLER_122_685 VPWR VGND VPWR VGND sky130_ef_sc_hd__decap_12
XFILLER_83_709 VGND VGND VPWR VPWR sky130_fd_sc_hd__decap_6
XFILLER_36_614 VPWR VGND VPWR VGND sky130_ef_sc_hd__decap_12
XFILLER_48_485 VGND VGND VPWR VPWR sky130_fd_sc_hd__fill_1
XFILLER_51_617 VGND VGND VPWR VPWR sky130_fd_sc_hd__decap_3
X_3951_ _1841_ _1852_ VGND VGND VPWR VPWR _1867_ sky130_fd_sc_hd__or2_1
XFILLER_50_105 VGND VGND VPWR VPWR sky130_fd_sc_hd__fill_2
XFILLER_50_127 VGND VGND VPWR VPWR sky130_fd_sc_hd__decap_4
XFILLER_91_3 VPWR VGND VPWR VGND sky130_ef_sc_hd__decap_12
X_3882_ reg_file_inst.registry\[1\]\[2\] _1142_ _1798_ _1799_ _1800_ VGND VGND VPWR
+ VPWR _1801_ sky130_fd_sc_hd__a2111o_1
XFILLER_50_149 VPWR VGND VPWR VGND sky130_ef_sc_hd__decap_12
X_5621_ net149 VGND VGND VPWR VPWR _0029_ sky130_fd_sc_hd__inv_2
X_5552_ _2948_ reg_file_inst.registry\[9\]\[11\] _3002_ VGND VGND VPWR VPWR _0514_
+ sky130_fd_sc_hd__mux2_1
X_4503_ net137 _2385_ VGND VGND VPWR VPWR _2386_ sky130_fd_sc_hd__nand2_1
XFILLER_8_581 VGND VGND VPWR VPWR sky130_fd_sc_hd__decap_6
X_5483_ JMPOFF\[22\] _2817_ _3000_ VGND VGND VPWR VPWR _0581_ sky130_fd_sc_hd__mux2_1
X_4434_ _1778_ _1840_ _2190_ VGND VGND VPWR VPWR _2319_ sky130_fd_sc_hd__and3_1
XFILLER_113_641 VPWR VGND VPWR VGND sky130_ef_sc_hd__decap_12
X_4365_ net30 net43 _2127_ _2251_ VGND VGND VPWR VPWR _2253_ sky130_fd_sc_hd__and4_2
XFILLER_113_685 VPWR VGND VPWR VGND sky130_ef_sc_hd__decap_12
X_3316_ _1246_ _1254_ reg_file_inst.registry\[0\]\[22\] _1076_ VGND VGND VPWR VPWR
+ _1255_ sky130_fd_sc_hd__o2bb2a_2
X_6104_ clknet_leaf_27_clk _0512_ _0037_ VGND VGND VPWR VPWR reg_file_inst.registry\[9\]\[9\]
+ sky130_fd_sc_hd__dfrtp_1
XFILLER_112_195 VGND VGND VPWR VPWR sky130_fd_sc_hd__fill_1
X_6035_ net148 VGND VGND VPWR VPWR _0443_ sky130_fd_sc_hd__inv_2
X_4296_ _2183_ _1608_ _1582_ _1109_ VGND VGND VPWR VPWR _2184_ sky130_fd_sc_hd__and4b_1
XFILLER_100_368 VGND VGND VPWR VPWR sky130_fd_sc_hd__fill_2
X_3247_ reg_file_inst.registry\[9\]\[25\] _1131_ _1137_ reg_file_inst.registry\[2\]\[25\]
+ VGND VGND VPWR VPWR _1189_ sky130_fd_sc_hd__a22o_1
XFILLER_54_400 VGND VGND VPWR VPWR sky130_fd_sc_hd__decap_4
X_3178_ _1119_ _1121_ VGND VGND VPWR VPWR _1122_ sky130_fd_sc_hd__and2_4
XFILLER_27_614 VGND VGND VPWR VPWR sky130_fd_sc_hd__fill_2
XFILLER_39_463 VPWR VGND VPWR VGND sky130_ef_sc_hd__decap_12
XFILLER_54_455 VGND VGND VPWR VPWR sky130_fd_sc_hd__fill_1
XFILLER_26_135 VGND VGND VPWR VPWR sky130_fd_sc_hd__decap_4
XFILLER_27_669 VGND VGND VPWR VPWR sky130_fd_sc_hd__decap_3
XTAP_TAPCELL_ROW_1_278 VGND VPWR sky130_fd_sc_hd__tapvpwrvgnd_1
XFILLER_14_319 VPWR VGND VPWR VGND sky130_ef_sc_hd__decap_12
XTAP_TAPCELL_ROW_120_1759 VGND VPWR sky130_fd_sc_hd__tapvpwrvgnd_1
X_5819_ net148 VGND VGND VPWR VPWR _0227_ sky130_fd_sc_hd__inv_2
XFILLER_41_13 VGND VGND VPWR VPWR sky130_fd_sc_hd__fill_2
XFILLER_10_569 VPWR VGND VPWR VGND sky130_ef_sc_hd__decap_12
XTAP_TAPCELL_ROW_20_520 VGND VPWR sky130_fd_sc_hd__tapvpwrvgnd_1
XFILLER_41_57 VPWR VGND VPWR VGND sky130_ef_sc_hd__decap_12
XFILLER_108_413 VGND VGND VPWR VPWR sky130_fd_sc_hd__decap_6
XFILLER_108_457 VPWR VGND VPWR VGND sky130_ef_sc_hd__decap_12
XTAP_TAPCELL_ROW_75_1205 VGND VPWR sky130_fd_sc_hd__tapvpwrvgnd_1
XFILLER_2_713 VPWR VGND VPWR VGND sky130_ef_sc_hd__decap_12
XFILLER_103_140 VGND VGND VPWR VPWR sky130_fd_sc_hd__fill_2
XTAP_TAPCELL_ROW_9_378 VGND VPWR sky130_fd_sc_hd__tapvpwrvgnd_1
XFILLER_49_205 VPWR VGND VPWR VGND sky130_ef_sc_hd__decap_12
XFILLER_2_29 VPWR VGND VPWR VGND sky130_ef_sc_hd__decap_12
XFILLER_106_83 VGND VGND VPWR VPWR sky130_fd_sc_hd__fill_1
XFILLER_66_21 VGND VGND VPWR VPWR sky130_fd_sc_hd__decap_6
XFILLER_73_720 VGND VGND VPWR VPWR sky130_fd_sc_hd__decap_3
XFILLER_17_102 VGND VGND VPWR VPWR sky130_fd_sc_hd__decap_8
XTAP_TAPCELL_ROW_86_1345 VGND VPWR sky130_fd_sc_hd__tapvpwrvgnd_1
XTAP_TAPCELL_ROW_86_1334 VGND VPWR sky130_fd_sc_hd__tapvpwrvgnd_1
XFILLER_57_293 VPWR VGND VPWR VGND sky130_ef_sc_hd__decap_12
XFILLER_17_113 VGND VGND VPWR VPWR sky130_fd_sc_hd__decap_8
XFILLER_18_669 VGND VGND VPWR VPWR sky130_fd_sc_hd__decap_6
XTAP_TAPCELL_ROW_28_620 VGND VPWR sky130_fd_sc_hd__tapvpwrvgnd_1
XTAP_TAPCELL_ROW_56_962 VGND VPWR sky130_fd_sc_hd__tapvpwrvgnd_1
XFILLER_17_157 VGND VGND VPWR VPWR sky130_fd_sc_hd__decap_8
XFILLER_33_617 VPWR VGND VPWR VGND sky130_ef_sc_hd__decap_12
XFILLER_82_53 VGND VGND VPWR VPWR sky130_fd_sc_hd__decap_8
XFILLER_13_352 VGND VGND VPWR VPWR sky130_fd_sc_hd__fill_1
XTAP_TAPCELL_ROW_97_1474 VGND VPWR sky130_fd_sc_hd__tapvpwrvgnd_1
Xoutput119 net119 VGND VGND VPWR VPWR IC[25] sky130_fd_sc_hd__buf_1
XFILLER_56_6 VGND VGND VPWR VPWR sky130_fd_sc_hd__decap_6
XFILLER_5_573 VPWR VGND VPWR VGND sky130_ef_sc_hd__decap_12
Xoutput108 net108 VGND VGND VPWR VPWR IC[15] sky130_fd_sc_hd__buf_1
X_4150_ _2064_ net120 net130 VGND VGND VPWR VPWR _0948_ sky130_fd_sc_hd__mux2_1
Xoutput90 net90 VGND VGND VPWR VPWR DataMemoryWrite[25] sky130_fd_sc_hd__buf_1
X_3101_ JMPOFF\[14\] _0967_ VGND VGND VPWR VPWR _1045_ sky130_fd_sc_hd__nand2_1
X_4081_ net131 _1994_ _1995_ net111 VGND VGND VPWR VPWR _1997_ sky130_fd_sc_hd__a31o_1
XFILLER_110_699 VGND VGND VPWR VPWR sky130_fd_sc_hd__fill_1
X_3032_ _0973_ _0974_ _0975_ VGND VGND VPWR VPWR _0976_ sky130_fd_sc_hd__and3_1
XFILLER_36_400 VGND VGND VPWR VPWR sky130_fd_sc_hd__fill_2
XFILLER_91_561 VPWR VGND VPWR VGND sky130_ef_sc_hd__decap_12
XFILLER_63_252 VGND VGND VPWR VPWR sky130_fd_sc_hd__decap_4
XFILLER_36_477 VGND VGND VPWR VPWR sky130_fd_sc_hd__decap_3
XFILLER_36_488 VPWR VGND VPWR VGND sky130_ef_sc_hd__decap_12
XFILLER_51_425 VGND VGND VPWR VPWR sky130_fd_sc_hd__decap_6
X_4983_ net14 net101 net58 _2308_ VGND VGND VPWR VPWR _2829_ sky130_fd_sc_hd__a22o_4
XTAP_TAPCELL_ROW_106_1592 VGND VPWR sky130_fd_sc_hd__tapvpwrvgnd_1
XFILLER_16_190 VGND VGND VPWR VPWR sky130_fd_sc_hd__decap_6
X_3934_ reg_file_inst.registry\[1\]\[0\] _1142_ _1842_ _1849_ _1850_ VGND VGND VPWR
+ VPWR _1851_ sky130_fd_sc_hd__a2111o_1
XFILLER_32_672 VPWR VGND VPWR VGND sky130_ef_sc_hd__decap_12
XTAP_TAPCELL_ROW_34_689 VGND VPWR sky130_fd_sc_hd__tapvpwrvgnd_1
X_3865_ _1780_ _1781_ _1782_ _1783_ VGND VGND VPWR VPWR _1784_ sky130_fd_sc_hd__or4_2
X_5604_ net147 VGND VGND VPWR VPWR _0012_ sky130_fd_sc_hd__inv_2
X_3796_ reg_file_inst.registry\[4\]\[4\] _1134_ _1139_ reg_file_inst.registry\[5\]\[4\]
+ _1714_ VGND VGND VPWR VPWR _1718_ sky130_fd_sc_hd__a221o_1
XFILLER_11_27 VPWR VGND VPWR VGND sky130_ef_sc_hd__decap_12
X_5535_ _1128_ _2117_ _2120_ VGND VGND VPWR VPWR _3002_ sky130_fd_sc_hd__or3_4
X_5466_ reg_file_inst.registry\[5\]\[10\] _2960_ _2999_ VGND VGND VPWR VPWR _0597_
+ sky130_fd_sc_hd__mux2_1
XFILLER_105_449 VPWR VGND VPWR VGND sky130_ef_sc_hd__decap_12
X_4417_ _1151_ _2190_ VGND VGND VPWR VPWR _2305_ sky130_fd_sc_hd__nand2_1
XFILLER_120_419 VGND VGND VPWR VPWR sky130_fd_sc_hd__fill_1
X_5397_ reg_file_inst.registry\[4\]\[21\] _2829_ _2997_ VGND VGND VPWR VPWR _0664_
+ sky130_fd_sc_hd__mux2_1
XTAP_TAPCELL_ROW_70_1135 VGND VPWR sky130_fd_sc_hd__tapvpwrvgnd_1
XTAP_TAPCELL_ROW_6_337 VGND VPWR sky130_fd_sc_hd__tapvpwrvgnd_1
X_4348_ _1151_ _1765_ VGND VGND VPWR VPWR _2236_ sky130_fd_sc_hd__nor2_1
X_4279_ _2154_ _2166_ VGND VGND VPWR VPWR _2167_ sky130_fd_sc_hd__nand2b_1
X_6018_ net44 VGND VGND VPWR VPWR _0426_ sky130_fd_sc_hd__inv_2
XFILLER_100_165 VGND VGND VPWR VPWR sky130_fd_sc_hd__decap_6
XFILLER_27_400 VGND VGND VPWR VPWR sky130_fd_sc_hd__decap_8
XFILLER_39_260 VGND VGND VPWR VPWR sky130_fd_sc_hd__fill_2
XFILLER_27_444 VGND VGND VPWR VPWR sky130_fd_sc_hd__decap_4
XFILLER_39_293 VGND VGND VPWR VPWR sky130_fd_sc_hd__decap_4
XFILLER_70_701 VGND VGND VPWR VPWR sky130_fd_sc_hd__decap_4
XFILLER_15_617 VPWR VGND VPWR VGND sky130_ef_sc_hd__decap_12
XFILLER_82_583 VGND VGND VPWR VPWR sky130_fd_sc_hd__decap_4
XTAP_TAPCELL_ROW_53_932 VGND VPWR sky130_fd_sc_hd__tapvpwrvgnd_1
XTAP_TAPCELL_ROW_53_921 VGND VPWR sky130_fd_sc_hd__tapvpwrvgnd_1
XFILLER_27_488 VGND VGND VPWR VPWR sky130_fd_sc_hd__decap_6
XFILLER_52_23 VGND VGND VPWR VPWR sky130_fd_sc_hd__decap_4
XFILLER_14_149 VGND VGND VPWR VPWR sky130_fd_sc_hd__decap_3
XTAP_TAPCELL_ROW_81_1275 VGND VPWR sky130_fd_sc_hd__tapvpwrvgnd_1
XFILLER_108_221 VPWR VGND VPWR VGND sky130_ef_sc_hd__decap_12
XFILLER_108_265 VPWR VGND VPWR VGND sky130_ef_sc_hd__decap_12
XFILLER_117_93 VPWR VGND VPWR VGND sky130_ef_sc_hd__decap_12
XFILLER_104_471 VGND VGND VPWR VPWR sky130_fd_sc_hd__fill_1
XFILLER_77_42 VGND VGND VPWR VPWR sky130_fd_sc_hd__decap_3
XFILLER_2_587 VGND VGND VPWR VPWR sky130_fd_sc_hd__fill_1
XFILLER_65_517 VGND VGND VPWR VPWR sky130_fd_sc_hd__fill_2
XFILLER_93_63 VGND VGND VPWR VPWR sky130_fd_sc_hd__fill_1
XFILLER_93_52 VGND VGND VPWR VPWR sky130_fd_sc_hd__decap_4
XFILLER_73_572 VGND VGND VPWR VPWR sky130_fd_sc_hd__decap_8
XFILLER_61_712 VGND VGND VPWR VPWR sky130_fd_sc_hd__decap_4
XFILLER_18_466 VGND VGND VPWR VPWR sky130_fd_sc_hd__fill_1
XFILLER_18_477 VPWR VGND VPWR VGND sky130_ef_sc_hd__decap_12
XFILLER_45_263 VGND VGND VPWR VPWR sky130_fd_sc_hd__fill_2
XFILLER_60_222 VPWR VGND VPWR VGND sky130_ef_sc_hd__decap_12
XFILLER_45_274 VGND VGND VPWR VPWR sky130_fd_sc_hd__decap_6
XFILLER_33_447 VGND VGND VPWR VPWR sky130_fd_sc_hd__fill_1
XFILLER_14_661 VGND VGND VPWR VPWR sky130_fd_sc_hd__fill_1
XTAP_TAPCELL_ROW_99_1503 VGND VPWR sky130_fd_sc_hd__tapvpwrvgnd_1
XTAP_TAPCELL_ROW_31_648 VGND VPWR sky130_fd_sc_hd__tapvpwrvgnd_1
XFILLER_41_480 VGND VGND VPWR VPWR sky130_fd_sc_hd__fill_2
X_3650_ reg_file_inst.registry\[4\]\[9\] _1092_ _1570_ _1575_ VGND VGND VPWR VPWR
+ _1576_ sky130_fd_sc_hd__a211oi_1
X_3581_ reg_file_inst.registry\[14\]\[14\] _1138_ _1508_ _1509_ VGND VGND VPWR VPWR
+ _1510_ sky130_fd_sc_hd__a211o_1
XFILLER_115_725 VGND VGND VPWR VPWR sky130_fd_sc_hd__fill_1
XFILLER_54_3 VPWR VGND VPWR VGND sky130_ef_sc_hd__decap_12
X_5320_ _2948_ reg_file_inst.registry\[8\]\[11\] _2994_ VGND VGND VPWR VPWR _0738_
+ sky130_fd_sc_hd__mux2_1
X_5251_ reg_file_inst.registry\[14\]\[22\] _2817_ _2992_ VGND VGND VPWR VPWR _0805_
+ sky130_fd_sc_hd__mux2_1
X_4202_ _1937_ _1973_ _1933_ VGND VGND VPWR VPWR _2099_ sky130_fd_sc_hd__o21bai_1
X_5182_ _2806_ reg_file_inst.registry\[0\]\[23\] _2988_ VGND VGND VPWR VPWR _0870_
+ sky130_fd_sc_hd__mux2_1
XFILLER_95_130 VPWR VGND VPWR VGND sky130_ef_sc_hd__decap_12
X_4133_ net117 _2043_ VGND VGND VPWR VPWR _2049_ sky130_fd_sc_hd__xor2_1
XFILLER_68_333 VGND VGND VPWR VPWR sky130_fd_sc_hd__decap_6
XTAP_TAPCELL_ROW_3_307 VGND VPWR sky130_fd_sc_hd__tapvpwrvgnd_1
X_4064_ _1878_ _1978_ net129 VGND VGND VPWR VPWR _1980_ sky130_fd_sc_hd__a21o_1
XTAP_TAPCELL_ROW_108_1610 VGND VPWR sky130_fd_sc_hd__tapvpwrvgnd_1
X_3015_ net149 VGND VGND VPWR VPWR _0000_ sky130_fd_sc_hd__inv_2
XTAP_TAPCELL_ROW_39_748 VGND VPWR sky130_fd_sc_hd__tapvpwrvgnd_1
XFILLER_64_561 VGND VGND VPWR VPWR sky130_fd_sc_hd__decap_4
XFILLER_52_701 VPWR VGND VPWR VGND sky130_ef_sc_hd__decap_12
XFILLER_51_244 VPWR VGND VPWR VGND sky130_ef_sc_hd__decap_12
XFILLER_24_469 VGND VGND VPWR VPWR sky130_fd_sc_hd__decap_6
X_4966_ _2323_ _2801_ _2810_ _2814_ VGND VGND VPWR VPWR _2815_ sky130_fd_sc_hd__a211o_1
X_4897_ _1185_ _2124_ _2287_ _1196_ _2289_ VGND VGND VPWR VPWR _2752_ sky130_fd_sc_hd__o221a_1
X_3917_ JMPOFF\[0\] _1095_ _1097_ reg_file_inst.registry\[5\]\[0\] _1828_ VGND VGND
+ VPWR VPWR _1834_ sky130_fd_sc_hd__a221o_2
X_3848_ reg_file_inst.registry\[1\]\[3\] net145 _1127_ VGND VGND VPWR VPWR _1768_
+ sky130_fd_sc_hd__and3_1
XTAP_TAPCELL_ROW_119_1750 VGND VPWR sky130_fd_sc_hd__tapvpwrvgnd_1
X_3779_ reg_file_inst.registry\[2\]\[4\] _1080_ _1082_ VGND VGND VPWR VPWR _1701_
+ sky130_fd_sc_hd__and3_1
XFILLER_106_725 VGND VGND VPWR VPWR sky130_fd_sc_hd__fill_1
X_5518_ reg_file_inst.registry\[6\]\[16\] _2883_ _3001_ VGND VGND VPWR VPWR _0547_
+ sky130_fd_sc_hd__mux2_1
X_6498_ clknet_leaf_23_clk _0906_ _0431_ VGND VGND VPWR VPWR reg_file_inst.registry\[11\]\[27\]
+ sky130_fd_sc_hd__dfrtp_1
X_5449_ reg_file_inst.registry\[5\]\[27\] _2715_ _2999_ VGND VGND VPWR VPWR _0614_
+ sky130_fd_sc_hd__mux2_1
XFILLER_105_279 VGND VGND VPWR VPWR sky130_fd_sc_hd__fill_1
XFILLER_87_653 VPWR VGND VPWR VGND sky130_ef_sc_hd__decap_12
XFILLER_86_141 VGND VGND VPWR VPWR sky130_fd_sc_hd__decap_8
XFILLER_59_333 VGND VGND VPWR VPWR sky130_fd_sc_hd__decap_3
XFILLER_87_697 VPWR VGND VPWR VGND sky130_ef_sc_hd__decap_12
XFILLER_47_517 VPWR VGND VPWR VGND sky130_ef_sc_hd__decap_12
XFILLER_103_51 VGND VGND VPWR VPWR sky130_fd_sc_hd__decap_4
XFILLER_55_561 VPWR VGND VPWR VGND sky130_ef_sc_hd__decap_12
XTAP_TAPCELL_ROW_83_1304 VGND VPWR sky130_fd_sc_hd__tapvpwrvgnd_1
XFILLER_42_211 VPWR VGND VPWR VGND sky130_ef_sc_hd__decap_12
XFILLER_43_712 VGND VGND VPWR VPWR sky130_fd_sc_hd__decap_8
XFILLER_63_99 VPWR VGND VPWR VGND sky130_ef_sc_hd__decap_12
XFILLER_109_541 VPWR VGND VPWR VGND sky130_ef_sc_hd__decap_12
XFILLER_109_585 VPWR VGND VPWR VGND sky130_ef_sc_hd__decap_12
XFILLER_6_156 VPWR VGND VPWR VGND sky130_ef_sc_hd__decap_12
XTAP_TAPCELL_ROW_94_1444 VGND VPWR sky130_fd_sc_hd__tapvpwrvgnd_1
XTAP_TAPCELL_ROW_94_1433 VGND VPWR sky130_fd_sc_hd__tapvpwrvgnd_1
XFILLER_6_189 VGND VGND VPWR VPWR sky130_fd_sc_hd__decap_6
XFILLER_111_205 VPWR VGND VPWR VGND sky130_ef_sc_hd__decap_12
XFILLER_97_428 VPWR VGND VPWR VGND sky130_ef_sc_hd__decap_12
XFILLER_2_362 VGND VGND VPWR VPWR sky130_fd_sc_hd__fill_2
XFILLER_111_249 VPWR VGND VPWR VGND sky130_ef_sc_hd__decap_12
XFILLER_93_601 VPWR VGND VPWR VGND sky130_ef_sc_hd__decap_12
XFILLER_92_133 VGND VGND VPWR VPWR sky130_fd_sc_hd__decap_6
XFILLER_92_166 VPWR VGND VPWR VGND sky130_ef_sc_hd__decap_12
XFILLER_34_701 VGND VGND VPWR VPWR sky130_fd_sc_hd__decap_4
XTAP_TAPCELL_ROW_36_718 VGND VPWR sky130_fd_sc_hd__tapvpwrvgnd_1
XFILLER_46_550 VGND VGND VPWR VPWR sky130_fd_sc_hd__fill_1
XFILLER_80_339 VGND VGND VPWR VPWR sky130_fd_sc_hd__decap_3
X_4820_ _2570_ _2676_ _2678_ VGND VGND VPWR VPWR _2679_ sky130_fd_sc_hd__o21a_1
XTAP_TAPCELL_ROW_103_1551 VGND VPWR sky130_fd_sc_hd__tapvpwrvgnd_1
XTAP_TAPCELL_ROW_16_464 VGND VPWR sky130_fd_sc_hd__tapvpwrvgnd_1
XFILLER_33_266 VGND VGND VPWR VPWR sky130_fd_sc_hd__fill_1
XPHY_EDGE_ROW_78_Left_201 VGND VGND VPWR VPWR sky130_fd_sc_hd__decap_3
X_4751_ _2127_ _2554_ VGND VGND VPWR VPWR _2610_ sky130_fd_sc_hd__nand2_1
XFILLER_119_305 VPWR VGND VPWR VGND sky130_ef_sc_hd__decap_12
X_4682_ _2419_ reg_file_inst.registry\[11\]\[13\] _2118_ VGND VGND VPWR VPWR _0912_
+ sky130_fd_sc_hd__mux2_1
X_3702_ _1623_ _1624_ _1625_ _1519_ VGND VGND VPWR VPWR _1626_ sky130_fd_sc_hd__a31o_1
XFILLER_119_349 VPWR VGND VPWR VGND sky130_ef_sc_hd__decap_12
X_6421_ clknet_leaf_14_clk _0829_ _0354_ VGND VGND VPWR VPWR reg_file_inst.registry\[1\]\[18\]
+ sky130_fd_sc_hd__dfrtp_1
X_3633_ reg_file_inst.registry\[15\]\[10\] _1122_ _1133_ reg_file_inst.registry\[7\]\[10\]
+ _1117_ VGND VGND VPWR VPWR _1560_ sky130_fd_sc_hd__a221o_1
XFILLER_108_29 VPWR VGND VPWR VGND sky130_ef_sc_hd__decap_12
XFILLER_108_18 VGND VGND VPWR VPWR sky130_fd_sc_hd__decap_8
X_6352_ clknet_leaf_28_clk _0760_ _0285_ VGND VGND VPWR VPWR reg_file_inst.registry\[2\]\[5\]
+ sky130_fd_sc_hd__dfrtp_1
X_3564_ _1480_ _1492_ VGND VGND VPWR VPWR _1493_ sky130_fd_sc_hd__or2_1
XFILLER_103_717 VGND VGND VPWR VPWR sky130_fd_sc_hd__decap_3
X_6283_ clknet_leaf_28_clk _0691_ _0216_ VGND VGND VPWR VPWR MEMOFF\[20\] sky130_fd_sc_hd__dfrtp_1
X_3495_ reg_file_inst.registry\[8\]\[12\] _1090_ _1091_ reg_file_inst.registry\[3\]\[12\]
+ VGND VGND VPWR VPWR _1427_ sky130_fd_sc_hd__a22o_1
X_5303_ _1115_ _2117_ _2120_ VGND VGND VPWR VPWR _2994_ sky130_fd_sc_hd__or3_4
XTAP_TAPCELL_ROW_114_1691 VGND VPWR sky130_fd_sc_hd__tapvpwrvgnd_1
XFILLER_102_205 VGND VGND VPWR VPWR sky130_fd_sc_hd__decap_3
XFILLER_88_417 VGND VGND VPWR VPWR sky130_fd_sc_hd__decap_3
XPHY_EDGE_ROW_87_Left_210 VGND VGND VPWR VPWR sky130_fd_sc_hd__decap_3
XFILLER_69_620 VGND VGND VPWR VPWR sky130_fd_sc_hd__decap_8
X_5234_ _2974_ reg_file_inst.registry\[1\]\[9\] _2990_ VGND VGND VPWR VPWR _0820_
+ sky130_fd_sc_hd__mux2_1
X_5165_ _2176_ _2619_ _2975_ _2985_ VGND VGND VPWR VPWR net71 sky130_fd_sc_hd__a31o_2
XFILLER_68_141 VGND VGND VPWR VPWR sky130_fd_sc_hd__decap_8
X_4116_ net115 _2031_ VGND VGND VPWR VPWR _2032_ sky130_fd_sc_hd__and2_1
XFILLER_29_517 VPWR VGND VPWR VGND sky130_ef_sc_hd__decap_12
XFILLER_84_645 VPWR VGND VPWR VGND sky130_ef_sc_hd__decap_12
X_5096_ _1433_ _2124_ VGND VGND VPWR VPWR _2925_ sky130_fd_sc_hd__nor2_1
X_4047_ _1951_ _1962_ VGND VGND VPWR VPWR _1963_ sky130_fd_sc_hd__nand2b_1
XFILLER_17_15 VPWR VGND VPWR VGND sky130_ef_sc_hd__decap_12
XFILLER_37_550 VGND VGND VPWR VPWR sky130_fd_sc_hd__decap_8
XFILLER_37_561 VGND VGND VPWR VPWR sky130_fd_sc_hd__fill_2
XFILLER_52_520 VPWR VGND VPWR VGND sky130_ef_sc_hd__decap_12
XFILLER_37_572 VGND VGND VPWR VPWR sky130_fd_sc_hd__decap_8
XFILLER_24_233 VPWR VGND VPWR VGND sky130_ef_sc_hd__decap_12
XTAP_TAPCELL_ROW_65_1078 VGND VPWR sky130_fd_sc_hd__tapvpwrvgnd_1
XFILLER_52_586 VGND VGND VPWR VPWR sky130_fd_sc_hd__fill_2
XFILLER_12_417 VGND VGND VPWR VPWR sky130_fd_sc_hd__decap_3
X_5998_ net148 VGND VGND VPWR VPWR _0406_ sky130_fd_sc_hd__inv_2
X_4949_ _2688_ _2709_ _1791_ VGND VGND VPWR VPWR _2800_ sky130_fd_sc_hd__mux2_1
XFILLER_24_299 VGND VGND VPWR VPWR sky130_fd_sc_hd__decap_8
XFILLER_33_69 VPWR VGND VPWR VGND sky130_ef_sc_hd__decap_12
XFILLER_106_533 VPWR VGND VPWR VGND sky130_ef_sc_hd__decap_12
XFILLER_121_503 VGND VGND VPWR VPWR sky130_fd_sc_hd__fill_1
XFILLER_58_11 VGND VGND VPWR VPWR sky130_fd_sc_hd__fill_2
XFILLER_87_461 VPWR VGND VPWR VGND sky130_ef_sc_hd__decap_12
XFILLER_58_66 VGND VGND VPWR VPWR sky130_fd_sc_hd__decap_3
XFILLER_101_260 VPWR VGND VPWR VGND sky130_ef_sc_hd__decap_12
XFILLER_74_100 VPWR VGND VPWR VGND sky130_ef_sc_hd__decap_12
XFILLER_47_325 VGND VGND VPWR VPWR sky130_fd_sc_hd__decap_8
XFILLER_114_83 VGND VGND VPWR VPWR sky130_fd_sc_hd__fill_1
XFILLER_16_701 VGND VGND VPWR VPWR sky130_fd_sc_hd__decap_4
XFILLER_47_369 VGND VGND VPWR VPWR sky130_fd_sc_hd__decap_3
XFILLER_90_637 VGND VGND VPWR VPWR sky130_fd_sc_hd__decap_6
XFILLER_74_177 VPWR VGND VPWR VGND sky130_ef_sc_hd__decap_12
XFILLER_74_65 VPWR VGND VPWR VGND sky130_ef_sc_hd__decap_12
XFILLER_15_211 VPWR VGND VPWR VGND sky130_ef_sc_hd__decap_12
XFILLER_15_266 VPWR VGND VPWR VGND sky130_ef_sc_hd__decap_12
XTAP_TAPCELL_ROW_13_423 VGND VPWR sky130_fd_sc_hd__tapvpwrvgnd_1
XFILLER_30_225 VPWR VGND VPWR VGND sky130_ef_sc_hd__decap_12
XFILLER_30_269 VPWR VGND VPWR VGND sky130_ef_sc_hd__decap_12
XTAP_TAPCELL_ROW_41_776 VGND VPWR sky130_fd_sc_hd__tapvpwrvgnd_1
XFILLER_7_421 VGND VGND VPWR VPWR sky130_fd_sc_hd__decap_8
XFILLER_23_91 VPWR VGND VPWR VGND sky130_ef_sc_hd__decap_12
XFILLER_11_494 VGND VGND VPWR VPWR sky130_fd_sc_hd__fill_1
XFILLER_109_393 VPWR VGND VPWR VGND sky130_ef_sc_hd__decap_12
XFILLER_99_51 VGND VGND VPWR VPWR sky130_fd_sc_hd__decap_4
XFILLER_112_525 VGND VGND VPWR VPWR sky130_fd_sc_hd__decap_6
XFILLER_3_671 VGND VGND VPWR VPWR sky130_fd_sc_hd__fill_1
X_3280_ _1218_ _1219_ VGND VGND VPWR VPWR _1220_ sky130_fd_sc_hd__and2_1
XFILLER_112_569 VPWR VGND VPWR VGND sky130_ef_sc_hd__decap_12
XFILLER_65_111 VGND VGND VPWR VPWR sky130_fd_sc_hd__fill_1
XFILLER_17_3 VPWR VGND VPWR VGND sky130_ef_sc_hd__decap_12
XTAP_TAPCELL_ROW_49_876 VGND VPWR sky130_fd_sc_hd__tapvpwrvgnd_1
X_5921_ net146 VGND VGND VPWR VPWR _0329_ sky130_fd_sc_hd__inv_2
XFILLER_65_177 VGND VGND VPWR VPWR sky130_fd_sc_hd__decap_4
XFILLER_19_561 VPWR VGND VPWR VGND sky130_ef_sc_hd__decap_12
XFILLER_34_531 VGND VGND VPWR VPWR sky130_fd_sc_hd__fill_1
XFILLER_46_380 VGND VGND VPWR VPWR sky130_fd_sc_hd__fill_1
XFILLER_61_372 VPWR VGND VPWR VGND sky130_ef_sc_hd__decap_12
XFILLER_22_715 VGND VGND VPWR VPWR sky130_fd_sc_hd__decap_3
XFILLER_34_586 VGND VGND VPWR VPWR sky130_fd_sc_hd__fill_2
X_5852_ net146 VGND VGND VPWR VPWR _0260_ sky130_fd_sc_hd__inv_2
X_5783_ net146 VGND VGND VPWR VPWR _0191_ sky130_fd_sc_hd__inv_2
X_4803_ _2660_ _2661_ VGND VGND VPWR VPWR _2662_ sky130_fd_sc_hd__nand2_1
XFILLER_21_225 VGND VGND VPWR VPWR sky130_fd_sc_hd__decap_8
X_4734_ _2591_ _2592_ VGND VGND VPWR VPWR _2593_ sky130_fd_sc_hd__nor2_1
XFILLER_21_258 VGND VGND VPWR VPWR sky130_fd_sc_hd__decap_4
XFILLER_119_113 VPWR VGND VPWR VGND sky130_ef_sc_hd__decap_12
XFILLER_119_39 VPWR VGND VPWR VGND sky130_ef_sc_hd__decap_12
X_4665_ _2279_ _2537_ _2536_ VGND VGND VPWR VPWR _2538_ sky130_fd_sc_hd__a21bo_1
XTAP_TAPCELL_ROW_116_1720 VGND VPWR sky130_fd_sc_hd__tapvpwrvgnd_1
X_3616_ reg_file_inst.registry\[15\]\[10\] _1093_ _1094_ reg_file_inst.registry\[6\]\[10\]
+ VGND VGND VPWR VPWR _1543_ sky130_fd_sc_hd__a22o_1
X_4596_ _2192_ _2465_ _2474_ _2249_ _2255_ VGND VGND VPWR VPWR _2475_ sky130_fd_sc_hd__o221a_1
X_6404_ clknet_leaf_60_clk _0812_ _0337_ VGND VGND VPWR VPWR reg_file_inst.registry\[1\]\[1\]
+ sky130_fd_sc_hd__dfrtp_1
X_6335_ clknet_leaf_17_clk _0743_ _0268_ VGND VGND VPWR VPWR reg_file_inst.registry\[8\]\[16\]
+ sky130_fd_sc_hd__dfrtp_1
X_3547_ reg_file_inst.registry\[2\]\[15\] _1083_ _1089_ reg_file_inst.registry\[9\]\[15\]
+ VGND VGND VPWR VPWR _1477_ sky130_fd_sc_hd__a22o_1
XFILLER_115_385 VGND VGND VPWR VPWR sky130_fd_sc_hd__decap_6
X_3478_ MEMOFF\[17\] _1129_ _1139_ reg_file_inst.registry\[5\]\[17\] _1117_ VGND VGND
+ VPWR VPWR _1411_ sky130_fd_sc_hd__a221o_1
X_6266_ clknet_leaf_60_clk _0674_ _0199_ VGND VGND VPWR VPWR MEMOFF\[3\] sky130_fd_sc_hd__dfrtp_1
X_5217_ _2747_ reg_file_inst.registry\[1\]\[26\] _2990_ VGND VGND VPWR VPWR _0837_
+ sky130_fd_sc_hd__mux2_1
XFILLER_88_269 VGND VGND VPWR VPWR sky130_fd_sc_hd__fill_1
X_6197_ clknet_leaf_9_clk _0605_ _0130_ VGND VGND VPWR VPWR reg_file_inst.registry\[5\]\[18\]
+ sky130_fd_sc_hd__dfrtp_1
X_5148_ _2277_ _2765_ _2965_ _2966_ VGND VGND VPWR VPWR _2971_ sky130_fd_sc_hd__a22o_1
XTAP_TAPCELL_ROW_67_1107 VGND VPWR sky130_fd_sc_hd__tapvpwrvgnd_1
X_5079_ _2630_ _2633_ _2648_ VGND VGND VPWR VPWR _2910_ sky130_fd_sc_hd__nand3_1
XFILLER_29_369 VPWR VGND VPWR VGND sky130_ef_sc_hd__decap_12
XFILLER_84_475 VGND VGND VPWR VPWR sky130_fd_sc_hd__fill_1
XFILLER_56_177 VPWR VGND VPWR VGND sky130_ef_sc_hd__decap_12
XFILLER_71_125 VPWR VGND VPWR VGND sky130_ef_sc_hd__decap_12
XFILLER_25_520 VGND VGND VPWR VPWR sky130_fd_sc_hd__decap_4
XFILLER_37_391 VGND VGND VPWR VPWR sky130_fd_sc_hd__fill_1
XFILLER_80_670 VGND VGND VPWR VPWR sky130_fd_sc_hd__fill_1
XFILLER_71_169 VPWR VGND VPWR VGND sky130_ef_sc_hd__decap_12
XFILLER_40_545 VPWR VGND VPWR VGND sky130_ef_sc_hd__decap_12
XFILLER_100_41 VPWR VGND VPWR VGND sky130_ef_sc_hd__decap_12
XFILLER_40_589 VPWR VGND VPWR VGND sky130_ef_sc_hd__decap_12
XFILLER_121_3 VPWR VGND VPWR VGND sky130_ef_sc_hd__decap_12
XTAP_TAPCELL_ROW_78_1236 VGND VPWR sky130_fd_sc_hd__tapvpwrvgnd_1
XTAP_TAPCELL_ROW_91_1403 VGND VPWR sky130_fd_sc_hd__tapvpwrvgnd_1
XFILLER_106_363 VGND VGND VPWR VPWR sky130_fd_sc_hd__fill_1
XFILLER_79_225 VGND VGND VPWR VPWR sky130_fd_sc_hd__decap_3
XFILLER_48_601 VGND VGND VPWR VPWR sky130_fd_sc_hd__decap_6
XFILLER_48_645 VPWR VGND VPWR VGND sky130_ef_sc_hd__decap_12
XFILLER_90_401 VGND VGND VPWR VPWR sky130_fd_sc_hd__fill_1
XTAP_TAPCELL_ROW_89_1376 VGND VPWR sky130_fd_sc_hd__tapvpwrvgnd_1
XFILLER_63_615 VGND VGND VPWR VPWR sky130_fd_sc_hd__fill_1
XFILLER_16_531 VGND VGND VPWR VPWR sky130_fd_sc_hd__fill_1
XFILLER_16_542 VGND VGND VPWR VPWR sky130_fd_sc_hd__decap_8
XTAP_TAPCELL_ROW_46_835 VGND VPWR sky130_fd_sc_hd__tapvpwrvgnd_1
XFILLER_71_670 VGND VGND VPWR VPWR sky130_fd_sc_hd__fill_2
XFILLER_50_309 VGND VGND VPWR VPWR sky130_fd_sc_hd__decap_8
XTAP_TAPCELL_ROW_100_1510 VGND VPWR sky130_fd_sc_hd__tapvpwrvgnd_1
XFILLER_71_692 VGND VGND VPWR VPWR sky130_fd_sc_hd__fill_1
XTAP_TAPCELL_ROW_26_592 VGND VPWR sky130_fd_sc_hd__tapvpwrvgnd_1
XFILLER_117_617 VPWR VGND VPWR VGND sky130_ef_sc_hd__decap_12
X_4450_ net132 _2221_ VGND VGND VPWR VPWR _2335_ sky130_fd_sc_hd__nor2_1
X_3401_ reg_file_inst.registry\[9\]\[19\] net144 _1127_ VGND VGND VPWR VPWR _1337_
+ sky130_fd_sc_hd__and3_1
X_4381_ _2266_ _2268_ VGND VGND VPWR VPWR _2269_ sky130_fd_sc_hd__or2_1
X_6120_ clknet_leaf_22_clk _0528_ _0053_ VGND VGND VPWR VPWR reg_file_inst.registry\[9\]\[25\]
+ sky130_fd_sc_hd__dfrtp_1
X_3332_ reg_file_inst.registry\[8\]\[21\] _1090_ _1098_ reg_file_inst.registry\[10\]\[21\]
+ VGND VGND VPWR VPWR _1270_ sky130_fd_sc_hd__a22o_1
XFILLER_112_333 VPWR VGND VPWR VGND sky130_ef_sc_hd__decap_12
XFILLER_98_545 VGND VGND VPWR VPWR sky130_fd_sc_hd__fill_1
XFILLER_112_377 VPWR VGND VPWR VGND sky130_ef_sc_hd__decap_12
XTAP_TAPCELL_ROW_111_1650 VGND VPWR sky130_fd_sc_hd__tapvpwrvgnd_1
XFILLER_98_589 VPWR VGND VPWR VGND sky130_ef_sc_hd__decap_12
XFILLER_98_578 VGND VGND VPWR VPWR sky130_fd_sc_hd__decap_8
X_3263_ reg_file_inst.registry\[6\]\[24\] _1094_ _1203_ _1075_ VGND VGND VPWR VPWR
+ _1204_ sky130_fd_sc_hd__a211o_1
X_6051_ net146 VGND VGND VPWR VPWR _0459_ sky130_fd_sc_hd__inv_2
XFILLER_39_601 VPWR VGND VPWR VGND sky130_ef_sc_hd__decap_12
X_3194_ net36 net37 _1123_ net34 VGND VGND VPWR VPWR _1138_ sky130_fd_sc_hd__a31o_4
X_5002_ _2658_ _2660_ _2844_ VGND VGND VPWR VPWR _2845_ sky130_fd_sc_hd__nand3_1
XFILLER_93_261 VPWR VGND VPWR VGND sky130_ef_sc_hd__decap_12
XFILLER_54_626 VPWR VGND VPWR VGND sky130_ef_sc_hd__decap_12
XFILLER_26_317 VGND VGND VPWR VPWR sky130_fd_sc_hd__decap_3
XFILLER_38_166 VPWR VGND VPWR VGND sky130_ef_sc_hd__decap_12
XFILLER_19_380 VPWR VGND VPWR VGND sky130_ef_sc_hd__decap_12
XFILLER_53_169 VPWR VGND VPWR VGND sky130_ef_sc_hd__decap_12
XFILLER_53_158 VGND VGND VPWR VPWR sky130_fd_sc_hd__decap_8
XFILLER_22_501 VPWR VGND VPWR VGND sky130_ef_sc_hd__decap_12
X_5904_ net146 VGND VGND VPWR VPWR _0312_ sky130_fd_sc_hd__inv_2
XFILLER_34_361 VGND VGND VPWR VPWR sky130_fd_sc_hd__decap_3
Xclkbuf_3_5__f_clk clknet_0_clk VGND VGND VPWR VPWR clknet_3_5__leaf_clk sky130_fd_sc_hd__clkbuf_16
X_5835_ net147 VGND VGND VPWR VPWR _0243_ sky130_fd_sc_hd__inv_2
XTAP_TAPCELL_ROW_62_1037 VGND VPWR sky130_fd_sc_hd__tapvpwrvgnd_1
XFILLER_14_27 VGND VGND VPWR VPWR sky130_fd_sc_hd__fill_1
XTAP_TAPCELL_ROW_122_1790 VGND VPWR sky130_fd_sc_hd__tapvpwrvgnd_1
XFILLER_22_545 VPWR VGND VPWR VGND sky130_ef_sc_hd__decap_12
XFILLER_22_589 VPWR VGND VPWR VGND sky130_ef_sc_hd__decap_12
X_5766_ net148 VGND VGND VPWR VPWR _0174_ sky130_fd_sc_hd__inv_2
X_5697_ net146 VGND VGND VPWR VPWR _0105_ sky130_fd_sc_hd__inv_2
X_4717_ _2575_ VGND VGND VPWR VPWR _2576_ sky130_fd_sc_hd__inv_2
XFILLER_107_105 VGND VGND VPWR VPWR sky130_fd_sc_hd__decap_6
X_4648_ _2245_ _2397_ _2243_ VGND VGND VPWR VPWR _2523_ sky130_fd_sc_hd__o21a_1
XPHY_EDGE_ROW_15_Left_138 VGND VGND VPWR VPWR sky130_fd_sc_hd__decap_3
XFILLER_107_149 VPWR VGND VPWR VGND sky130_ef_sc_hd__decap_12
XFILLER_100_8 VPWR VGND VPWR VGND sky130_ef_sc_hd__decap_12
X_4579_ _2456_ _2457_ _1765_ VGND VGND VPWR VPWR _2458_ sky130_fd_sc_hd__mux2_1
XFILLER_115_193 VPWR VGND VPWR VGND sky130_ef_sc_hd__decap_12
X_6318_ clknet_leaf_17_clk _0726_ _0251_ VGND VGND VPWR VPWR reg_file_inst.registry\[3\]\[27\]
+ sky130_fd_sc_hd__dfrtp_1
XTAP_TAPCELL_ROW_73_1177 VGND VPWR sky130_fd_sc_hd__tapvpwrvgnd_1
X_6249_ clknet_leaf_10_clk _0657_ _0182_ VGND VGND VPWR VPWR reg_file_inst.registry\[4\]\[14\]
+ sky130_fd_sc_hd__dfrtp_1
XFILLER_39_57 VGND VGND VPWR VPWR sky130_fd_sc_hd__fill_1
XFILLER_76_239 VPWR VGND VPWR VGND sky130_ef_sc_hd__decap_12
XFILLER_76_217 VGND VGND VPWR VPWR sky130_fd_sc_hd__fill_1
XPHY_EDGE_ROW_24_Left_147 VGND VGND VPWR VPWR sky130_fd_sc_hd__decap_3
XFILLER_72_489 VGND VGND VPWR VPWR sky130_fd_sc_hd__decap_3
XFILLER_53_670 VGND VGND VPWR VPWR sky130_fd_sc_hd__fill_2
XTAP_TAPCELL_ROW_43_805 VGND VPWR sky130_fd_sc_hd__tapvpwrvgnd_1
XFILLER_111_51 VGND VGND VPWR VPWR sky130_fd_sc_hd__decap_4
XFILLER_53_681 VGND VGND VPWR VPWR sky130_fd_sc_hd__decap_3
XFILLER_13_512 VGND VGND VPWR VPWR sky130_fd_sc_hd__fill_1
XFILLER_9_505 VPWR VGND VPWR VGND sky130_ef_sc_hd__decap_12
XTAP_TAPCELL_ROW_23_551 VGND VPWR sky130_fd_sc_hd__tapvpwrvgnd_1
XPHY_EDGE_ROW_33_Left_156 VGND VGND VPWR VPWR sky130_fd_sc_hd__decap_3
XFILLER_4_221 VPWR VGND VPWR VGND sky130_ef_sc_hd__decap_12
XFILLER_4_265 VGND VGND VPWR VPWR sky130_fd_sc_hd__decap_8
XFILLER_122_620 VPWR VGND VPWR VGND sky130_ef_sc_hd__decap_12
XFILLER_122_697 VGND VGND VPWR VPWR sky130_fd_sc_hd__decap_3
XFILLER_95_559 VGND VGND VPWR VPWR sky130_fd_sc_hd__fill_1
XPHY_EDGE_ROW_42_Left_165 VGND VGND VPWR VPWR sky130_fd_sc_hd__decap_3
XFILLER_91_721 VGND VGND VPWR VPWR sky130_fd_sc_hd__decap_4
XFILLER_36_626 VPWR VGND VPWR VGND sky130_ef_sc_hd__decap_12
XFILLER_48_464 VGND VGND VPWR VPWR sky130_fd_sc_hd__fill_1
XFILLER_90_253 VGND VGND VPWR VPWR sky130_fd_sc_hd__decap_8
X_3950_ _1175_ _1865_ _1864_ VGND VGND VPWR VPWR _1866_ sky130_fd_sc_hd__o21ai_1
XFILLER_35_169 VPWR VGND VPWR VGND sky130_ef_sc_hd__decap_12
XFILLER_16_361 VGND VGND VPWR VPWR sky130_fd_sc_hd__decap_3
XFILLER_50_139 VGND VGND VPWR VPWR sky130_fd_sc_hd__fill_1
X_3881_ reg_file_inst.registry\[9\]\[2\] _1131_ _1792_ _1793_ _1794_ VGND VGND VPWR
+ VPWR _1800_ sky130_fd_sc_hd__a2111o_1
XPHY_EDGE_ROW_51_Left_174 VGND VGND VPWR VPWR sky130_fd_sc_hd__decap_3
XFILLER_31_364 VGND VGND VPWR VPWR sky130_fd_sc_hd__decap_4
X_5620_ net146 VGND VGND VPWR VPWR _0028_ sky130_fd_sc_hd__inv_2
X_5551_ _2934_ reg_file_inst.registry\[9\]\[12\] _3002_ VGND VGND VPWR VPWR _0515_
+ sky130_fd_sc_hd__mux2_1
X_4502_ _2377_ _2378_ _1790_ VGND VGND VPWR VPWR _2385_ sky130_fd_sc_hd__mux2_1
XFILLER_117_447 VGND VGND VPWR VPWR sky130_fd_sc_hd__fill_1
XFILLER_105_609 VGND VGND VPWR VPWR sky130_fd_sc_hd__decap_6
X_5482_ JMPOFF\[23\] _2806_ _3000_ VGND VGND VPWR VPWR _0582_ sky130_fd_sc_hd__mux2_1
X_4433_ _2315_ _2316_ _1816_ VGND VGND VPWR VPWR _2318_ sky130_fd_sc_hd__mux2_1
XFILLER_116_29 VPWR VGND VPWR VGND sky130_ef_sc_hd__decap_12
XFILLER_116_18 VGND VGND VPWR VPWR sky130_fd_sc_hd__decap_8
X_4364_ net31 net42 VGND VGND VPWR VPWR _2252_ sky130_fd_sc_hd__or2_1
XFILLER_113_653 VPWR VGND VPWR VGND sky130_ef_sc_hd__decap_12
XFILLER_112_141 VPWR VGND VPWR VGND sky130_ef_sc_hd__decap_12
X_3315_ reg_file_inst.registry\[7\]\[22\] _1086_ _1247_ _1248_ _1253_ VGND VGND VPWR
+ VPWR _1254_ sky130_fd_sc_hd__a2111oi_1
XPHY_EDGE_ROW_60_Left_183 VGND VGND VPWR VPWR sky130_fd_sc_hd__decap_3
X_4295_ _1382_ _1403_ _1480_ VGND VGND VPWR VPWR _2183_ sky130_fd_sc_hd__or3b_1
X_6103_ clknet_leaf_46_clk _0511_ _0036_ VGND VGND VPWR VPWR reg_file_inst.registry\[9\]\[8\]
+ sky130_fd_sc_hd__dfrtp_1
XFILLER_113_697 VPWR VGND VPWR VGND sky130_ef_sc_hd__decap_12
X_3246_ reg_file_inst.registry\[15\]\[25\] _1122_ _1129_ MEMOFF\[25\] _1187_ VGND
+ VGND VPWR VPWR _1188_ sky130_fd_sc_hd__a221o_1
X_6034_ net148 VGND VGND VPWR VPWR _0442_ sky130_fd_sc_hd__inv_2
X_3177_ net34 net36 net37 VGND VGND VPWR VPWR _1121_ sky130_fd_sc_hd__and3b_1
XFILLER_39_475 VPWR VGND VPWR VGND sky130_ef_sc_hd__decap_12
XTAP_TAPCELL_ROW_1_279 VGND VPWR sky130_fd_sc_hd__tapvpwrvgnd_1
XFILLER_14_309 VGND VGND VPWR VPWR sky130_fd_sc_hd__decap_6
XFILLER_35_670 VGND VGND VPWR VPWR sky130_fd_sc_hd__fill_2
XFILLER_35_681 VGND VGND VPWR VPWR sky130_fd_sc_hd__fill_1
XFILLER_22_353 VGND VGND VPWR VPWR sky130_fd_sc_hd__decap_8
X_5818_ net147 VGND VGND VPWR VPWR _0226_ sky130_fd_sc_hd__inv_2
X_5749_ net147 VGND VGND VPWR VPWR _0157_ sky130_fd_sc_hd__inv_2
XTAP_TAPCELL_ROW_20_510 VGND VPWR sky130_fd_sc_hd__tapvpwrvgnd_1
XFILLER_41_69 VPWR VGND VPWR VGND sky130_ef_sc_hd__decap_12
XFILLER_108_469 VGND VGND VPWR VPWR sky130_fd_sc_hd__decap_6
XTAP_TAPCELL_ROW_75_1206 VGND VPWR sky130_fd_sc_hd__tapvpwrvgnd_1
XFILLER_2_725 VGND VGND VPWR VPWR sky130_fd_sc_hd__fill_1
XFILLER_89_353 VGND VGND VPWR VPWR sky130_fd_sc_hd__decap_8
XTAP_TAPCELL_ROW_9_379 VGND VPWR sky130_fd_sc_hd__tapvpwrvgnd_1
XFILLER_66_11 VGND VGND VPWR VPWR sky130_fd_sc_hd__fill_1
XFILLER_49_217 VGND VGND VPWR VPWR sky130_fd_sc_hd__decap_6
XFILLER_77_559 VGND VGND VPWR VPWR sky130_fd_sc_hd__fill_1
XFILLER_85_570 VPWR VGND VPWR VGND sky130_ef_sc_hd__decap_12
XFILLER_45_412 VPWR VGND VPWR VGND sky130_ef_sc_hd__decap_12
XTAP_TAPCELL_ROW_86_1335 VGND VPWR sky130_fd_sc_hd__tapvpwrvgnd_1
XFILLER_17_136 VPWR VGND VPWR VGND sky130_ef_sc_hd__decap_12
XTAP_TAPCELL_ROW_28_610 VGND VPWR sky130_fd_sc_hd__tapvpwrvgnd_1
XFILLER_72_253 VPWR VGND VPWR VGND sky130_ef_sc_hd__decap_12
XTAP_TAPCELL_ROW_56_963 VGND VPWR sky130_fd_sc_hd__tapvpwrvgnd_1
XFILLER_17_169 VPWR VGND VPWR VGND sky130_ef_sc_hd__decap_12
XFILLER_33_629 VGND VGND VPWR VPWR sky130_fd_sc_hd__fill_2
XFILLER_41_673 VPWR VGND VPWR VGND sky130_ef_sc_hd__decap_12
XFILLER_40_194 VGND VGND VPWR VPWR sky130_fd_sc_hd__fill_2
XTAP_TAPCELL_ROW_97_1475 VGND VPWR sky130_fd_sc_hd__tapvpwrvgnd_1
XFILLER_5_541 VPWR VGND VPWR VGND sky130_ef_sc_hd__decap_12
Xoutput109 net109 VGND VGND VPWR VPWR IC[16] sky130_fd_sc_hd__buf_1
XFILLER_5_585 VPWR VGND VPWR VGND sky130_ef_sc_hd__decap_12
XFILLER_122_461 VPWR VGND VPWR VGND sky130_ef_sc_hd__decap_12
XFILLER_110_601 VPWR VGND VPWR VGND sky130_ef_sc_hd__decap_12
Xoutput91 net91 VGND VGND VPWR VPWR DataMemoryWrite[26] sky130_fd_sc_hd__buf_1
XFILLER_95_301 VPWR VGND VPWR VGND sky130_ef_sc_hd__decap_12
Xoutput80 net80 VGND VGND VPWR VPWR DataMemoryWrite[16] sky130_fd_sc_hd__buf_1
X_3100_ _1042_ _1043_ VGND VGND VPWR VPWR _1044_ sky130_fd_sc_hd__nand2_1
XFILLER_110_645 VPWR VGND VPWR VGND sky130_ef_sc_hd__decap_12
XFILLER_95_356 VPWR VGND VPWR VGND sky130_ef_sc_hd__decap_12
X_4080_ net111 net131 _1994_ _1995_ VGND VGND VPWR VPWR _1996_ sky130_fd_sc_hd__and4_1
X_3031_ JMPOFF\[19\] _0967_ VGND VGND VPWR VPWR _0975_ sky130_fd_sc_hd__nand2_1
XFILLER_91_573 VGND VGND VPWR VPWR sky130_fd_sc_hd__decap_4
X_4982_ _2176_ _2818_ _2828_ _2721_ _2827_ VGND VGND VPWR VPWR net58 sky130_fd_sc_hd__a221o_1
XFILLER_17_670 VGND VGND VPWR VPWR sky130_fd_sc_hd__fill_2
XTAP_TAPCELL_ROW_106_1593 VGND VPWR sky130_fd_sc_hd__tapvpwrvgnd_1
X_3933_ reg_file_inst.registry\[7\]\[0\] _1133_ _1136_ reg_file_inst.registry\[8\]\[0\]
+ VGND VGND VPWR VPWR _1850_ sky130_fd_sc_hd__a22o_1
XFILLER_32_684 VPWR VGND VPWR VGND sky130_ef_sc_hd__decap_12
X_3864_ reg_file_inst.registry\[6\]\[2\] _1094_ _1095_ JMPOFF\[2\] VGND VGND VPWR
+ VPWR _1783_ sky130_fd_sc_hd__a22o_1
X_5603_ net147 VGND VGND VPWR VPWR _0011_ sky130_fd_sc_hd__inv_2
XFILLER_118_701 VPWR VGND VPWR VGND sky130_ef_sc_hd__decap_12
X_3795_ JMPOFF\[4\] _1130_ _1136_ reg_file_inst.registry\[8\]\[4\] _1117_ VGND VGND
+ VPWR VPWR _1717_ sky130_fd_sc_hd__a221o_1
XFILLER_11_39 VPWR VGND VPWR VGND sky130_ef_sc_hd__decap_12
X_5534_ reg_file_inst.registry\[6\]\[0\] _2550_ _3001_ VGND VGND VPWR VPWR _0531_
+ sky130_fd_sc_hd__mux2_1
XFILLER_105_406 VGND VGND VPWR VPWR sky130_fd_sc_hd__decap_8
X_5465_ reg_file_inst.registry\[5\]\[11\] _2948_ _2999_ VGND VGND VPWR VPWR _0598_
+ sky130_fd_sc_hd__mux2_1
X_4416_ net136 _2244_ _2299_ VGND VGND VPWR VPWR _2304_ sky130_fd_sc_hd__a21o_1
XFILLER_99_673 VPWR VGND VPWR VGND sky130_ef_sc_hd__decap_12
X_5396_ reg_file_inst.registry\[4\]\[22\] _2817_ _2997_ VGND VGND VPWR VPWR _0665_
+ sky130_fd_sc_hd__mux2_1
XFILLER_113_461 VPWR VGND VPWR VGND sky130_ef_sc_hd__decap_12
XFILLER_98_161 VGND VGND VPWR VPWR sky130_fd_sc_hd__decap_6
XFILLER_86_301 VGND VGND VPWR VPWR sky130_fd_sc_hd__decap_6
XTAP_TAPCELL_ROW_70_1136 VGND VPWR sky130_fd_sc_hd__tapvpwrvgnd_1
X_4347_ _2228_ _2234_ _1764_ VGND VGND VPWR VPWR _2235_ sky130_fd_sc_hd__mux2_1
XTAP_TAPCELL_ROW_6_338 VGND VPWR sky130_fd_sc_hd__tapvpwrvgnd_1
X_4278_ _2163_ _2164_ _2157_ VGND VGND VPWR VPWR _2166_ sky130_fd_sc_hd__o21ai_1
X_6017_ net148 VGND VGND VPWR VPWR _0425_ sky130_fd_sc_hd__inv_2
X_3229_ MEMOFF\[26\] net91 _1113_ VGND VGND VPWR VPWR _1171_ sky130_fd_sc_hd__mux2_4
XFILLER_46_209 VGND VGND VPWR VPWR sky130_fd_sc_hd__decap_8
XFILLER_70_724 VGND VGND VPWR VPWR sky130_fd_sc_hd__fill_2
XFILLER_54_264 VGND VGND VPWR VPWR sky130_fd_sc_hd__fill_2
XTAP_TAPCELL_ROW_53_922 VGND VPWR sky130_fd_sc_hd__tapvpwrvgnd_1
XFILLER_15_629 VPWR VGND VPWR VGND sky130_ef_sc_hd__decap_12
XFILLER_14_139 VGND VGND VPWR VPWR sky130_fd_sc_hd__fill_1
XTAP_TAPCELL_ROW_81_1276 VGND VPWR sky130_fd_sc_hd__tapvpwrvgnd_1
XFILLER_23_673 VGND VGND VPWR VPWR sky130_fd_sc_hd__fill_1
XFILLER_6_316 VGND VGND VPWR VPWR sky130_fd_sc_hd__decap_3
XFILLER_108_233 VPWR VGND VPWR VGND sky130_ef_sc_hd__decap_12
XFILLER_108_277 VPWR VGND VPWR VGND sky130_ef_sc_hd__decap_12
XPHY_EDGE_ROW_107_Left_230 VGND VGND VPWR VPWR sky130_fd_sc_hd__decap_3
XFILLER_2_533 VPWR VGND VPWR VGND sky130_ef_sc_hd__decap_12
XFILLER_89_150 VPWR VGND VPWR VGND sky130_ef_sc_hd__decap_12
XFILLER_45_231 VPWR VGND VPWR VGND sky130_ef_sc_hd__decap_12
XFILLER_18_489 VPWR VGND VPWR VGND sky130_ef_sc_hd__decap_12
XFILLER_33_415 VPWR VGND VPWR VGND sky130_ef_sc_hd__decap_12
XFILLER_45_286 VPWR VGND VPWR VGND sky130_ef_sc_hd__decap_12
XFILLER_60_234 VGND VGND VPWR VPWR sky130_fd_sc_hd__fill_2
XTAP_TAPCELL_ROW_99_1504 VGND VPWR sky130_fd_sc_hd__tapvpwrvgnd_1
XFILLER_9_143 VGND VGND VPWR VPWR sky130_fd_sc_hd__fill_1
XFILLER_9_110 VGND VGND VPWR VPWR sky130_fd_sc_hd__fill_2
XFILLER_13_172 VGND VGND VPWR VPWR sky130_fd_sc_hd__decap_8
XTAP_TAPCELL_ROW_31_649 VGND VPWR sky130_fd_sc_hd__tapvpwrvgnd_1
X_3580_ reg_file_inst.registry\[6\]\[14\] _1135_ _1137_ reg_file_inst.registry\[2\]\[14\]
+ VGND VGND VPWR VPWR _1509_ sky130_fd_sc_hd__a22o_1
X_5250_ reg_file_inst.registry\[14\]\[23\] _2806_ _2992_ VGND VGND VPWR VPWR _0806_
+ sky130_fd_sc_hd__mux2_1
XFILLER_102_409 VGND VGND VPWR VPWR sky130_fd_sc_hd__decap_8
X_4201_ _2098_ net129 net130 VGND VGND VPWR VPWR _0931_ sky130_fd_sc_hd__mux2_1
XFILLER_47_3 VGND VGND VPWR VPWR sky130_fd_sc_hd__decap_8
X_5181_ _2787_ reg_file_inst.registry\[0\]\[24\] _2988_ VGND VGND VPWR VPWR _0871_
+ sky130_fd_sc_hd__mux2_1
XFILLER_68_301 VGND VGND VPWR VPWR sky130_fd_sc_hd__decap_6
XFILLER_96_643 VGND VGND VPWR VPWR sky130_fd_sc_hd__fill_1
X_4132_ net118 _2041_ VGND VGND VPWR VPWR _2048_ sky130_fd_sc_hd__xor2_1
XFILLER_3_51 VGND VGND VPWR VPWR sky130_fd_sc_hd__decap_4
XFILLER_110_475 VGND VGND VPWR VPWR sky130_fd_sc_hd__fill_1
XFILLER_95_142 VGND VGND VPWR VPWR sky130_fd_sc_hd__decap_6
X_4063_ net129 _1878_ _1978_ VGND VGND VPWR VPWR _1979_ sky130_fd_sc_hd__nand3_1
XTAP_TAPCELL_ROW_108_1611 VGND VPWR sky130_fd_sc_hd__tapvpwrvgnd_1
X_3014_ net43 VGND VGND VPWR VPWR _0960_ sky130_fd_sc_hd__inv_2
XTAP_TAPCELL_ROW_39_749 VGND VPWR sky130_fd_sc_hd__tapvpwrvgnd_1
XFILLER_49_592 VGND VGND VPWR VPWR sky130_fd_sc_hd__fill_1
XFILLER_36_253 VPWR VGND VPWR VGND sky130_ef_sc_hd__decap_12
XFILLER_52_713 VPWR VGND VPWR VGND sky130_ef_sc_hd__decap_12
XFILLER_51_234 VGND VGND VPWR VPWR sky130_fd_sc_hd__fill_1
X_4965_ _2365_ _2698_ _2711_ _2811_ _2813_ VGND VGND VPWR VPWR _2814_ sky130_fd_sc_hd__a221o_1
XFILLER_51_256 VPWR VGND VPWR VGND sky130_ef_sc_hd__decap_12
X_3916_ reg_file_inst.registry\[1\]\[0\] _1078_ _1082_ VGND VGND VPWR VPWR _1833_
+ sky130_fd_sc_hd__and3_1
X_4896_ _2129_ _2750_ _2721_ VGND VGND VPWR VPWR _2751_ sky130_fd_sc_hd__o21a_1
XFILLER_20_610 VPWR VGND VPWR VGND sky130_ef_sc_hd__decap_12
XFILLER_20_654 VGND VGND VPWR VPWR sky130_fd_sc_hd__fill_1
X_3847_ reg_file_inst.registry\[6\]\[3\] _1123_ _1132_ VGND VGND VPWR VPWR _1767_
+ sky130_fd_sc_hd__and3_1
XFILLER_118_531 VGND VGND VPWR VPWR sky130_fd_sc_hd__fill_1
XTAP_TAPCELL_ROW_119_1751 VGND VPWR sky130_fd_sc_hd__tapvpwrvgnd_1
X_3778_ reg_file_inst.registry\[10\]\[4\] _1080_ _1088_ VGND VGND VPWR VPWR _1700_
+ sky130_fd_sc_hd__and3_1
X_5517_ reg_file_inst.registry\[6\]\[17\] _2873_ _3001_ VGND VGND VPWR VPWR _0548_
+ sky130_fd_sc_hd__mux2_1
XFILLER_3_308 VGND VGND VPWR VPWR sky130_fd_sc_hd__decap_6
XFILLER_105_225 VPWR VGND VPWR VGND sky130_ef_sc_hd__decap_12
X_6497_ clknet_leaf_23_clk _0905_ _0430_ VGND VGND VPWR VPWR reg_file_inst.registry\[11\]\[26\]
+ sky130_fd_sc_hd__dfrtp_1
XFILLER_3_319 VGND VGND VPWR VPWR sky130_fd_sc_hd__fill_2
X_5448_ _1128_ _2552_ VGND VGND VPWR VPWR _2999_ sky130_fd_sc_hd__nor2_8
XFILLER_99_481 VGND VGND VPWR VPWR sky130_fd_sc_hd__decap_4
XFILLER_78_109 VPWR VGND VPWR VGND sky130_ef_sc_hd__decap_12
X_5379_ MEMOFF\[10\] _2960_ _2996_ VGND VGND VPWR VPWR _0681_ sky130_fd_sc_hd__mux2_1
XFILLER_87_665 VGND VGND VPWR VPWR sky130_fd_sc_hd__decap_6
XFILLER_47_529 VGND VGND VPWR VPWR sky130_fd_sc_hd__decap_8
XFILLER_86_197 VGND VGND VPWR VPWR sky130_fd_sc_hd__decap_6
XFILLER_28_721 VGND VGND VPWR VPWR sky130_fd_sc_hd__fill_2
XPHY_EDGE_ROW_29_Right_29 VGND VGND VPWR VPWR sky130_fd_sc_hd__decap_3
XFILLER_47_57 VPWR VGND VPWR VGND sky130_ef_sc_hd__decap_12
XTAP_TAPCELL_ROW_83_1305 VGND VPWR sky130_fd_sc_hd__tapvpwrvgnd_1
XFILLER_70_510 VPWR VGND VPWR VGND sky130_ef_sc_hd__decap_12
XFILLER_55_573 VGND VGND VPWR VPWR sky130_fd_sc_hd__decap_6
XFILLER_42_201 VGND VGND VPWR VPWR sky130_fd_sc_hd__fill_1
XFILLER_42_223 VPWR VGND VPWR VGND sky130_ef_sc_hd__decap_12
XFILLER_70_576 VPWR VGND VPWR VGND sky130_ef_sc_hd__decap_12
XFILLER_70_565 VGND VGND VPWR VPWR sky130_fd_sc_hd__fill_2
XFILLER_8_29 VPWR VGND VPWR VGND sky130_ef_sc_hd__decap_12
XPHY_EDGE_ROW_38_Right_38 VGND VGND VPWR VPWR sky130_fd_sc_hd__decap_3
XFILLER_109_553 VGND VGND VPWR VPWR sky130_fd_sc_hd__decap_6
XFILLER_10_197 VGND VGND VPWR VPWR sky130_fd_sc_hd__decap_8
XFILLER_6_168 VPWR VGND VPWR VGND sky130_ef_sc_hd__decap_12
XFILLER_109_597 VPWR VGND VPWR VGND sky130_ef_sc_hd__decap_12
XTAP_TAPCELL_ROW_94_1445 VGND VPWR sky130_fd_sc_hd__tapvpwrvgnd_1
XTAP_TAPCELL_ROW_94_1434 VGND VPWR sky130_fd_sc_hd__tapvpwrvgnd_1
XFILLER_111_217 VGND VGND VPWR VPWR sky130_fd_sc_hd__decap_6
XFILLER_78_643 VGND VGND VPWR VPWR sky130_fd_sc_hd__fill_1
XFILLER_93_613 VGND VGND VPWR VPWR sky130_fd_sc_hd__decap_3
XPHY_EDGE_ROW_47_Right_47 VGND VGND VPWR VPWR sky130_fd_sc_hd__decap_3
XFILLER_77_197 VGND VGND VPWR VPWR sky130_fd_sc_hd__fill_2
XFILLER_65_337 VGND VGND VPWR VPWR sky130_fd_sc_hd__decap_4
XFILLER_18_231 VGND VGND VPWR VPWR sky130_fd_sc_hd__decap_3
XTAP_TAPCELL_ROW_36_708 VGND VPWR sky130_fd_sc_hd__tapvpwrvgnd_1
XFILLER_92_178 VPWR VGND VPWR VGND sky130_ef_sc_hd__decap_12
XFILLER_18_253 VGND VGND VPWR VPWR sky130_fd_sc_hd__decap_4
XFILLER_33_212 VGND VGND VPWR VPWR sky130_fd_sc_hd__decap_4
XTAP_TAPCELL_ROW_36_719 VGND VPWR sky130_fd_sc_hd__tapvpwrvgnd_1
XFILLER_33_234 VGND VGND VPWR VPWR sky130_fd_sc_hd__fill_2
XTAP_TAPCELL_ROW_103_1552 VGND VPWR sky130_fd_sc_hd__tapvpwrvgnd_1
XTAP_TAPCELL_ROW_16_465 VGND VPWR sky130_fd_sc_hd__tapvpwrvgnd_1
XPHY_EDGE_ROW_56_Right_56 VGND VGND VPWR VPWR sky130_fd_sc_hd__decap_3
X_4750_ _1566_ _2607_ VGND VGND VPWR VPWR _2609_ sky130_fd_sc_hd__or2_1
XFILLER_119_317 VPWR VGND VPWR VGND sky130_ef_sc_hd__decap_12
X_4681_ _2375_ reg_file_inst.registry\[11\]\[14\] _2118_ VGND VGND VPWR VPWR _0913_
+ sky130_fd_sc_hd__mux2_1
X_3701_ _1529_ _1540_ VGND VGND VPWR VPWR _1625_ sky130_fd_sc_hd__or2_1
X_3632_ reg_file_inst.registry\[2\]\[10\] _1137_ _1142_ reg_file_inst.registry\[1\]\[10\]
+ VGND VGND VPWR VPWR _1559_ sky130_fd_sc_hd__a22o_1
X_6420_ clknet_leaf_26_clk _0828_ _0353_ VGND VGND VPWR VPWR reg_file_inst.registry\[1\]\[17\]
+ sky130_fd_sc_hd__dfrtp_1
X_6351_ clknet_leaf_46_clk _0759_ _0284_ VGND VGND VPWR VPWR reg_file_inst.registry\[2\]\[4\]
+ sky130_fd_sc_hd__dfrtp_1
X_3563_ _1491_ VGND VGND VPWR VPWR _1492_ sky130_fd_sc_hd__inv_2
X_5302_ _2550_ reg_file_inst.registry\[2\]\[0\] _2993_ VGND VGND VPWR VPWR _0755_
+ sky130_fd_sc_hd__mux2_1
X_6282_ clknet_leaf_19_clk _0690_ _0215_ VGND VGND VPWR VPWR MEMOFF\[19\] sky130_fd_sc_hd__dfrtp_1
X_3494_ MEMOFF\[12\] _1079_ net140 VGND VGND VPWR VPWR _1426_ sky130_fd_sc_hd__a21o_1
XTAP_TAPCELL_ROW_114_1692 VGND VPWR sky130_fd_sc_hd__tapvpwrvgnd_1
XFILLER_102_217 VGND VGND VPWR VPWR sky130_fd_sc_hd__decap_4
X_5233_ _2960_ reg_file_inst.registry\[1\]\[10\] _2990_ VGND VGND VPWR VPWR _0821_
+ sky130_fd_sc_hd__mux2_1
XPHY_EDGE_ROW_65_Right_65 VGND VGND VPWR VPWR sky130_fd_sc_hd__decap_3
X_5164_ _2277_ _2785_ _2980_ _2983_ _2984_ VGND VGND VPWR VPWR _2985_ sky130_fd_sc_hd__a2111o_1
XFILLER_69_665 VGND VGND VPWR VPWR sky130_fd_sc_hd__decap_6
X_4115_ _2022_ _2030_ net131 VGND VGND VPWR VPWR _2031_ sky130_fd_sc_hd__nor3b_1
XFILLER_83_101 VGND VGND VPWR VPWR sky130_fd_sc_hd__fill_2
XFILLER_68_197 VGND VGND VPWR VPWR sky130_fd_sc_hd__decap_8
X_5095_ _1446_ _2282_ VGND VGND VPWR VPWR _2924_ sky130_fd_sc_hd__nor2_1
XFILLER_29_529 VGND VGND VPWR VPWR sky130_fd_sc_hd__decap_3
XFILLER_84_657 VPWR VGND VPWR VGND sky130_ef_sc_hd__decap_12
X_4046_ _1017_ _1878_ _1950_ net123 VGND VGND VPWR VPWR _1962_ sky130_fd_sc_hd__a31o_1
XFILLER_17_27 VGND VGND VPWR VPWR sky130_fd_sc_hd__decap_8
XFILLER_83_167 VGND VGND VPWR VPWR sky130_fd_sc_hd__fill_1
XFILLER_52_543 VPWR VGND VPWR VGND sky130_ef_sc_hd__decap_12
XFILLER_24_245 VGND VGND VPWR VPWR sky130_fd_sc_hd__decap_6
XPHY_EDGE_ROW_74_Right_74 VGND VGND VPWR VPWR sky130_fd_sc_hd__decap_3
XTAP_TAPCELL_ROW_65_1079 VGND VPWR sky130_fd_sc_hd__tapvpwrvgnd_1
X_5997_ net149 VGND VGND VPWR VPWR _0405_ sky130_fd_sc_hd__inv_2
X_4948_ _2797_ _2798_ _2796_ VGND VGND VPWR VPWR _2799_ sky130_fd_sc_hd__o21ai_1
X_4879_ _1162_ _1172_ _2289_ _2735_ VGND VGND VPWR VPWR _2736_ sky130_fd_sc_hd__a22o_1
XFILLER_116_6 VPWR VGND VPWR VGND sky130_ef_sc_hd__decap_12
XFILLER_106_501 VPWR VGND VPWR VGND sky130_ef_sc_hd__decap_12
XFILLER_106_545 VPWR VGND VPWR VGND sky130_ef_sc_hd__decap_12
XPHY_EDGE_ROW_83_Right_83 VGND VGND VPWR VPWR sky130_fd_sc_hd__decap_3
XFILLER_106_589 VPWR VGND VPWR VGND sky130_ef_sc_hd__decap_12
XFILLER_121_559 VGND VGND VPWR VPWR sky130_fd_sc_hd__fill_1
XFILLER_87_473 VGND VGND VPWR VPWR sky130_fd_sc_hd__decap_8
XFILLER_101_272 VGND VGND VPWR VPWR sky130_fd_sc_hd__decap_3
XFILLER_74_112 VPWR VGND VPWR VGND sky130_ef_sc_hd__decap_12
XFILLER_47_337 VGND VGND VPWR VPWR sky130_fd_sc_hd__fill_2
XFILLER_74_189 VGND VGND VPWR VPWR sky130_fd_sc_hd__decap_3
XFILLER_74_77 VGND VGND VPWR VPWR sky130_fd_sc_hd__decap_6
XFILLER_62_307 VGND VGND VPWR VPWR sky130_fd_sc_hd__fill_1
XPHY_EDGE_ROW_92_Right_92 VGND VGND VPWR VPWR sky130_fd_sc_hd__decap_3
XFILLER_74_88 VPWR VGND VPWR VGND sky130_ef_sc_hd__decap_12
XFILLER_15_223 VGND VGND VPWR VPWR sky130_fd_sc_hd__fill_1
XFILLER_70_362 VGND VGND VPWR VPWR sky130_fd_sc_hd__fill_2
XFILLER_15_245 VGND VGND VPWR VPWR sky130_fd_sc_hd__decap_3
XFILLER_15_278 VGND VGND VPWR VPWR sky130_fd_sc_hd__fill_2
XFILLER_31_705 VGND VGND VPWR VPWR sky130_fd_sc_hd__fill_1
XTAP_TAPCELL_ROW_13_424 VGND VPWR sky130_fd_sc_hd__tapvpwrvgnd_1
XFILLER_15_289 VGND VGND VPWR VPWR sky130_fd_sc_hd__fill_2
XFILLER_30_237 VGND VGND VPWR VPWR sky130_fd_sc_hd__fill_1
XTAP_TAPCELL_ROW_41_777 VGND VPWR sky130_fd_sc_hd__tapvpwrvgnd_1
XFILLER_116_309 VPWR VGND VPWR VGND sky130_ef_sc_hd__decap_12
XFILLER_7_466 VPWR VGND VPWR VGND sky130_ef_sc_hd__decap_12
XFILLER_109_361 VPWR VGND VPWR VGND sky130_ef_sc_hd__decap_12
XFILLER_99_96 VPWR VGND VPWR VGND sky130_ef_sc_hd__decap_12
XFILLER_99_85 VGND VGND VPWR VPWR sky130_fd_sc_hd__fill_2
XFILLER_97_259 VPWR VGND VPWR VGND sky130_ef_sc_hd__decap_12
XFILLER_120_581 VGND VGND VPWR VPWR sky130_fd_sc_hd__decap_6
XFILLER_93_465 VPWR VGND VPWR VGND sky130_ef_sc_hd__decap_12
XFILLER_66_668 VPWR VGND VPWR VGND sky130_ef_sc_hd__decap_12
X_5920_ net146 VGND VGND VPWR VPWR _0328_ sky130_fd_sc_hd__inv_2
XFILLER_53_329 VGND VGND VPWR VPWR sky130_fd_sc_hd__decap_6
XFILLER_19_573 VPWR VGND VPWR VGND sky130_ef_sc_hd__decap_12
XTAP_TAPCELL_ROW_49_877 VGND VPWR sky130_fd_sc_hd__tapvpwrvgnd_1
XFILLER_0_85 VGND VGND VPWR VPWR sky130_fd_sc_hd__fill_1
XFILLER_0_63 VGND VGND VPWR VPWR sky130_fd_sc_hd__decap_8
X_5851_ net146 VGND VGND VPWR VPWR _0259_ sky130_fd_sc_hd__inv_2
XPHY_EDGE_ROW_100_Right_100 VGND VGND VPWR VPWR sky130_fd_sc_hd__decap_3
X_5782_ net146 VGND VGND VPWR VPWR _0190_ sky130_fd_sc_hd__inv_2
XFILLER_61_384 VGND VGND VPWR VPWR sky130_fd_sc_hd__decap_8
X_4802_ _1369_ _2659_ VGND VGND VPWR VPWR _2661_ sky130_fd_sc_hd__or2_1
XFILLER_34_598 VGND VGND VPWR VPWR sky130_fd_sc_hd__decap_3
X_4733_ _1294_ _2588_ VGND VGND VPWR VPWR _2592_ sky130_fd_sc_hd__and2_1
XFILLER_119_125 VPWR VGND VPWR VGND sky130_ef_sc_hd__decap_12
XFILLER_119_169 VPWR VGND VPWR VGND sky130_ef_sc_hd__decap_12
X_4664_ _2130_ _2259_ VGND VGND VPWR VPWR _2537_ sky130_fd_sc_hd__nor2_1
X_6403_ clknet_leaf_47_clk _0811_ _0336_ VGND VGND VPWR VPWR reg_file_inst.registry\[1\]\[0\]
+ sky130_fd_sc_hd__dfrtp_1
XTAP_TAPCELL_ROW_116_1710 VGND VPWR sky130_fd_sc_hd__tapvpwrvgnd_1
X_4595_ _2449_ _2459_ _2237_ VGND VGND VPWR VPWR _2474_ sky130_fd_sc_hd__o21a_1
X_3615_ _1529_ _1540_ VGND VGND VPWR VPWR _1542_ sky130_fd_sc_hd__xnor2_1
X_3546_ reg_file_inst.registry\[5\]\[15\] _1097_ _1098_ reg_file_inst.registry\[10\]\[15\]
+ _1475_ VGND VGND VPWR VPWR _1476_ sky130_fd_sc_hd__a221o_1
X_6334_ clknet_leaf_13_clk _0742_ _0267_ VGND VGND VPWR VPWR reg_file_inst.registry\[8\]\[15\]
+ sky130_fd_sc_hd__dfrtp_1
XFILLER_1_609 VGND VGND VPWR VPWR sky130_fd_sc_hd__decap_6
X_6265_ clknet_leaf_61_clk _0673_ _0198_ VGND VGND VPWR VPWR MEMOFF\[2\] sky130_fd_sc_hd__dfrtp_1
XFILLER_103_559 VGND VGND VPWR VPWR sky130_fd_sc_hd__fill_1
X_5216_ _2715_ reg_file_inst.registry\[1\]\[27\] _2990_ VGND VGND VPWR VPWR _0838_
+ sky130_fd_sc_hd__mux2_1
XFILLER_88_226 VPWR VGND VPWR VGND sky130_ef_sc_hd__decap_12
X_3477_ reg_file_inst.registry\[10\]\[17\] _1123_ net143 VGND VGND VPWR VPWR _1410_
+ sky130_fd_sc_hd__and3_1
X_6196_ clknet_leaf_8_clk _0604_ _0129_ VGND VGND VPWR VPWR reg_file_inst.registry\[5\]\[17\]
+ sky130_fd_sc_hd__dfrtp_1
XFILLER_84_421 VPWR VGND VPWR VGND sky130_ef_sc_hd__decap_12
XFILLER_29_337 VGND VGND VPWR VPWR sky130_fd_sc_hd__decap_4
X_5147_ _1622_ _2286_ _2967_ _1581_ _2969_ VGND VGND VPWR VPWR _2970_ sky130_fd_sc_hd__a221o_1
XFILLER_84_443 VPWR VGND VPWR VGND sky130_ef_sc_hd__decap_12
X_5078_ reg_file_inst.registry\[7\]\[14\] _2909_ _2553_ VGND VGND VPWR VPWR _0889_
+ sky130_fd_sc_hd__mux2_1
XFILLER_56_156 VGND VGND VPWR VPWR sky130_fd_sc_hd__fill_1
XFILLER_56_189 VGND VGND VPWR VPWR sky130_fd_sc_hd__decap_6
X_4029_ _1004_ _1005_ _1016_ VGND VGND VPWR VPWR _1945_ sky130_fd_sc_hd__nor3_1
XFILLER_71_137 VPWR VGND VPWR VGND sky130_ef_sc_hd__decap_12
XFILLER_100_20 VGND VGND VPWR VPWR sky130_fd_sc_hd__decap_8
XFILLER_9_709 VPWR VGND VPWR VGND sky130_ef_sc_hd__decap_12
XFILLER_100_53 VPWR VGND VPWR VGND sky130_ef_sc_hd__decap_12
XFILLER_40_557 VPWR VGND VPWR VGND sky130_ef_sc_hd__decap_12
XFILLER_114_3 VPWR VGND VPWR VGND sky130_ef_sc_hd__decap_12
XTAP_TAPCELL_ROW_78_1237 VGND VPWR sky130_fd_sc_hd__tapvpwrvgnd_1
XFILLER_109_51 VGND VGND VPWR VPWR sky130_fd_sc_hd__decap_4
XTAP_TAPCELL_ROW_91_1404 VGND VPWR sky130_fd_sc_hd__tapvpwrvgnd_1
XFILLER_4_458 VGND VGND VPWR VPWR sky130_fd_sc_hd__decap_4
XFILLER_0_631 VGND VGND VPWR VPWR sky130_fd_sc_hd__fill_1
XFILLER_79_259 VGND VGND VPWR VPWR sky130_fd_sc_hd__fill_1
XFILLER_102_581 VGND VGND VPWR VPWR sky130_fd_sc_hd__decap_6
XFILLER_94_229 VGND VGND VPWR VPWR sky130_fd_sc_hd__decap_3
XFILLER_75_432 VGND VGND VPWR VPWR sky130_fd_sc_hd__decap_6
XFILLER_47_145 VGND VGND VPWR VPWR sky130_fd_sc_hd__fill_2
XFILLER_48_657 VGND VGND VPWR VPWR sky130_fd_sc_hd__decap_6
XFILLER_48_679 VGND VGND VPWR VPWR sky130_fd_sc_hd__decap_4
XTAP_TAPCELL_ROW_89_1377 VGND VPWR sky130_fd_sc_hd__tapvpwrvgnd_1
XFILLER_47_167 VGND VGND VPWR VPWR sky130_fd_sc_hd__fill_1
XTAP_TAPCELL_ROW_46_836 VGND VPWR sky130_fd_sc_hd__tapvpwrvgnd_1
XFILLER_16_598 VGND VGND VPWR VPWR sky130_fd_sc_hd__fill_2
XTAP_TAPCELL_ROW_100_1511 VGND VPWR sky130_fd_sc_hd__tapvpwrvgnd_1
XTAP_TAPCELL_ROW_26_593 VGND VPWR sky130_fd_sc_hd__tapvpwrvgnd_1
XFILLER_34_91 VGND VGND VPWR VPWR sky130_fd_sc_hd__fill_1
XFILLER_11_281 VGND VGND VPWR VPWR sky130_fd_sc_hd__fill_2
XFILLER_117_629 VPWR VGND VPWR VGND sky130_ef_sc_hd__decap_12
XFILLER_116_139 VGND VGND VPWR VPWR sky130_fd_sc_hd__fill_1
X_3400_ reg_file_inst.registry\[10\]\[19\] _1123_ net144 VGND VGND VPWR VPWR _1336_
+ sky130_fd_sc_hd__and3_1
X_4380_ _1840_ _2267_ VGND VGND VPWR VPWR _2268_ sky130_fd_sc_hd__nor2_1
XFILLER_112_301 VGND VGND VPWR VPWR sky130_fd_sc_hd__decap_6
X_3331_ _1256_ _1267_ VGND VGND VPWR VPWR _1269_ sky130_fd_sc_hd__xnor2_1
XFILLER_112_345 VPWR VGND VPWR VGND sky130_ef_sc_hd__decap_12
XTAP_TAPCELL_ROW_111_1651 VGND VPWR sky130_fd_sc_hd__tapvpwrvgnd_1
X_3262_ reg_file_inst.registry\[7\]\[24\] _1086_ _1087_ reg_file_inst.registry\[1\]\[24\]
+ VGND VGND VPWR VPWR _1203_ sky130_fd_sc_hd__a22o_1
X_6050_ net146 VGND VGND VPWR VPWR _0458_ sky130_fd_sc_hd__inv_2
XFILLER_112_389 VPWR VGND VPWR VGND sky130_ef_sc_hd__decap_12
X_3193_ _1116_ _1123_ VGND VGND VPWR VPWR _1137_ sky130_fd_sc_hd__and2_4
XFILLER_66_421 VGND VGND VPWR VPWR sky130_fd_sc_hd__decap_4
X_5001_ _2662_ _2843_ VGND VGND VPWR VPWR _2844_ sky130_fd_sc_hd__or2_1
XFILLER_39_613 VGND VGND VPWR VPWR sky130_fd_sc_hd__decap_3
XFILLER_93_273 VGND VGND VPWR VPWR sky130_fd_sc_hd__decap_6
XFILLER_54_638 VGND VGND VPWR VPWR sky130_fd_sc_hd__decap_6
XFILLER_26_307 VGND VGND VPWR VPWR sky130_fd_sc_hd__fill_1
XFILLER_38_156 VGND VGND VPWR VPWR sky130_fd_sc_hd__decap_3
XFILLER_38_178 VGND VGND VPWR VPWR sky130_fd_sc_hd__decap_4
XFILLER_93_295 VGND VGND VPWR VPWR sky130_fd_sc_hd__fill_1
X_5903_ net148 VGND VGND VPWR VPWR _0311_ sky130_fd_sc_hd__inv_2
X_5834_ net147 VGND VGND VPWR VPWR _0242_ sky130_fd_sc_hd__inv_2
XFILLER_22_513 VPWR VGND VPWR VGND sky130_ef_sc_hd__decap_12
XFILLER_34_384 VPWR VGND VPWR VGND sky130_ef_sc_hd__decap_12
XTAP_TAPCELL_ROW_122_1791 VGND VPWR sky130_fd_sc_hd__tapvpwrvgnd_1
XTAP_TAPCELL_ROW_62_1038 VGND VPWR sky130_fd_sc_hd__tapvpwrvgnd_1
XFILLER_22_557 VPWR VGND VPWR VGND sky130_ef_sc_hd__decap_12
X_5765_ net146 VGND VGND VPWR VPWR _0173_ sky130_fd_sc_hd__inv_2
X_5696_ net146 VGND VGND VPWR VPWR _0104_ sky130_fd_sc_hd__inv_2
X_4716_ _1217_ _2573_ VGND VGND VPWR VPWR _2575_ sky130_fd_sc_hd__xnor2_1
X_4647_ _2295_ _2521_ _2513_ VGND VGND VPWR VPWR _2522_ sky130_fd_sc_hd__a21o_1
XFILLER_30_27 VGND VGND VPWR VPWR sky130_fd_sc_hd__fill_1
XFILLER_122_109 VGND VGND VPWR VPWR sky130_fd_sc_hd__decap_3
X_6317_ clknet_leaf_20_clk _0725_ _0250_ VGND VGND VPWR VPWR reg_file_inst.registry\[3\]\[26\]
+ sky130_fd_sc_hd__dfrtp_1
X_4578_ _2208_ _2242_ _1790_ VGND VGND VPWR VPWR _2457_ sky130_fd_sc_hd__mux2_1
XFILLER_115_161 VGND VGND VPWR VPWR sky130_fd_sc_hd__decap_6
X_3529_ reg_file_inst.registry\[11\]\[13\] _1119_ net143 VGND VGND VPWR VPWR _1460_
+ sky130_fd_sc_hd__and3_1
XTAP_TAPCELL_ROW_73_1178 VGND VPWR sky130_fd_sc_hd__tapvpwrvgnd_1
X_6248_ clknet_leaf_1_clk _0656_ _0181_ VGND VGND VPWR VPWR reg_file_inst.registry\[4\]\[13\]
+ sky130_fd_sc_hd__dfrtp_1
X_6179_ clknet_leaf_54_clk _0587_ _0112_ VGND VGND VPWR VPWR reg_file_inst.registry\[5\]\[0\]
+ sky130_fd_sc_hd__dfrtp_1
XFILLER_29_123 VPWR VGND VPWR VGND sky130_ef_sc_hd__decap_12
XFILLER_84_251 VGND VGND VPWR VPWR sky130_fd_sc_hd__fill_1
XFILLER_57_487 VPWR VGND VPWR VGND sky130_ef_sc_hd__decap_12
XFILLER_29_167 VGND VGND VPWR VPWR sky130_fd_sc_hd__fill_1
XFILLER_55_57 VGND VGND VPWR VPWR sky130_fd_sc_hd__decap_3
XFILLER_44_126 VGND VGND VPWR VPWR sky130_fd_sc_hd__decap_4
XFILLER_60_619 VGND VGND VPWR VPWR sky130_fd_sc_hd__fill_1
XTAP_TAPCELL_ROW_43_806 VGND VPWR sky130_fd_sc_hd__tapvpwrvgnd_1
XFILLER_44_148 VGND VGND VPWR VPWR sky130_fd_sc_hd__fill_1
XFILLER_9_517 VGND VGND VPWR VPWR sky130_fd_sc_hd__decap_6
XTAP_TAPCELL_ROW_23_552 VGND VPWR sky130_fd_sc_hd__tapvpwrvgnd_1
XFILLER_40_365 VGND VGND VPWR VPWR sky130_fd_sc_hd__fill_1
XFILLER_4_233 VGND VGND VPWR VPWR sky130_fd_sc_hd__decap_8
XFILLER_107_673 VPWR VGND VPWR VGND sky130_ef_sc_hd__decap_12
XFILLER_122_632 VPWR VGND VPWR VGND sky130_ef_sc_hd__decap_12
XFILLER_96_20 VGND VGND VPWR VPWR sky130_fd_sc_hd__decap_8
XFILLER_96_42 VGND VGND VPWR VPWR sky130_fd_sc_hd__decap_6
XFILLER_95_505 VPWR VGND VPWR VGND sky130_ef_sc_hd__decap_12
XFILLER_0_461 VGND VGND VPWR VPWR sky130_fd_sc_hd__fill_2
XFILLER_48_410 VGND VGND VPWR VPWR sky130_fd_sc_hd__fill_1
XFILLER_48_421 VGND VGND VPWR VPWR sky130_fd_sc_hd__decap_4
XFILLER_90_221 VGND VGND VPWR VPWR sky130_fd_sc_hd__decap_8
XFILLER_36_638 VGND VGND VPWR VPWR sky130_fd_sc_hd__decap_6
XFILLER_63_479 VPWR VGND VPWR VGND sky130_ef_sc_hd__decap_12
XFILLER_31_321 VGND VGND VPWR VPWR sky130_fd_sc_hd__decap_4
X_3880_ reg_file_inst.registry\[7\]\[2\] _1133_ _1135_ reg_file_inst.registry\[6\]\[2\]
+ VGND VGND VPWR VPWR _1799_ sky130_fd_sc_hd__a22o_1
XFILLER_31_354 VGND VGND VPWR VPWR sky130_fd_sc_hd__decap_6
XFILLER_77_3 VGND VGND VPWR VPWR sky130_fd_sc_hd__decap_8
X_5550_ _2922_ reg_file_inst.registry\[9\]\[13\] _3002_ VGND VGND VPWR VPWR _0516_
+ sky130_fd_sc_hd__mux2_1
X_5481_ JMPOFF\[24\] _2787_ _3000_ VGND VGND VPWR VPWR _0583_ sky130_fd_sc_hd__mux2_1
X_4501_ _1790_ _2383_ _2380_ VGND VGND VPWR VPWR _2384_ sky130_fd_sc_hd__a21oi_1
X_4432_ _2316_ VGND VGND VPWR VPWR _2317_ sky130_fd_sc_hd__inv_2
XFILLER_104_109 VGND VGND VPWR VPWR sky130_fd_sc_hd__decap_8
X_4363_ net31 net42 VGND VGND VPWR VPWR _2251_ sky130_fd_sc_hd__nor2_1
XFILLER_113_665 VGND VGND VPWR VPWR sky130_fd_sc_hd__decap_6
X_3314_ _1249_ _1250_ _1251_ _1252_ VGND VGND VPWR VPWR _1253_ sky130_fd_sc_hd__or4_1
X_6102_ clknet_leaf_47_clk _0510_ _0035_ VGND VGND VPWR VPWR reg_file_inst.registry\[9\]\[7\]
+ sky130_fd_sc_hd__dfrtp_1
X_4294_ _1162_ _1185_ _1208_ _2181_ VGND VGND VPWR VPWR _2182_ sky130_fd_sc_hd__and4_1
XFILLER_112_153 VPWR VGND VPWR VGND sky130_ef_sc_hd__decap_12
XFILLER_98_398 VGND VGND VPWR VPWR sky130_fd_sc_hd__fill_1
X_3245_ JMPOFF\[25\] _1130_ _1140_ reg_file_inst.registry\[3\]\[25\] _1117_ VGND VGND
+ VPWR VPWR _1187_ sky130_fd_sc_hd__a221o_1
X_6033_ net149 VGND VGND VPWR VPWR _0441_ sky130_fd_sc_hd__inv_2
XFILLER_112_197 VPWR VGND VPWR VGND sky130_ef_sc_hd__decap_12
X_3176_ net29 net35 VGND VGND VPWR VPWR _1120_ sky130_fd_sc_hd__nand2_4
XFILLER_39_487 VGND VGND VPWR VPWR sky130_fd_sc_hd__decap_8
XFILLER_94_582 VGND VGND VPWR VPWR sky130_fd_sc_hd__decap_6
XFILLER_81_210 VGND VGND VPWR VPWR sky130_fd_sc_hd__decap_8
XFILLER_42_619 VPWR VGND VPWR VGND sky130_ef_sc_hd__decap_12
XFILLER_34_170 VGND VGND VPWR VPWR sky130_fd_sc_hd__decap_3
Xclkbuf_leaf_61_clk clknet_3_0__leaf_clk VGND VGND VPWR VPWR clknet_leaf_61_clk sky130_fd_sc_hd__clkbuf_8
X_5817_ net149 VGND VGND VPWR VPWR _0225_ sky130_fd_sc_hd__inv_2
X_5748_ net44 VGND VGND VPWR VPWR _0156_ sky130_fd_sc_hd__inv_2
XTAP_TAPCELL_ROW_20_511 VGND VPWR sky130_fd_sc_hd__tapvpwrvgnd_1
XFILLER_22_398 VPWR VGND VPWR VGND sky130_ef_sc_hd__decap_12
XTAP_TAPCELL_ROW_75_1207 VGND VPWR sky130_fd_sc_hd__tapvpwrvgnd_1
X_5679_ net149 VGND VGND VPWR VPWR _0087_ sky130_fd_sc_hd__inv_2
XFILLER_1_225 VGND VGND VPWR VPWR sky130_fd_sc_hd__fill_1
XFILLER_104_643 VGND VGND VPWR VPWR sky130_fd_sc_hd__fill_1
XFILLER_77_505 VGND VGND VPWR VPWR sky130_fd_sc_hd__decap_8
XFILLER_106_41 VPWR VGND VPWR VGND sky130_ef_sc_hd__decap_12
XFILLER_106_85 VPWR VGND VPWR VGND sky130_ef_sc_hd__decap_12
XFILLER_77_549 VGND VGND VPWR VPWR sky130_fd_sc_hd__fill_1
XFILLER_66_78 VGND VGND VPWR VPWR sky130_fd_sc_hd__decap_6
XFILLER_57_240 VPWR VGND VPWR VGND sky130_ef_sc_hd__decap_12
XFILLER_85_582 VGND VGND VPWR VPWR sky130_fd_sc_hd__decap_8
XTAP_TAPCELL_ROW_86_1336 VGND VPWR sky130_fd_sc_hd__tapvpwrvgnd_1
XTAP_TAPCELL_ROW_28_611 VGND VPWR sky130_fd_sc_hd__tapvpwrvgnd_1
XFILLER_45_424 VGND VGND VPWR VPWR sky130_fd_sc_hd__decap_8
XTAP_TAPCELL_ROW_56_964 VGND VPWR sky130_fd_sc_hd__tapvpwrvgnd_1
XFILLER_17_148 VGND VGND VPWR VPWR sky130_fd_sc_hd__decap_4
XFILLER_72_265 VPWR VGND VPWR VGND sky130_ef_sc_hd__decap_12
XFILLER_60_427 VPWR VGND VPWR VGND sky130_ef_sc_hd__decap_12
Xclkbuf_leaf_52_clk clknet_3_5__leaf_clk VGND VGND VPWR VPWR clknet_leaf_52_clk sky130_fd_sc_hd__clkbuf_8
XFILLER_41_641 VGND VGND VPWR VPWR sky130_fd_sc_hd__decap_8
XFILLER_13_376 VGND VGND VPWR VPWR sky130_fd_sc_hd__decap_3
XFILLER_41_685 VGND VGND VPWR VPWR sky130_fd_sc_hd__decap_4
XTAP_TAPCELL_ROW_97_1476 VGND VPWR sky130_fd_sc_hd__tapvpwrvgnd_1
XFILLER_5_553 VGND VGND VPWR VPWR sky130_fd_sc_hd__decap_6
XFILLER_5_597 VPWR VGND VPWR VGND sky130_ef_sc_hd__decap_12
Xoutput70 net70 VGND VGND VPWR VPWR DataAddress[7] sky130_fd_sc_hd__buf_1
XFILLER_122_473 VGND VGND VPWR VPWR sky130_fd_sc_hd__decap_3
Xoutput92 net92 VGND VGND VPWR VPWR DataMemoryWrite[27] sky130_fd_sc_hd__buf_1
XFILLER_110_613 VPWR VGND VPWR VGND sky130_ef_sc_hd__decap_12
XFILLER_95_324 VPWR VGND VPWR VGND sky130_ef_sc_hd__decap_12
XFILLER_95_313 VGND VGND VPWR VPWR sky130_fd_sc_hd__fill_2
Xoutput81 net81 VGND VGND VPWR VPWR DataMemoryWrite[17] sky130_fd_sc_hd__buf_1
XFILLER_110_657 VPWR VGND VPWR VGND sky130_ef_sc_hd__decap_12
XFILLER_95_368 VPWR VGND VPWR VGND sky130_ef_sc_hd__decap_12
XFILLER_64_711 VGND VGND VPWR VPWR sky130_fd_sc_hd__decap_4
X_3030_ JMPOFF\[18\] _0967_ VGND VGND VPWR VPWR _0974_ sky130_fd_sc_hd__nand2_1
XFILLER_48_262 VGND VGND VPWR VPWR sky130_fd_sc_hd__decap_6
XFILLER_36_413 VGND VGND VPWR VPWR sky130_fd_sc_hd__decap_6
XFILLER_63_265 VPWR VGND VPWR VGND sky130_ef_sc_hd__decap_12
X_4981_ _2129_ _2400_ VGND VGND VPWR VPWR _2828_ sky130_fd_sc_hd__or2_1
XTAP_TAPCELL_ROW_106_1594 VGND VPWR sky130_fd_sc_hd__tapvpwrvgnd_1
XTAP_TAPCELL_ROW_106_1583 VGND VPWR sky130_fd_sc_hd__tapvpwrvgnd_1
Xclkbuf_leaf_43_clk clknet_3_6__leaf_clk VGND VGND VPWR VPWR clknet_leaf_43_clk sky130_fd_sc_hd__clkbuf_8
XFILLER_51_449 VGND VGND VPWR VPWR sky130_fd_sc_hd__decap_4
XFILLER_17_693 VGND VGND VPWR VPWR sky130_fd_sc_hd__decap_3
XFILLER_32_641 VGND VGND VPWR VPWR sky130_fd_sc_hd__decap_3
X_3932_ reg_file_inst.registry\[5\]\[0\] _1139_ _1843_ _1844_ _1845_ VGND VGND VPWR
+ VPWR _1849_ sky130_fd_sc_hd__a2111o_1
X_3863_ reg_file_inst.registry\[8\]\[2\] _1090_ net140 VGND VGND VPWR VPWR _1782_
+ sky130_fd_sc_hd__a21o_1
X_5602_ net149 VGND VGND VPWR VPWR _0010_ sky130_fd_sc_hd__inv_2
XFILLER_32_696 VGND VGND VPWR VPWR sky130_fd_sc_hd__decap_4
XFILLER_118_713 VPWR VGND VPWR VGND sky130_ef_sc_hd__decap_12
X_5533_ reg_file_inst.registry\[6\]\[1\] _2528_ _3001_ VGND VGND VPWR VPWR _0532_
+ sky130_fd_sc_hd__mux2_1
X_3794_ reg_file_inst.registry\[14\]\[4\] _1138_ _1140_ reg_file_inst.registry\[3\]\[4\]
+ _1715_ VGND VGND VPWR VPWR _1716_ sky130_fd_sc_hd__a221o_1
XFILLER_117_223 VGND VGND VPWR VPWR sky130_fd_sc_hd__fill_1
X_5464_ reg_file_inst.registry\[5\]\[12\] _2934_ _2999_ VGND VGND VPWR VPWR _0599_
+ sky130_fd_sc_hd__mux2_1
X_5395_ reg_file_inst.registry\[4\]\[23\] _2806_ _2997_ VGND VGND VPWR VPWR _0666_
+ sky130_fd_sc_hd__mux2_1
X_4415_ _1708_ _2235_ _2296_ _2302_ VGND VGND VPWR VPWR _2303_ sky130_fd_sc_hd__o22a_1
XFILLER_99_641 VPWR VGND VPWR VGND sky130_ef_sc_hd__decap_12
X_4346_ _2229_ _2233_ _1790_ VGND VGND VPWR VPWR _2234_ sky130_fd_sc_hd__mux2_1
XFILLER_113_473 VPWR VGND VPWR VGND sky130_ef_sc_hd__decap_12
XFILLER_99_685 VPWR VGND VPWR VGND sky130_ef_sc_hd__decap_12
XTAP_TAPCELL_ROW_70_1137 VGND VPWR sky130_fd_sc_hd__tapvpwrvgnd_1
XTAP_TAPCELL_ROW_6_339 VGND VPWR sky130_fd_sc_hd__tapvpwrvgnd_1
X_4277_ _2163_ _2164_ VGND VGND VPWR VPWR _2165_ sky130_fd_sc_hd__or2_1
X_6016_ net146 VGND VGND VPWR VPWR _0424_ sky130_fd_sc_hd__inv_2
X_3228_ reg_file_inst.registry\[0\]\[26\] _1118_ _1164_ _1170_ VGND VGND VPWR VPWR
+ net91 sky130_fd_sc_hd__o22a_2
X_3159_ MEMOFF\[27\] _1079_ _1089_ reg_file_inst.registry\[9\]\[27\] VGND VGND VPWR
+ VPWR _1103_ sky130_fd_sc_hd__a22o_1
XFILLER_55_722 VGND VGND VPWR VPWR sky130_fd_sc_hd__fill_1
XTAP_TAPCELL_ROW_53_923 VGND VPWR sky130_fd_sc_hd__tapvpwrvgnd_1
Xclkbuf_leaf_34_clk clknet_3_7__leaf_clk VGND VGND VPWR VPWR clknet_leaf_34_clk sky130_fd_sc_hd__clkbuf_8
XFILLER_23_652 VGND VGND VPWR VPWR sky130_fd_sc_hd__decap_3
XFILLER_23_685 VPWR VGND VPWR VGND sky130_ef_sc_hd__decap_12
XTAP_TAPCELL_ROW_81_1277 VGND VPWR sky130_fd_sc_hd__tapvpwrvgnd_1
XTAP_TAPCELL_ROW_33_680 VGND VPWR sky130_fd_sc_hd__tapvpwrvgnd_1
XFILLER_6_339 VGND VGND VPWR VPWR sky130_fd_sc_hd__fill_1
XFILLER_108_245 VGND VGND VPWR VPWR sky130_fd_sc_hd__decap_6
XFILLER_108_289 VPWR VGND VPWR VGND sky130_ef_sc_hd__decap_12
XFILLER_117_51 VGND VGND VPWR VPWR sky130_fd_sc_hd__decap_4
XFILLER_77_11 VGND VGND VPWR VPWR sky130_fd_sc_hd__fill_1
XFILLER_7_3 VPWR VGND VPWR VGND sky130_ef_sc_hd__decap_12
XFILLER_2_545 VPWR VGND VPWR VGND sky130_ef_sc_hd__decap_12
XFILLER_89_162 VGND VGND VPWR VPWR sky130_fd_sc_hd__decap_6
XFILLER_2_589 VPWR VGND VPWR VGND sky130_ef_sc_hd__decap_12
XFILLER_77_346 VGND VGND VPWR VPWR sky130_fd_sc_hd__decap_4
XFILLER_77_324 VPWR VGND VPWR VGND sky130_ef_sc_hd__decap_12
XFILLER_92_327 VPWR VGND VPWR VGND sky130_ef_sc_hd__decap_12
XFILLER_58_582 VGND VGND VPWR VPWR sky130_fd_sc_hd__decap_6
XFILLER_18_413 VGND VGND VPWR VPWR sky130_fd_sc_hd__decap_6
XFILLER_73_530 VGND VGND VPWR VPWR sky130_fd_sc_hd__fill_1
XFILLER_45_243 VGND VGND VPWR VPWR sky130_fd_sc_hd__decap_3
Xclkbuf_leaf_25_clk clknet_3_3__leaf_clk VGND VGND VPWR VPWR clknet_leaf_25_clk sky130_fd_sc_hd__clkbuf_8
XFILLER_33_449 VPWR VGND VPWR VGND sky130_ef_sc_hd__decap_12
XFILLER_45_298 VGND VGND VPWR VPWR sky130_fd_sc_hd__fill_1
XFILLER_14_674 VPWR VGND VPWR VGND sky130_ef_sc_hd__decap_12
XTAP_TAPCELL_ROW_99_1505 VGND VPWR sky130_fd_sc_hd__tapvpwrvgnd_1
XFILLER_9_177 VGND VGND VPWR VPWR sky130_fd_sc_hd__decap_8
XTAP_TAPCELL_ROW_11_396 VGND VPWR sky130_fd_sc_hd__tapvpwrvgnd_1
XFILLER_5_361 VPWR VGND VPWR VGND sky130_ef_sc_hd__decap_12
X_4200_ _1976_ _1981_ VGND VGND VPWR VPWR _2098_ sky130_fd_sc_hd__xor2_1
X_5180_ _2767_ reg_file_inst.registry\[0\]\[25\] _2988_ VGND VGND VPWR VPWR _0872_
+ sky130_fd_sc_hd__mux2_1
XFILLER_122_281 VPWR VGND VPWR VGND sky130_ef_sc_hd__decap_12
XFILLER_110_421 VPWR VGND VPWR VGND sky130_ef_sc_hd__decap_12
X_4131_ net118 _2041_ _2045_ VGND VGND VPWR VPWR _2047_ sky130_fd_sc_hd__a21boi_1
XFILLER_96_699 VGND VGND VPWR VPWR sky130_fd_sc_hd__fill_1
XFILLER_95_165 VGND VGND VPWR VPWR sky130_fd_sc_hd__decap_3
X_4062_ _1029_ _1977_ VGND VGND VPWR VPWR _1978_ sky130_fd_sc_hd__and2_1
XTAP_TAPCELL_ROW_108_1612 VGND VPWR sky130_fd_sc_hd__tapvpwrvgnd_1
XFILLER_83_349 VGND VGND VPWR VPWR sky130_fd_sc_hd__decap_4
XFILLER_83_316 VPWR VGND VPWR VGND sky130_ef_sc_hd__decap_12
X_3013_ net37 VGND VGND VPWR VPWR _0959_ sky130_fd_sc_hd__inv_2
XFILLER_64_574 VPWR VGND VPWR VGND sky130_ef_sc_hd__decap_12
XFILLER_52_725 VGND VGND VPWR VPWR sky130_fd_sc_hd__fill_1
XFILLER_24_416 VGND VGND VPWR VPWR sky130_fd_sc_hd__decap_4
XFILLER_24_427 VGND VGND VPWR VPWR sky130_fd_sc_hd__fill_1
XFILLER_36_265 VGND VGND VPWR VPWR sky130_fd_sc_hd__decap_8
XFILLER_91_393 VPWR VGND VPWR VGND sky130_ef_sc_hd__decap_12
Xclkbuf_leaf_16_clk clknet_3_2__leaf_clk VGND VGND VPWR VPWR clknet_leaf_16_clk sky130_fd_sc_hd__clkbuf_8
X_4964_ net136 _2728_ _2812_ _2279_ VGND VGND VPWR VPWR _2813_ sky130_fd_sc_hd__o211a_1
XTAP_TAPCELL_ROW_19_496 VGND VPWR sky130_fd_sc_hd__tapvpwrvgnd_1
XFILLER_51_268 VPWR VGND VPWR VGND sky130_ef_sc_hd__decap_12
X_3915_ reg_file_inst.registry\[7\]\[0\] _1084_ _1085_ VGND VGND VPWR VPWR _1832_
+ sky130_fd_sc_hd__and3_1
X_4895_ _1764_ _2523_ _2237_ VGND VGND VPWR VPWR _2750_ sky130_fd_sc_hd__o21a_1
X_3846_ reg_file_inst.registry\[8\]\[3\] _1114_ net143 VGND VGND VPWR VPWR _1766_
+ sky130_fd_sc_hd__and3_1
XFILLER_22_17 VGND VGND VPWR VPWR sky130_fd_sc_hd__decap_8
XTAP_TAPCELL_ROW_119_1752 VGND VPWR sky130_fd_sc_hd__tapvpwrvgnd_1
XFILLER_20_699 VGND VGND VPWR VPWR sky130_fd_sc_hd__fill_1
X_3777_ reg_file_inst.registry\[14\]\[4\] _1077_ _1080_ VGND VGND VPWR VPWR _1699_
+ sky130_fd_sc_hd__and3_1
X_6496_ clknet_leaf_23_clk _0904_ _0429_ VGND VGND VPWR VPWR reg_file_inst.registry\[11\]\[25\]
+ sky130_fd_sc_hd__dfrtp_1
X_5516_ reg_file_inst.registry\[6\]\[18\] _2863_ _3001_ VGND VGND VPWR VPWR _0549_
+ sky130_fd_sc_hd__mux2_1
XFILLER_118_587 VGND VGND VPWR VPWR sky130_fd_sc_hd__fill_1
X_5447_ _2550_ reg_file_inst.registry\[10\]\[0\] _2998_ VGND VGND VPWR VPWR _0615_
+ sky130_fd_sc_hd__mux2_1
XFILLER_105_237 VPWR VGND VPWR VGND sky130_ef_sc_hd__decap_12
X_5378_ MEMOFF\[11\] _2948_ _2996_ VGND VGND VPWR VPWR _0682_ sky130_fd_sc_hd__mux2_1
XFILLER_113_281 VPWR VGND VPWR VGND sky130_ef_sc_hd__decap_12
XFILLER_101_432 VPWR VGND VPWR VGND sky130_ef_sc_hd__decap_12
XFILLER_101_421 VGND VGND VPWR VPWR sky130_fd_sc_hd__fill_2
X_4329_ _2214_ _2216_ VGND VGND VPWR VPWR _2217_ sky130_fd_sc_hd__nor2_1
XPHY_EDGE_ROW_114_Right_114 VGND VGND VPWR VPWR sky130_fd_sc_hd__decap_3
XFILLER_47_69 VGND VGND VPWR VPWR sky130_fd_sc_hd__decap_4
XTAP_TAPCELL_ROW_83_1306 VGND VPWR sky130_fd_sc_hd__tapvpwrvgnd_1
XFILLER_70_522 VGND VGND VPWR VPWR sky130_fd_sc_hd__decap_8
XFILLER_15_449 VPWR VGND VPWR VGND sky130_ef_sc_hd__decap_12
XFILLER_27_298 VGND VGND VPWR VPWR sky130_fd_sc_hd__fill_1
XFILLER_42_235 VPWR VGND VPWR VGND sky130_ef_sc_hd__decap_12
XFILLER_11_633 VGND VGND VPWR VPWR sky130_fd_sc_hd__fill_1
XFILLER_11_666 VGND VGND VPWR VPWR sky130_fd_sc_hd__decap_6
XFILLER_7_615 VGND VGND VPWR VPWR sky130_fd_sc_hd__fill_1
XFILLER_6_136 VGND VGND VPWR VPWR sky130_fd_sc_hd__decap_4
XTAP_TAPCELL_ROW_94_1435 VGND VPWR sky130_fd_sc_hd__tapvpwrvgnd_1
XFILLER_88_32 VGND VGND VPWR VPWR sky130_fd_sc_hd__decap_8
XFILLER_77_143 VGND VGND VPWR VPWR sky130_fd_sc_hd__decap_6
XFILLER_65_305 VPWR VGND VPWR VGND sky130_ef_sc_hd__decap_12
XFILLER_78_699 VGND VGND VPWR VPWR sky130_fd_sc_hd__fill_1
XFILLER_19_722 VGND VGND VPWR VPWR sky130_fd_sc_hd__fill_1
XFILLER_18_243 VGND VGND VPWR VPWR sky130_fd_sc_hd__decap_8
XTAP_TAPCELL_ROW_36_709 VGND VPWR sky130_fd_sc_hd__tapvpwrvgnd_1
XFILLER_18_265 VPWR VGND VPWR VGND sky130_ef_sc_hd__decap_12
XFILLER_34_725 VGND VGND VPWR VPWR sky130_fd_sc_hd__fill_1
XTAP_TAPCELL_ROW_103_1553 VGND VPWR sky130_fd_sc_hd__tapvpwrvgnd_1
XTAP_TAPCELL_ROW_16_466 VGND VPWR sky130_fd_sc_hd__tapvpwrvgnd_1
XFILLER_33_279 VGND VGND VPWR VPWR sky130_fd_sc_hd__fill_1
X_3700_ _1542_ _1552_ _1566_ VGND VGND VPWR VPWR _1624_ sky130_fd_sc_hd__or3b_1
X_4680_ _2311_ reg_file_inst.registry\[11\]\[15\] _2118_ VGND VGND VPWR VPWR _0914_
+ sky130_fd_sc_hd__mux2_1
XFILLER_119_329 VGND VGND VPWR VPWR sky130_fd_sc_hd__decap_6
X_3631_ reg_file_inst.registry\[9\]\[10\] net144 _1127_ VGND VGND VPWR VPWR _1558_
+ sky130_fd_sc_hd__and3_1
X_3562_ MEMOFF\[15\] net79 _1113_ VGND VGND VPWR VPWR _1491_ sky130_fd_sc_hd__mux2_4
X_6350_ clknet_leaf_4_clk _0758_ _0283_ VGND VGND VPWR VPWR reg_file_inst.registry\[2\]\[3\]
+ sky130_fd_sc_hd__dfrtp_1
X_5301_ _2528_ reg_file_inst.registry\[2\]\[1\] _2993_ VGND VGND VPWR VPWR _0756_
+ sky130_fd_sc_hd__mux2_1
XFILLER_6_681 VPWR VGND VPWR VGND sky130_ef_sc_hd__decap_12
X_6281_ clknet_leaf_10_clk _0689_ _0214_ VGND VGND VPWR VPWR MEMOFF\[18\] sky130_fd_sc_hd__dfrtp_1
X_3493_ reg_file_inst.registry\[4\]\[12\] _1092_ _1096_ reg_file_inst.registry\[11\]\[12\]
+ VGND VGND VPWR VPWR _1425_ sky130_fd_sc_hd__a22o_1
X_5232_ _2948_ reg_file_inst.registry\[1\]\[11\] _2990_ VGND VGND VPWR VPWR _0822_
+ sky130_fd_sc_hd__mux2_1
Xclkbuf_leaf_5_clk clknet_3_1__leaf_clk VGND VGND VPWR VPWR clknet_leaf_5_clk sky130_fd_sc_hd__clkbuf_8
XTAP_TAPCELL_ROW_114_1693 VGND VPWR sky130_fd_sc_hd__tapvpwrvgnd_1
XFILLER_96_430 VGND VGND VPWR VPWR sky130_fd_sc_hd__fill_1
X_5163_ _2249_ _2770_ _2978_ _2192_ _2255_ VGND VGND VPWR VPWR _2984_ sky130_fd_sc_hd__o221a_1
XFILLER_110_251 VGND VGND VPWR VPWR sky130_fd_sc_hd__fill_1
X_4114_ _0976_ _0982_ _1068_ VGND VGND VPWR VPWR _2030_ sky130_fd_sc_hd__and3_1
XFILLER_96_496 VGND VGND VPWR VPWR sky130_fd_sc_hd__decap_8
XFILLER_96_485 VGND VGND VPWR VPWR sky130_fd_sc_hd__fill_2
XFILLER_96_474 VGND VGND VPWR VPWR sky130_fd_sc_hd__fill_2
XFILLER_84_636 VGND VGND VPWR VPWR sky130_fd_sc_hd__decap_8
XFILLER_83_113 VGND VGND VPWR VPWR sky130_fd_sc_hd__decap_4
X_5094_ _2604_ _2608_ _2624_ _2631_ _2603_ VGND VGND VPWR VPWR _2923_ sky130_fd_sc_hd__a311o_1
XFILLER_84_669 VPWR VGND VPWR VGND sky130_ef_sc_hd__decap_12
X_4045_ _1958_ _1959_ _1955_ VGND VGND VPWR VPWR _1961_ sky130_fd_sc_hd__a21oi_1
XFILLER_64_360 VGND VGND VPWR VPWR sky130_fd_sc_hd__decap_4
XFILLER_25_714 VGND VGND VPWR VPWR sky130_fd_sc_hd__decap_8
XFILLER_52_533 VGND VGND VPWR VPWR sky130_fd_sc_hd__decap_3
XFILLER_52_555 VPWR VGND VPWR VGND sky130_ef_sc_hd__decap_12
X_5996_ net146 VGND VGND VPWR VPWR _0404_ sky130_fd_sc_hd__inv_2
X_4947_ _1791_ _2706_ _2279_ VGND VGND VPWR VPWR _2798_ sky130_fd_sc_hd__o21ai_1
X_4878_ _1173_ _2286_ _2124_ _1162_ VGND VGND VPWR VPWR _2735_ sky130_fd_sc_hd__o2bb2a_1
X_3829_ _1746_ _1747_ _1748_ _1749_ VGND VGND VPWR VPWR _1750_ sky130_fd_sc_hd__or4_1
XFILLER_106_513 VPWR VGND VPWR VGND sky130_ef_sc_hd__decap_12
XFILLER_106_557 VPWR VGND VPWR VGND sky130_ef_sc_hd__decap_12
X_6479_ clknet_leaf_10_clk _0887_ _0412_ VGND VGND VPWR VPWR reg_file_inst.registry\[7\]\[12\]
+ sky130_fd_sc_hd__dfrtp_1
XFILLER_121_505 VPWR VGND VPWR VGND sky130_ef_sc_hd__decap_12
XFILLER_59_121 VGND VGND VPWR VPWR sky130_fd_sc_hd__decap_3
XFILLER_59_110 VGND VGND VPWR VPWR sky130_fd_sc_hd__fill_2
XFILLER_114_41 VPWR VGND VPWR VGND sky130_ef_sc_hd__decap_12
XFILLER_87_496 VGND VGND VPWR VPWR sky130_fd_sc_hd__decap_8
XFILLER_59_176 VGND VGND VPWR VPWR sky130_fd_sc_hd__decap_4
XFILLER_114_85 VPWR VGND VPWR VGND sky130_ef_sc_hd__decap_12
XFILLER_74_124 VPWR VGND VPWR VGND sky130_ef_sc_hd__decap_12
XFILLER_16_725 VGND VGND VPWR VPWR sky130_fd_sc_hd__fill_1
XTAP_TAPCELL_ROW_13_425 VGND VPWR sky130_fd_sc_hd__tapvpwrvgnd_1
XFILLER_7_401 VGND VGND VPWR VPWR sky130_fd_sc_hd__fill_2
XTAP_TAPCELL_ROW_41_778 VGND VPWR sky130_fd_sc_hd__tapvpwrvgnd_1
XFILLER_7_445 VGND VGND VPWR VPWR sky130_fd_sc_hd__decap_3
XFILLER_109_373 VPWR VGND VPWR VGND sky130_ef_sc_hd__decap_12
XFILLER_7_478 VPWR VGND VPWR VGND sky130_ef_sc_hd__decap_12
XFILLER_3_673 VPWR VGND VPWR VGND sky130_ef_sc_hd__decap_12
XFILLER_78_430 VPWR VGND VPWR VGND sky130_ef_sc_hd__decap_12
XFILLER_93_444 VGND VGND VPWR VPWR sky130_fd_sc_hd__decap_4
XFILLER_81_617 VPWR VGND VPWR VGND sky130_ef_sc_hd__decap_12
XFILLER_46_360 VGND VGND VPWR VPWR sky130_fd_sc_hd__decap_4
XTAP_TAPCELL_ROW_49_878 VGND VPWR sky130_fd_sc_hd__tapvpwrvgnd_1
XFILLER_80_138 VGND VGND VPWR VPWR sky130_fd_sc_hd__fill_2
XFILLER_19_585 VPWR VGND VPWR VGND sky130_ef_sc_hd__decap_12
XFILLER_34_533 VGND VGND VPWR VPWR sky130_fd_sc_hd__decap_8
X_5850_ net148 VGND VGND VPWR VPWR _0258_ sky130_fd_sc_hd__inv_2
X_5781_ net146 VGND VGND VPWR VPWR _0189_ sky130_fd_sc_hd__inv_2
X_4801_ _1369_ _2659_ VGND VGND VPWR VPWR _2660_ sky130_fd_sc_hd__nand2_1
XFILLER_9_51 VGND VGND VPWR VPWR sky130_fd_sc_hd__decap_4
X_4732_ _1320_ _2590_ VGND VGND VPWR VPWR _2591_ sky130_fd_sc_hd__and2_1
X_4663_ _1868_ _2175_ _2534_ _1841_ _2535_ VGND VGND VPWR VPWR _2536_ sky130_fd_sc_hd__o221a_1
XFILLER_119_137 VPWR VGND VPWR VGND sky130_ef_sc_hd__decap_12
X_6402_ clknet_leaf_18_clk _0810_ _0335_ VGND VGND VPWR VPWR reg_file_inst.registry\[14\]\[27\]
+ sky130_fd_sc_hd__dfrtp_1
X_3614_ _1540_ VGND VGND VPWR VPWR _1541_ sky130_fd_sc_hd__inv_2
XTAP_TAPCELL_ROW_116_1711 VGND VPWR sky130_fd_sc_hd__tapvpwrvgnd_1
X_4594_ _2279_ _2472_ _2471_ VGND VGND VPWR VPWR _2473_ sky130_fd_sc_hd__a21o_1
X_3545_ MEMOFF\[15\] _1079_ _1094_ reg_file_inst.registry\[6\]\[15\] VGND VGND VPWR
+ VPWR _1475_ sky130_fd_sc_hd__a22o_1
X_6333_ clknet_leaf_12_clk _0741_ _0266_ VGND VGND VPWR VPWR reg_file_inst.registry\[8\]\[14\]
+ sky130_fd_sc_hd__dfrtp_1
XFILLER_103_505 VPWR VGND VPWR VGND sky130_ef_sc_hd__decap_12
X_3476_ reg_file_inst.registry\[3\]\[17\] net145 _1119_ VGND VGND VPWR VPWR _1409_
+ sky130_fd_sc_hd__and3_1
X_6264_ clknet_leaf_56_clk _0672_ _0197_ VGND VGND VPWR VPWR MEMOFF\[1\] sky130_fd_sc_hd__dfrtp_2
XFILLER_88_238 VPWR VGND VPWR VGND sky130_ef_sc_hd__decap_12
X_5215_ _1127_ _2987_ VGND VGND VPWR VPWR _2990_ sky130_fd_sc_hd__nand2_8
X_6195_ clknet_leaf_17_clk _0603_ _0128_ VGND VGND VPWR VPWR reg_file_inst.registry\[5\]\[16\]
+ sky130_fd_sc_hd__dfrtp_1
XFILLER_69_441 VGND VGND VPWR VPWR sky130_fd_sc_hd__decap_6
X_5146_ _2968_ VGND VGND VPWR VPWR _2969_ sky130_fd_sc_hd__inv_2
XFILLER_84_455 VPWR VGND VPWR VGND sky130_ef_sc_hd__decap_12
XFILLER_84_433 VGND VGND VPWR VPWR sky130_fd_sc_hd__fill_1
XFILLER_57_647 VGND VGND VPWR VPWR sky130_fd_sc_hd__fill_1
X_5077_ net6 net101 net50 _2308_ VGND VGND VPWR VPWR _2909_ sky130_fd_sc_hd__a22o_4
XFILLER_84_477 VPWR VGND VPWR VGND sky130_ef_sc_hd__decap_12
X_4028_ _0953_ _1942_ _1943_ VGND VGND VPWR VPWR _1944_ sky130_fd_sc_hd__o21ai_1
XFILLER_71_149 VPWR VGND VPWR VGND sky130_ef_sc_hd__decap_12
XFILLER_37_393 VGND VGND VPWR VPWR sky130_fd_sc_hd__decap_6
X_5979_ net147 VGND VGND VPWR VPWR _0387_ sky130_fd_sc_hd__inv_2
XFILLER_52_385 VPWR VGND VPWR VGND sky130_ef_sc_hd__decap_12
XFILLER_52_363 VGND VGND VPWR VPWR sky130_fd_sc_hd__fill_1
XFILLER_40_503 VGND VGND VPWR VPWR sky130_fd_sc_hd__fill_2
XFILLER_8_209 VPWR VGND VPWR VGND sky130_ef_sc_hd__decap_12
XFILLER_40_569 VPWR VGND VPWR VGND sky130_ef_sc_hd__decap_12
XFILLER_100_65 VGND VGND VPWR VPWR sky130_fd_sc_hd__fill_1
XFILLER_119_671 VGND VGND VPWR VPWR sky130_fd_sc_hd__fill_1
XTAP_TAPCELL_ROW_78_1238 VGND VPWR sky130_fd_sc_hd__tapvpwrvgnd_1
XFILLER_107_3 VPWR VGND VPWR VGND sky130_ef_sc_hd__decap_12
XFILLER_106_321 VPWR VGND VPWR VGND sky130_ef_sc_hd__decap_12
XTAP_TAPCELL_ROW_91_1405 VGND VPWR sky130_fd_sc_hd__tapvpwrvgnd_1
XFILLER_69_23 VGND VGND VPWR VPWR sky130_fd_sc_hd__decap_6
XFILLER_106_365 VPWR VGND VPWR VGND sky130_ef_sc_hd__decap_12
XFILLER_79_205 VPWR VGND VPWR VGND sky130_ef_sc_hd__decap_12
XFILLER_121_335 VGND VGND VPWR VPWR sky130_fd_sc_hd__fill_1
XFILLER_0_610 VGND VGND VPWR VPWR sky130_fd_sc_hd__decap_6
XFILLER_95_709 VGND VGND VPWR VPWR sky130_fd_sc_hd__fill_1
XFILLER_0_643 VGND VGND VPWR VPWR sky130_fd_sc_hd__fill_1
XFILLER_0_676 VGND VGND VPWR VPWR sky130_fd_sc_hd__decap_8
XFILLER_0_687 VPWR VGND VPWR VGND sky130_ef_sc_hd__decap_12
XFILLER_47_113 VGND VGND VPWR VPWR sky130_fd_sc_hd__decap_8
XFILLER_85_55 VGND VGND VPWR VPWR sky130_fd_sc_hd__fill_1
XTAP_TAPCELL_ROW_89_1378 VGND VPWR sky130_fd_sc_hd__tapvpwrvgnd_1
XFILLER_18_93 VPWR VGND VPWR VGND sky130_ef_sc_hd__decap_12
XFILLER_28_393 VGND VGND VPWR VPWR sky130_fd_sc_hd__decap_3
XTAP_TAPCELL_ROW_46_837 VGND VPWR sky130_fd_sc_hd__tapvpwrvgnd_1
XFILLER_90_458 VPWR VGND VPWR VGND sky130_ef_sc_hd__decap_12
XTAP_TAPCELL_ROW_26_583 VGND VPWR sky130_fd_sc_hd__tapvpwrvgnd_1
XFILLER_43_374 VGND VGND VPWR VPWR sky130_fd_sc_hd__decap_8
XTAP_TAPCELL_ROW_100_1512 VGND VPWR sky130_fd_sc_hd__tapvpwrvgnd_1
XFILLER_70_193 VGND VGND VPWR VPWR sky130_fd_sc_hd__decap_3
XTAP_TAPCELL_ROW_26_594 VGND VPWR sky130_fd_sc_hd__tapvpwrvgnd_1
XFILLER_34_70 VGND VGND VPWR VPWR sky130_fd_sc_hd__decap_6
XFILLER_8_721 VGND VGND VPWR VPWR sky130_fd_sc_hd__fill_2
XFILLER_109_181 VPWR VGND VPWR VGND sky130_ef_sc_hd__decap_12
X_3330_ _1255_ _1267_ VGND VGND VPWR VPWR _1268_ sky130_fd_sc_hd__nand2_1
XFILLER_112_357 VGND VGND VPWR VPWR sky130_fd_sc_hd__decap_6
XTAP_TAPCELL_ROW_111_1652 VGND VPWR sky130_fd_sc_hd__tapvpwrvgnd_1
X_3261_ reg_file_inst.registry\[4\]\[24\] _1092_ _1095_ JMPOFF\[24\] _1201_ VGND VGND
+ VPWR VPWR _1202_ sky130_fd_sc_hd__a221o_1
X_5000_ _2656_ _2669_ _2665_ VGND VGND VPWR VPWR _2843_ sky130_fd_sc_hd__o21ai_1
XFILLER_85_219 VGND VGND VPWR VPWR sky130_fd_sc_hd__decap_4
X_3192_ _1114_ net143 VGND VGND VPWR VPWR _1136_ sky130_fd_sc_hd__and2_4
XFILLER_22_3 VGND VGND VPWR VPWR sky130_fd_sc_hd__decap_8
XFILLER_38_102 VGND VGND VPWR VPWR sky130_fd_sc_hd__decap_4
XFILLER_39_669 VGND VGND VPWR VPWR sky130_fd_sc_hd__decap_3
XFILLER_93_252 VGND VGND VPWR VPWR sky130_fd_sc_hd__fill_2
XFILLER_66_477 VPWR VGND VPWR VGND sky130_ef_sc_hd__decap_12
XFILLER_81_447 VGND VGND VPWR VPWR sky130_fd_sc_hd__fill_1
XFILLER_19_393 VGND VGND VPWR VPWR sky130_fd_sc_hd__decap_3
XFILLER_47_691 VPWR VGND VPWR VGND sky130_ef_sc_hd__decap_12
XFILLER_81_458 VGND VGND VPWR VPWR sky130_fd_sc_hd__decap_6
XFILLER_62_650 VGND VGND VPWR VPWR sky130_fd_sc_hd__decap_6
X_5902_ net147 VGND VGND VPWR VPWR _0310_ sky130_fd_sc_hd__inv_2
XFILLER_34_352 VGND VGND VPWR VPWR sky130_fd_sc_hd__fill_2
X_5833_ net148 VGND VGND VPWR VPWR _0241_ sky130_fd_sc_hd__inv_2
XFILLER_22_525 VGND VGND VPWR VPWR sky130_fd_sc_hd__decap_6
XTAP_TAPCELL_ROW_122_1792 VGND VPWR sky130_fd_sc_hd__tapvpwrvgnd_1
XTAP_TAPCELL_ROW_62_1039 VGND VPWR sky130_fd_sc_hd__tapvpwrvgnd_1
XFILLER_14_29 VPWR VGND VPWR VGND sky130_ef_sc_hd__decap_12
XFILLER_22_569 VPWR VGND VPWR VGND sky130_ef_sc_hd__decap_12
XFILLER_34_396 VGND VGND VPWR VPWR sky130_fd_sc_hd__decap_6
X_5764_ net146 VGND VGND VPWR VPWR _0172_ sky130_fd_sc_hd__inv_2
X_5695_ net147 VGND VGND VPWR VPWR _0103_ sky130_fd_sc_hd__inv_2
X_4715_ _1217_ _2573_ VGND VGND VPWR VPWR _2574_ sky130_fd_sc_hd__nand2_1
X_4646_ _2517_ _2520_ _1708_ VGND VGND VPWR VPWR _2521_ sky130_fd_sc_hd__mux2_1
X_4577_ _2130_ _2305_ VGND VGND VPWR VPWR _2456_ sky130_fd_sc_hd__nor2_1
X_6316_ clknet_leaf_23_clk _0724_ _0249_ VGND VGND VPWR VPWR reg_file_inst.registry\[3\]\[25\]
+ sky130_fd_sc_hd__dfrtp_1
XFILLER_1_407 VGND VGND VPWR VPWR sky130_fd_sc_hd__fill_1
X_3528_ reg_file_inst.registry\[8\]\[13\] _1114_ net143 VGND VGND VPWR VPWR _1459_
+ sky130_fd_sc_hd__and3_1
XFILLER_39_15 VGND VGND VPWR VPWR sky130_fd_sc_hd__decap_3
X_3459_ MEMOFF\[16\] net80 _1113_ VGND VGND VPWR VPWR _1392_ sky130_fd_sc_hd__mux2_8
XTAP_TAPCELL_ROW_73_1179 VGND VPWR sky130_fd_sc_hd__tapvpwrvgnd_1
X_6247_ clknet_leaf_10_clk _0655_ _0180_ VGND VGND VPWR VPWR reg_file_inst.registry\[4\]\[12\]
+ sky130_fd_sc_hd__dfrtp_1
X_6178_ clknet_leaf_19_clk _0586_ _0111_ VGND VGND VPWR VPWR JMPOFF\[27\] sky130_fd_sc_hd__dfrtp_1
X_5129_ _1552_ _2124_ _2287_ _1567_ _2289_ VGND VGND VPWR VPWR _2954_ sky130_fd_sc_hd__o221a_1
XFILLER_29_113 VGND VGND VPWR VPWR sky130_fd_sc_hd__decap_3
XFILLER_29_135 VPWR VGND VPWR VGND sky130_ef_sc_hd__decap_12
XFILLER_72_403 VGND VGND VPWR VPWR sky130_fd_sc_hd__decap_8
XFILLER_45_617 VPWR VGND VPWR VGND sky130_ef_sc_hd__decap_12
XTAP_TAPCELL_ROW_43_807 VGND VPWR sky130_fd_sc_hd__tapvpwrvgnd_1
XFILLER_13_503 VGND VGND VPWR VPWR sky130_fd_sc_hd__fill_1
XFILLER_25_363 VGND VGND VPWR VPWR sky130_fd_sc_hd__decap_8
XFILLER_71_57 VGND VGND VPWR VPWR sky130_fd_sc_hd__decap_8
XTAP_TAPCELL_ROW_23_553 VGND VPWR sky130_fd_sc_hd__tapvpwrvgnd_1
XFILLER_21_580 VGND VGND VPWR VPWR sky130_fd_sc_hd__fill_1
XFILLER_107_641 VPWR VGND VPWR VGND sky130_ef_sc_hd__decap_12
XFILLER_107_685 VPWR VGND VPWR VGND sky130_ef_sc_hd__decap_12
XFILLER_4_278 VPWR VGND VPWR VGND sky130_ef_sc_hd__decap_12
XFILLER_106_195 VGND VGND VPWR VPWR sky130_fd_sc_hd__fill_1
XFILLER_95_539 VPWR VGND VPWR VGND sky130_ef_sc_hd__decap_12
XFILLER_95_517 VPWR VGND VPWR VGND sky130_ef_sc_hd__decap_12
XFILLER_48_477 VGND VGND VPWR VPWR sky130_fd_sc_hd__decap_8
XFILLER_16_352 VGND VGND VPWR VPWR sky130_fd_sc_hd__fill_1
XFILLER_31_388 VGND VGND VPWR VPWR sky130_fd_sc_hd__decap_4
XFILLER_117_405 VPWR VGND VPWR VGND sky130_ef_sc_hd__decap_12
X_5480_ JMPOFF\[25\] _2767_ _3000_ VGND VGND VPWR VPWR _0584_ sky130_fd_sc_hd__mux2_1
X_4500_ _2196_ _2230_ _1816_ VGND VGND VPWR VPWR _2383_ sky130_fd_sc_hd__mux2_1
XFILLER_117_449 VPWR VGND VPWR VGND sky130_ef_sc_hd__decap_12
XANTENNA_1 JMPOFF\[25\] VGND VGND VPWR VPWR sky130_fd_sc_hd__diode_2
XFILLER_6_41 VPWR VGND VPWR VGND sky130_ef_sc_hd__decap_12
X_4431_ net132 _1852_ _2190_ VGND VGND VPWR VPWR _2316_ sky130_fd_sc_hd__and3_1
XFILLER_6_85 VPWR VGND VPWR VGND sky130_ef_sc_hd__decap_12
X_4362_ _2248_ _2249_ VGND VGND VPWR VPWR _2250_ sky130_fd_sc_hd__or2_1
XFILLER_112_121 VPWR VGND VPWR VGND sky130_ef_sc_hd__decap_12
X_3313_ reg_file_inst.registry\[9\]\[22\] _1089_ _1094_ reg_file_inst.registry\[6\]\[22\]
+ VGND VGND VPWR VPWR _1252_ sky130_fd_sc_hd__a22o_1
X_4293_ _1231_ _1255_ VGND VGND VPWR VPWR _2181_ sky130_fd_sc_hd__nor2_1
X_6101_ clknet_leaf_3_clk _0509_ _0034_ VGND VGND VPWR VPWR reg_file_inst.registry\[9\]\[6\]
+ sky130_fd_sc_hd__dfrtp_1
XFILLER_112_165 VPWR VGND VPWR VGND sky130_ef_sc_hd__decap_12
X_3244_ reg_file_inst.registry\[6\]\[25\] _1135_ _1142_ reg_file_inst.registry\[1\]\[25\]
+ VGND VGND VPWR VPWR _1186_ sky130_fd_sc_hd__a22o_1
X_6032_ net149 VGND VGND VPWR VPWR _0440_ sky130_fd_sc_hd__inv_2
XFILLER_82_701 VPWR VGND VPWR VGND sky130_ef_sc_hd__decap_12
X_3175_ net29 net35 VGND VGND VPWR VPWR _1119_ sky130_fd_sc_hd__and2_4
XFILLER_27_606 VGND VGND VPWR VPWR sky130_fd_sc_hd__decap_8
XFILLER_66_274 VPWR VGND VPWR VGND sky130_ef_sc_hd__decap_12
XFILLER_50_642 VGND VGND VPWR VPWR sky130_fd_sc_hd__fill_2
X_5816_ net149 VGND VGND VPWR VPWR _0224_ sky130_fd_sc_hd__inv_2
X_5747_ net44 VGND VGND VPWR VPWR _0155_ sky130_fd_sc_hd__inv_2
XTAP_TAPCELL_ROW_20_512 VGND VPWR sky130_fd_sc_hd__tapvpwrvgnd_1
XFILLER_41_38 VGND VGND VPWR VPWR sky130_fd_sc_hd__decap_6
X_5678_ net147 VGND VGND VPWR VPWR _0086_ sky130_fd_sc_hd__inv_2
X_4629_ _1791_ _2378_ _2503_ VGND VGND VPWR VPWR _2504_ sky130_fd_sc_hd__a21oi_1
XFILLER_1_248 VGND VGND VPWR VPWR sky130_fd_sc_hd__fill_2
XFILLER_106_53 VPWR VGND VPWR VGND sky130_ef_sc_hd__decap_12
XFILLER_104_699 VGND VGND VPWR VPWR sky130_fd_sc_hd__fill_1
XFILLER_103_165 VGND VGND VPWR VPWR sky130_fd_sc_hd__decap_3
XFILLER_89_377 VPWR VGND VPWR VGND sky130_ef_sc_hd__decap_12
XFILLER_66_35 VGND VGND VPWR VPWR sky130_fd_sc_hd__decap_4
XFILLER_106_97 VPWR VGND VPWR VGND sky130_ef_sc_hd__decap_12
XFILLER_57_252 VPWR VGND VPWR VGND sky130_ef_sc_hd__decap_12
XFILLER_122_41 VPWR VGND VPWR VGND sky130_ef_sc_hd__decap_12
XTAP_TAPCELL_ROW_86_1337 VGND VPWR sky130_fd_sc_hd__tapvpwrvgnd_1
XTAP_TAPCELL_ROW_28_612 VGND VPWR sky130_fd_sc_hd__tapvpwrvgnd_1
XFILLER_82_23 VGND VGND VPWR VPWR sky130_fd_sc_hd__decap_4
XFILLER_72_244 VGND VGND VPWR VPWR sky130_fd_sc_hd__decap_8
XTAP_TAPCELL_ROW_56_965 VGND VPWR sky130_fd_sc_hd__tapvpwrvgnd_1
XFILLER_122_85 VPWR VGND VPWR VGND sky130_ef_sc_hd__decap_12
XFILLER_72_288 VPWR VGND VPWR VGND sky130_ef_sc_hd__decap_12
XFILLER_72_277 VGND VGND VPWR VPWR sky130_fd_sc_hd__decap_8
XTAP_TAPCELL_ROW_0_270 VGND VPWR sky130_fd_sc_hd__tapvpwrvgnd_1
XFILLER_60_439 VGND VGND VPWR VPWR sky130_fd_sc_hd__decap_3
XFILLER_9_337 VGND VGND VPWR VPWR sky130_fd_sc_hd__decap_3
XFILLER_13_399 VPWR VGND VPWR VGND sky130_ef_sc_hd__decap_12
XFILLER_41_697 VGND VGND VPWR VPWR sky130_fd_sc_hd__decap_6
XFILLER_99_108 VGND VGND VPWR VPWR sky130_fd_sc_hd__decap_4
XTAP_TAPCELL_ROW_97_1477 VGND VPWR sky130_fd_sc_hd__tapvpwrvgnd_1
XFILLER_114_419 VGND VGND VPWR VPWR sky130_fd_sc_hd__fill_1
Xoutput60 net60 VGND VGND VPWR VPWR DataAddress[23] sky130_fd_sc_hd__buf_1
XFILLER_110_625 VPWR VGND VPWR VGND sky130_ef_sc_hd__decap_12
Xoutput82 net82 VGND VGND VPWR VPWR DataMemoryWrite[18] sky130_fd_sc_hd__buf_1
Xoutput93 net93 VGND VGND VPWR VPWR DataMemoryWrite[2] sky130_fd_sc_hd__buf_1
XTAP_TAPCELL_ROW_8_370 VGND VPWR sky130_fd_sc_hd__tapvpwrvgnd_1
Xoutput71 net71 VGND VGND VPWR VPWR DataAddress[8] sky130_fd_sc_hd__buf_1
XFILLER_110_669 VPWR VGND VPWR VGND sky130_ef_sc_hd__decap_12
XFILLER_64_701 VGND VGND VPWR VPWR sky130_fd_sc_hd__fill_1
XFILLER_0_292 VGND VGND VPWR VPWR sky130_fd_sc_hd__fill_2
XFILLER_63_288 VGND VGND VPWR VPWR sky130_fd_sc_hd__fill_1
XFILLER_63_277 VGND VGND VPWR VPWR sky130_fd_sc_hd__decap_3
X_4980_ _1765_ _2296_ _2392_ _2826_ VGND VGND VPWR VPWR _2827_ sky130_fd_sc_hd__a31o_1
XFILLER_23_119 VGND VGND VPWR VPWR sky130_fd_sc_hd__fill_1
XTAP_TAPCELL_ROW_106_1595 VGND VPWR sky130_fd_sc_hd__tapvpwrvgnd_1
XTAP_TAPCELL_ROW_106_1584 VGND VPWR sky130_fd_sc_hd__tapvpwrvgnd_1
XFILLER_16_171 VGND VGND VPWR VPWR sky130_fd_sc_hd__fill_1
X_3931_ reg_file_inst.registry\[3\]\[0\] _1140_ _1141_ reg_file_inst.registry\[11\]\[0\]
+ VGND VGND VPWR VPWR _1848_ sky130_fd_sc_hd__a22o_1
XFILLER_31_130 VGND VGND VPWR VPWR sky130_fd_sc_hd__fill_2
X_3862_ MEMOFF\[2\] _1079_ _1086_ reg_file_inst.registry\[7\]\[2\] VGND VGND VPWR
+ VPWR _1781_ sky130_fd_sc_hd__a22o_1
X_5601_ net148 VGND VGND VPWR VPWR _0009_ sky130_fd_sc_hd__inv_2
XFILLER_118_725 VGND VGND VPWR VPWR sky130_fd_sc_hd__fill_1
X_5532_ reg_file_inst.registry\[6\]\[2\] _2501_ _3001_ VGND VGND VPWR VPWR _0533_
+ sky130_fd_sc_hd__mux2_1
X_3793_ reg_file_inst.registry\[10\]\[4\] _1126_ _1141_ reg_file_inst.registry\[11\]\[4\]
+ VGND VGND VPWR VPWR _1715_ sky130_fd_sc_hd__a22o_1
X_5463_ reg_file_inst.registry\[5\]\[13\] _2922_ _2999_ VGND VGND VPWR VPWR _0600_
+ sky130_fd_sc_hd__mux2_1
XFILLER_117_279 VGND VGND VPWR VPWR sky130_fd_sc_hd__fill_1
X_5394_ reg_file_inst.registry\[4\]\[24\] _2787_ _2997_ VGND VGND VPWR VPWR _0667_
+ sky130_fd_sc_hd__mux2_1
X_4414_ _2300_ _2301_ VGND VGND VPWR VPWR _2302_ sky130_fd_sc_hd__nor2_1
XFILLER_113_441 VGND VGND VPWR VPWR sky130_fd_sc_hd__decap_6
XFILLER_99_653 VPWR VGND VPWR VGND sky130_ef_sc_hd__decap_12
XFILLER_98_130 VGND VGND VPWR VPWR sky130_fd_sc_hd__decap_8
X_4345_ _2230_ _2232_ _1816_ VGND VGND VPWR VPWR _2233_ sky130_fd_sc_hd__mux2_1
XFILLER_99_697 VPWR VGND VPWR VGND sky130_ef_sc_hd__decap_12
XTAP_TAPCELL_ROW_70_1138 VGND VPWR sky130_fd_sc_hd__tapvpwrvgnd_1
XFILLER_113_485 VPWR VGND VPWR VGND sky130_ef_sc_hd__decap_12
X_4276_ _1802_ _2156_ VGND VGND VPWR VPWR _2164_ sky130_fd_sc_hd__xnor2_1
X_6015_ net146 VGND VGND VPWR VPWR _0423_ sky130_fd_sc_hd__inv_2
X_3227_ reg_file_inst.registry\[7\]\[26\] _1133_ _1166_ _1167_ _1169_ VGND VGND VPWR
+ VPWR _1170_ sky130_fd_sc_hd__a2111o_1
XFILLER_67_561 VPWR VGND VPWR VGND sky130_ef_sc_hd__decap_12
X_3158_ reg_file_inst.registry\[2\]\[27\] _1083_ _1101_ net139 VGND VGND VPWR VPWR
+ _1102_ sky130_fd_sc_hd__a211o_1
XFILLER_55_712 VGND VGND VPWR VPWR sky130_fd_sc_hd__decap_6
XFILLER_36_27 VGND VGND VPWR VPWR sky130_fd_sc_hd__fill_1
XFILLER_82_531 VGND VGND VPWR VPWR sky130_fd_sc_hd__fill_1
XTAP_TAPCELL_ROW_53_924 VGND VPWR sky130_fd_sc_hd__tapvpwrvgnd_1
XFILLER_14_119 VPWR VGND VPWR VGND sky130_ef_sc_hd__decap_12
X_3089_ _1028_ _1032_ VGND VGND VPWR VPWR _1033_ sky130_fd_sc_hd__nand2_1
XFILLER_23_620 VGND VGND VPWR VPWR sky130_fd_sc_hd__decap_6
XTAP_TAPCELL_ROW_81_1278 VGND VPWR sky130_fd_sc_hd__tapvpwrvgnd_1
XFILLER_10_303 VGND VGND VPWR VPWR sky130_fd_sc_hd__decap_4
XFILLER_22_174 VGND VGND VPWR VPWR sky130_fd_sc_hd__fill_1
XTAP_TAPCELL_ROW_33_681 VGND VPWR sky130_fd_sc_hd__tapvpwrvgnd_1
XFILLER_109_725 VGND VGND VPWR VPWR sky130_fd_sc_hd__fill_1
XFILLER_2_557 VPWR VGND VPWR VGND sky130_ef_sc_hd__decap_12
XFILLER_89_141 VGND VGND VPWR VPWR sky130_fd_sc_hd__fill_1
XFILLER_77_34 VGND VGND VPWR VPWR sky130_fd_sc_hd__decap_8
XFILLER_104_496 VPWR VGND VPWR VGND sky130_ef_sc_hd__decap_12
XFILLER_77_89 VGND VGND VPWR VPWR sky130_fd_sc_hd__fill_1
XFILLER_46_701 VGND VGND VPWR VPWR sky130_fd_sc_hd__fill_2
XFILLER_92_339 VPWR VGND VPWR VGND sky130_ef_sc_hd__decap_12
XTAP_TAPCELL_ROW_99_1506 VGND VPWR sky130_fd_sc_hd__tapvpwrvgnd_1
XFILLER_9_123 VPWR VGND VPWR VGND sky130_ef_sc_hd__decap_12
XFILLER_14_686 VGND VGND VPWR VPWR sky130_fd_sc_hd__decap_6
XTAP_TAPCELL_ROW_11_397 VGND VPWR sky130_fd_sc_hd__tapvpwrvgnd_1
XFILLER_5_373 VGND VGND VPWR VPWR sky130_fd_sc_hd__decap_4
XPHY_EDGE_ROW_39_Left_162 VGND VGND VPWR VPWR sky130_fd_sc_hd__decap_3
XFILLER_96_601 VPWR VGND VPWR VGND sky130_ef_sc_hd__decap_12
X_4130_ _2028_ _2032_ _2026_ VGND VGND VPWR VPWR _2046_ sky130_fd_sc_hd__a21oi_1
XFILLER_122_293 VPWR VGND VPWR VGND sky130_ef_sc_hd__decap_12
XFILLER_110_433 VPWR VGND VPWR VGND sky130_ef_sc_hd__decap_12
XFILLER_96_645 VPWR VGND VPWR VGND sky130_ef_sc_hd__decap_12
XFILLER_3_97 VPWR VGND VPWR VGND sky130_ef_sc_hd__decap_12
X_4061_ _0992_ _1024_ _1027_ VGND VGND VPWR VPWR _1977_ sky130_fd_sc_hd__or3_1
XFILLER_49_561 VGND VGND VPWR VPWR sky130_fd_sc_hd__decap_8
XFILLER_110_477 VPWR VGND VPWR VGND sky130_ef_sc_hd__decap_12
XTAP_TAPCELL_ROW_108_1613 VGND VPWR sky130_fd_sc_hd__tapvpwrvgnd_1
XFILLER_83_328 VGND VGND VPWR VPWR sky130_fd_sc_hd__decap_8
X_3012_ net36 VGND VGND VPWR VPWR _0958_ sky130_fd_sc_hd__inv_2
XFILLER_64_531 VGND VGND VPWR VPWR sky130_fd_sc_hd__fill_1
XFILLER_36_244 VGND VGND VPWR VPWR sky130_fd_sc_hd__fill_1
XFILLER_64_586 VGND VGND VPWR VPWR sky130_fd_sc_hd__fill_2
XPHY_EDGE_ROW_48_Left_171 VGND VGND VPWR VPWR sky130_fd_sc_hd__decap_3
X_4963_ _1790_ _2734_ VGND VGND VPWR VPWR _2812_ sky130_fd_sc_hd__or2_1
XTAP_TAPCELL_ROW_19_497 VGND VPWR sky130_fd_sc_hd__tapvpwrvgnd_1
X_3914_ reg_file_inst.registry\[14\]\[0\] _1077_ _1080_ VGND VGND VPWR VPWR _1831_
+ sky130_fd_sc_hd__and3_1
X_4894_ _2177_ _2676_ _2748_ VGND VGND VPWR VPWR _2749_ sky130_fd_sc_hd__or3_1
XFILLER_22_29 VPWR VGND VPWR VGND sky130_ef_sc_hd__decap_12
XTAP_TAPCELL_ROW_30_640 VGND VPWR sky130_fd_sc_hd__tapvpwrvgnd_1
X_3845_ reg_file_inst.registry\[0\]\[3\] net138 _1757_ _1763_ VGND VGND VPWR VPWR
+ _1765_ sky130_fd_sc_hd__o22ai_4
XFILLER_118_533 VPWR VGND VPWR VGND sky130_ef_sc_hd__decap_12
XTAP_TAPCELL_ROW_119_1753 VGND VPWR sky130_fd_sc_hd__tapvpwrvgnd_1
X_3776_ reg_file_inst.registry\[4\]\[4\] _1074_ _1084_ VGND VGND VPWR VPWR _1698_
+ sky130_fd_sc_hd__and3_1
X_5515_ reg_file_inst.registry\[6\]\[19\] _2854_ _3001_ VGND VGND VPWR VPWR _0550_
+ sky130_fd_sc_hd__mux2_1
X_6495_ clknet_leaf_31_clk _0903_ _0428_ VGND VGND VPWR VPWR reg_file_inst.registry\[11\]\[24\]
+ sky130_fd_sc_hd__dfrtp_1
XPHY_EDGE_ROW_57_Left_180 VGND VGND VPWR VPWR sky130_fd_sc_hd__decap_3
XFILLER_105_205 VPWR VGND VPWR VGND sky130_ef_sc_hd__decap_12
X_5446_ _2528_ reg_file_inst.registry\[10\]\[1\] _2998_ VGND VGND VPWR VPWR _0616_
+ sky130_fd_sc_hd__mux2_1
XFILLER_121_709 VPWR VGND VPWR VGND sky130_ef_sc_hd__decap_12
XFILLER_105_249 VPWR VGND VPWR VGND sky130_ef_sc_hd__decap_12
X_5377_ MEMOFF\[12\] _2934_ _2996_ VGND VGND VPWR VPWR _0683_ sky130_fd_sc_hd__mux2_1
XFILLER_86_122 VGND VGND VPWR VPWR sky130_fd_sc_hd__decap_6
X_4328_ _1840_ _2215_ VGND VGND VPWR VPWR _2216_ sky130_fd_sc_hd__nor2_1
XFILLER_113_293 VPWR VGND VPWR VGND sky130_ef_sc_hd__decap_12
XFILLER_101_444 VGND VGND VPWR VPWR sky130_fd_sc_hd__decap_4
XFILLER_74_306 VGND VGND VPWR VPWR sky130_fd_sc_hd__fill_2
XFILLER_59_369 VPWR VGND VPWR VGND sky130_ef_sc_hd__decap_12
X_4259_ _2127_ _2131_ VGND VGND VPWR VPWR _2147_ sky130_fd_sc_hd__nand2_1
XFILLER_47_15 VPWR VGND VPWR VGND sky130_ef_sc_hd__decap_12
XFILLER_28_701 VGND VGND VPWR VPWR sky130_fd_sc_hd__decap_3
XTAP_TAPCELL_ROW_38_740 VGND VPWR sky130_fd_sc_hd__tapvpwrvgnd_1
XTAP_TAPCELL_ROW_83_1307 VGND VPWR sky130_fd_sc_hd__tapvpwrvgnd_1
XFILLER_27_255 VPWR VGND VPWR VGND sky130_ef_sc_hd__decap_12
XFILLER_42_247 VGND VGND VPWR VPWR sky130_fd_sc_hd__decap_4
XFILLER_70_589 VPWR VGND VPWR VGND sky130_ef_sc_hd__decap_12
XFILLER_23_461 VPWR VGND VPWR VGND sky130_ef_sc_hd__decap_12
XFILLER_50_280 VGND VGND VPWR VPWR sky130_fd_sc_hd__decap_6
XFILLER_10_166 VGND VGND VPWR VPWR sky130_fd_sc_hd__fill_1
XFILLER_6_148 VGND VGND VPWR VPWR sky130_fd_sc_hd__decap_4
XTAP_TAPCELL_ROW_94_1436 VGND VPWR sky130_fd_sc_hd__tapvpwrvgnd_1
XFILLER_12_95 VGND VGND VPWR VPWR sky130_fd_sc_hd__decap_8
XFILLER_88_77 VGND VGND VPWR VPWR sky130_fd_sc_hd__decap_6
XFILLER_78_601 VPWR VGND VPWR VGND sky130_ef_sc_hd__decap_12
XFILLER_2_365 VGND VGND VPWR VPWR sky130_fd_sc_hd__decap_6
XFILLER_78_645 VPWR VGND VPWR VGND sky130_ef_sc_hd__decap_12
XFILLER_77_122 VGND VGND VPWR VPWR sky130_fd_sc_hd__fill_1
XFILLER_65_317 VPWR VGND VPWR VGND sky130_ef_sc_hd__decap_12
XFILLER_18_222 VGND VGND VPWR VPWR sky130_fd_sc_hd__fill_1
XFILLER_46_520 VPWR VGND VPWR VGND sky130_ef_sc_hd__decap_12
XFILLER_80_309 VGND VGND VPWR VPWR sky130_fd_sc_hd__decap_6
XFILLER_18_277 VGND VGND VPWR VPWR sky130_fd_sc_hd__decap_4
XFILLER_37_81 VGND VGND VPWR VPWR sky130_fd_sc_hd__decap_6
XFILLER_46_586 VGND VGND VPWR VPWR sky130_fd_sc_hd__fill_2
XTAP_TAPCELL_ROW_103_1554 VGND VPWR sky130_fd_sc_hd__tapvpwrvgnd_1
XFILLER_33_258 VGND VGND VPWR VPWR sky130_fd_sc_hd__decap_8
XTAP_TAPCELL_ROW_16_467 VGND VPWR sky130_fd_sc_hd__tapvpwrvgnd_1
X_3630_ reg_file_inst.registry\[10\]\[10\] _1123_ net144 VGND VGND VPWR VPWR _1557_
+ sky130_fd_sc_hd__and3_1
X_3561_ reg_file_inst.registry\[0\]\[15\] _1118_ _1485_ _1490_ VGND VGND VPWR VPWR
+ net79 sky130_fd_sc_hd__o22a_1
XFILLER_115_503 VGND VGND VPWR VPWR sky130_fd_sc_hd__fill_1
X_5300_ _2501_ reg_file_inst.registry\[2\]\[2\] _2993_ VGND VGND VPWR VPWR _0757_
+ sky130_fd_sc_hd__mux2_1
X_6280_ clknet_leaf_8_clk _0688_ _0213_ VGND VGND VPWR VPWR MEMOFF\[17\] sky130_fd_sc_hd__dfrtp_1
X_3492_ reg_file_inst.registry\[14\]\[12\] _1081_ _1095_ JMPOFF\[12\] VGND VGND VPWR
+ VPWR _1424_ sky130_fd_sc_hd__a22o_1
XFILLER_6_693 VGND VGND VPWR VPWR sky130_fd_sc_hd__decap_6
XTAP_TAPCELL_ROW_114_1683 VGND VPWR sky130_fd_sc_hd__tapvpwrvgnd_1
XFILLER_103_709 VGND VGND VPWR VPWR sky130_fd_sc_hd__decap_8
XFILLER_88_409 VGND VGND VPWR VPWR sky130_fd_sc_hd__decap_8
X_5231_ _2934_ reg_file_inst.registry\[1\]\[12\] _2990_ VGND VGND VPWR VPWR _0823_
+ sky130_fd_sc_hd__mux2_1
XTAP_TAPCELL_ROW_114_1694 VGND VPWR sky130_fd_sc_hd__tapvpwrvgnd_1
X_5162_ _1620_ _2282_ _2285_ _1639_ _2982_ VGND VGND VPWR VPWR _2983_ sky130_fd_sc_hd__o221ai_4
X_4113_ _2026_ _2027_ VGND VGND VPWR VPWR _2029_ sky130_fd_sc_hd__nor2_1
X_5093_ reg_file_inst.registry\[7\]\[13\] _2922_ _2553_ VGND VGND VPWR VPWR _0888_
+ sky130_fd_sc_hd__mux2_1
XFILLER_69_689 VGND VGND VPWR VPWR sky130_fd_sc_hd__fill_1
X_4044_ _1955_ _1959_ VGND VGND VPWR VPWR _1960_ sky130_fd_sc_hd__nand2b_1
XFILLER_83_169 VGND VGND VPWR VPWR sky130_fd_sc_hd__decap_6
XFILLER_92_681 VPWR VGND VPWR VGND sky130_ef_sc_hd__decap_12
X_5995_ net148 VGND VGND VPWR VPWR _0403_ sky130_fd_sc_hd__inv_2
XFILLER_52_578 VGND VGND VPWR VPWR sky130_fd_sc_hd__decap_8
XFILLER_52_567 VGND VGND VPWR VPWR sky130_fd_sc_hd__decap_8
X_4946_ _1790_ _2696_ VGND VGND VPWR VPWR _2797_ sky130_fd_sc_hd__nor2_1
X_4877_ _2732_ _2733_ net134 VGND VGND VPWR VPWR _2734_ sky130_fd_sc_hd__mux2_1
XFILLER_20_442 VPWR VGND VPWR VGND sky130_ef_sc_hd__decap_12
X_3828_ reg_file_inst.registry\[14\]\[5\] _1138_ _1741_ _1742_ _1744_ VGND VGND VPWR
+ VPWR _1749_ sky130_fd_sc_hd__a2111o_1
XFILLER_118_363 VGND VGND VPWR VPWR sky130_fd_sc_hd__fill_1
XFILLER_106_525 VGND VGND VPWR VPWR sky130_fd_sc_hd__decap_6
X_3759_ reg_file_inst.registry\[15\]\[6\] _1122_ _1129_ MEMOFF\[6\] VGND VGND VPWR
+ VPWR _1682_ sky130_fd_sc_hd__a22o_1
X_6478_ clknet_leaf_0_clk _0886_ _0411_ VGND VGND VPWR VPWR reg_file_inst.registry\[7\]\[11\]
+ sky130_fd_sc_hd__dfrtp_1
XFILLER_121_517 VPWR VGND VPWR VGND sky130_ef_sc_hd__decap_12
XFILLER_106_569 VPWR VGND VPWR VGND sky130_ef_sc_hd__decap_12
X_5429_ _2863_ reg_file_inst.registry\[10\]\[18\] _2998_ VGND VGND VPWR VPWR _0633_
+ sky130_fd_sc_hd__mux2_1
XFILLER_59_133 VPWR VGND VPWR VGND sky130_ef_sc_hd__decap_12
XFILLER_59_166 VGND VGND VPWR VPWR sky130_fd_sc_hd__fill_2
XFILLER_114_53 VPWR VGND VPWR VGND sky130_ef_sc_hd__decap_12
XFILLER_101_296 VGND VGND VPWR VPWR sky130_fd_sc_hd__fill_2
XFILLER_74_136 VGND VGND VPWR VPWR sky130_fd_sc_hd__decap_4
XFILLER_114_97 VPWR VGND VPWR VGND sky130_ef_sc_hd__decap_12
XFILLER_83_670 VGND VGND VPWR VPWR sky130_fd_sc_hd__fill_2
XFILLER_62_309 VPWR VGND VPWR VGND sky130_ef_sc_hd__decap_12
XFILLER_16_715 VGND VGND VPWR VPWR sky130_fd_sc_hd__decap_3
XFILLER_43_501 VGND VGND VPWR VPWR sky130_fd_sc_hd__decap_3
XFILLER_55_372 VGND VGND VPWR VPWR sky130_fd_sc_hd__fill_2
XFILLER_15_225 VGND VGND VPWR VPWR sky130_fd_sc_hd__decap_4
XFILLER_70_342 VPWR VGND VPWR VGND sky130_ef_sc_hd__decap_12
XFILLER_90_23 VGND VGND VPWR VPWR sky130_fd_sc_hd__decap_4
XFILLER_30_206 VGND VGND VPWR VPWR sky130_fd_sc_hd__decap_3
XFILLER_90_67 VGND VGND VPWR VPWR sky130_fd_sc_hd__decap_4
XTAP_TAPCELL_ROW_13_426 VGND VPWR sky130_fd_sc_hd__tapvpwrvgnd_1
XTAP_TAPCELL_ROW_41_779 VGND VPWR sky130_fd_sc_hd__tapvpwrvgnd_1
XFILLER_109_385 VGND VGND VPWR VPWR sky130_fd_sc_hd__decap_6
XFILLER_3_641 VPWR VGND VPWR VGND sky130_ef_sc_hd__decap_12
XFILLER_3_685 VPWR VGND VPWR VGND sky130_ef_sc_hd__decap_12
XFILLER_2_162 VGND VGND VPWR VPWR sky130_fd_sc_hd__fill_1
XFILLER_78_442 VPWR VGND VPWR VGND sky130_ef_sc_hd__decap_12
XFILLER_2_195 VGND VGND VPWR VPWR sky130_fd_sc_hd__fill_1
XFILLER_78_475 VGND VGND VPWR VPWR sky130_fd_sc_hd__fill_1
XFILLER_93_456 VGND VGND VPWR VPWR sky130_fd_sc_hd__decap_6
XFILLER_66_659 VGND VGND VPWR VPWR sky130_fd_sc_hd__fill_1
XFILLER_81_629 VPWR VGND VPWR VGND sky130_ef_sc_hd__decap_12
XFILLER_53_309 VGND VGND VPWR VPWR sky130_fd_sc_hd__decap_4
XTAP_TAPCELL_ROW_49_879 VGND VPWR sky130_fd_sc_hd__tapvpwrvgnd_1
XFILLER_0_76 VGND VGND VPWR VPWR sky130_fd_sc_hd__decap_8
X_4800_ _1358_ _2561_ VGND VGND VPWR VPWR _2659_ sky130_fd_sc_hd__xnor2_1
X_5780_ net146 VGND VGND VPWR VPWR _0188_ sky130_fd_sc_hd__inv_2
XTAP_TAPCELL_ROW_64_1070 VGND VPWR sky130_fd_sc_hd__tapvpwrvgnd_1
X_4731_ _1307_ _2586_ VGND VGND VPWR VPWR _2590_ sky130_fd_sc_hd__xnor2_1
XFILLER_9_63 VGND VGND VPWR VPWR sky130_fd_sc_hd__fill_1
XFILLER_119_105 VGND VGND VPWR VPWR sky130_fd_sc_hd__decap_6
X_4662_ _2282_ _2289_ _1852_ VGND VGND VPWR VPWR _2535_ sky130_fd_sc_hd__mux2_1
XFILLER_119_149 VPWR VGND VPWR VGND sky130_ef_sc_hd__decap_12
X_6401_ clknet_leaf_21_clk _0809_ _0334_ VGND VGND VPWR VPWR reg_file_inst.registry\[14\]\[26\]
+ sky130_fd_sc_hd__dfrtp_1
X_3613_ MEMOFF\[11\] net75 _1113_ VGND VGND VPWR VPWR _1540_ sky130_fd_sc_hd__mux2_2
XTAP_TAPCELL_ROW_116_1712 VGND VPWR sky130_fd_sc_hd__tapvpwrvgnd_1
X_4593_ _1790_ _2265_ VGND VGND VPWR VPWR _2472_ sky130_fd_sc_hd__nor2_1
X_3544_ reg_file_inst.registry\[14\]\[15\] _1081_ _1472_ net139 VGND VGND VPWR VPWR
+ _1474_ sky130_fd_sc_hd__a211o_1
X_6332_ clknet_leaf_11_clk _0740_ _0265_ VGND VGND VPWR VPWR reg_file_inst.registry\[8\]\[13\]
+ sky130_fd_sc_hd__dfrtp_1
XFILLER_103_517 VPWR VGND VPWR VGND sky130_ef_sc_hd__decap_12
X_3475_ reg_file_inst.registry\[1\]\[17\] net145 _1127_ VGND VGND VPWR VPWR _1408_
+ sky130_fd_sc_hd__and3_1
X_6263_ clknet_leaf_55_clk _0671_ _0196_ VGND VGND VPWR VPWR MEMOFF\[0\] sky130_fd_sc_hd__dfrtp_2
X_5214_ reg_file_inst.registry\[11\]\[16\] _2550_ _2989_ VGND VGND VPWR VPWR _0839_
+ sky130_fd_sc_hd__mux2_1
X_6194_ clknet_leaf_15_clk _0602_ _0127_ VGND VGND VPWR VPWR reg_file_inst.registry\[5\]\[15\]
+ sky130_fd_sc_hd__dfrtp_1
XFILLER_111_561 VPWR VGND VPWR VGND sky130_ef_sc_hd__decap_12
XFILLER_84_401 VGND VGND VPWR VPWR sky130_fd_sc_hd__decap_3
XFILLER_69_464 VPWR VGND VPWR VGND sky130_ef_sc_hd__decap_12
XFILLER_57_615 VGND VGND VPWR VPWR sky130_fd_sc_hd__fill_1
XFILLER_57_604 VGND VGND VPWR VPWR sky130_fd_sc_hd__fill_2
X_5145_ _2282_ _2289_ _1594_ VGND VGND VPWR VPWR _2968_ sky130_fd_sc_hd__mux2_1
X_5076_ _2176_ _2898_ _2901_ _2908_ VGND VGND VPWR VPWR net50 sky130_fd_sc_hd__a211o_1
XFILLER_84_489 VPWR VGND VPWR VGND sky130_ef_sc_hd__decap_12
XFILLER_84_467 VGND VGND VPWR VPWR sky130_fd_sc_hd__decap_8
X_4027_ net126 _1022_ _1878_ _1939_ VGND VGND VPWR VPWR _1943_ sky130_fd_sc_hd__nand4_1
XFILLER_44_309 VPWR VGND VPWR VGND sky130_ef_sc_hd__decap_12
XFILLER_25_534 VGND VGND VPWR VPWR sky130_fd_sc_hd__decap_4
XFILLER_37_383 VGND VGND VPWR VPWR sky130_fd_sc_hd__decap_8
XFILLER_44_27 VGND VGND VPWR VPWR sky130_fd_sc_hd__fill_1
X_5978_ net147 VGND VGND VPWR VPWR _0386_ sky130_fd_sc_hd__inv_2
X_4929_ _2279_ _2775_ _2778_ _2711_ _2781_ VGND VGND VPWR VPWR _2782_ sky130_fd_sc_hd__a221o_1
XTAP_TAPCELL_ROW_78_1239 VGND VPWR sky130_fd_sc_hd__tapvpwrvgnd_1
XFILLER_106_333 VPWR VGND VPWR VGND sky130_ef_sc_hd__decap_12
XTAP_TAPCELL_ROW_91_1406 VGND VPWR sky130_fd_sc_hd__tapvpwrvgnd_1
XFILLER_69_57 VGND VGND VPWR VPWR sky130_fd_sc_hd__decap_8
XFILLER_106_377 VPWR VGND VPWR VGND sky130_ef_sc_hd__decap_12
XFILLER_79_217 VGND VGND VPWR VPWR sky130_fd_sc_hd__decap_6
XFILLER_94_209 VPWR VGND VPWR VGND sky130_ef_sc_hd__decap_12
XFILLER_0_699 VGND VGND VPWR VPWR sky130_fd_sc_hd__fill_1
XTAP_TAPCELL_ROW_89_1379 VGND VPWR sky130_fd_sc_hd__tapvpwrvgnd_1
XFILLER_63_629 VGND VGND VPWR VPWR sky130_fd_sc_hd__decap_4
XFILLER_35_309 VGND VGND VPWR VPWR sky130_fd_sc_hd__fill_1
XFILLER_47_169 VGND VGND VPWR VPWR sky130_fd_sc_hd__decap_4
XFILLER_16_523 VGND VGND VPWR VPWR sky130_fd_sc_hd__decap_8
XFILLER_28_372 VGND VGND VPWR VPWR sky130_fd_sc_hd__fill_1
XTAP_TAPCELL_ROW_46_838 VGND VPWR sky130_fd_sc_hd__tapvpwrvgnd_1
XFILLER_71_662 VGND VGND VPWR VPWR sky130_fd_sc_hd__decap_8
XFILLER_31_526 VGND VGND VPWR VPWR sky130_fd_sc_hd__decap_4
XTAP_TAPCELL_ROW_100_1513 VGND VPWR sky130_fd_sc_hd__tapvpwrvgnd_1
XTAP_TAPCELL_ROW_26_584 VGND VPWR sky130_fd_sc_hd__tapvpwrvgnd_1
XTAP_TAPCELL_ROW_26_595 VGND VPWR sky130_fd_sc_hd__tapvpwrvgnd_1
XFILLER_117_609 VGND VGND VPWR VPWR sky130_fd_sc_hd__decap_6
XFILLER_11_272 VGND VGND VPWR VPWR sky130_fd_sc_hd__fill_1
Xwire141 _0966_ VGND VGND VPWR VPWR net141 sky130_fd_sc_hd__clkbuf_8
XFILLER_109_193 VPWR VGND VPWR VGND sky130_ef_sc_hd__decap_12
XTAP_TAPCELL_ROW_111_1653 VGND VPWR sky130_fd_sc_hd__tapvpwrvgnd_1
Xload_slew146 net149 VGND VGND VPWR VPWR net146 sky130_fd_sc_hd__clkbuf_16
X_3260_ reg_file_inst.registry\[2\]\[24\] _1083_ _1093_ reg_file_inst.registry\[15\]\[24\]
+ VGND VGND VPWR VPWR _1201_ sky130_fd_sc_hd__a22o_1
XFILLER_100_509 VGND VGND VPWR VPWR sky130_fd_sc_hd__decap_3
X_3191_ _1123_ net142 VGND VGND VPWR VPWR _1135_ sky130_fd_sc_hd__and2_4
XFILLER_15_3 VPWR VGND VPWR VGND sky130_ef_sc_hd__decap_12
XFILLER_38_114 VGND VGND VPWR VPWR sky130_fd_sc_hd__decap_4
XFILLER_26_309 VGND VGND VPWR VPWR sky130_fd_sc_hd__decap_8
XFILLER_66_489 VPWR VGND VPWR VGND sky130_ef_sc_hd__decap_12
X_5901_ net149 VGND VGND VPWR VPWR _0309_ sky130_fd_sc_hd__inv_2
XFILLER_47_670 VGND VGND VPWR VPWR sky130_fd_sc_hd__fill_2
X_5832_ net44 VGND VGND VPWR VPWR _0240_ sky130_fd_sc_hd__inv_2
XTAP_TAPCELL_ROW_122_1793 VGND VPWR sky130_fd_sc_hd__tapvpwrvgnd_1
X_5763_ net149 VGND VGND VPWR VPWR _0171_ sky130_fd_sc_hd__inv_2
X_4714_ _1207_ _2564_ VGND VGND VPWR VPWR _2573_ sky130_fd_sc_hd__xnor2_1
X_5694_ net147 VGND VGND VPWR VPWR _0102_ sky130_fd_sc_hd__inv_2
XFILLER_30_592 VPWR VGND VPWR VGND sky130_ef_sc_hd__decap_12
X_4645_ _2518_ _2519_ net137 VGND VGND VPWR VPWR _2520_ sky130_fd_sc_hd__mux2_1
X_4576_ reg_file_inst.registry\[11\]\[4\] _2455_ _2122_ VGND VGND VPWR VPWR _0919_
+ sky130_fd_sc_hd__mux2_1
X_6315_ clknet_leaf_32_clk _0723_ _0248_ VGND VGND VPWR VPWR reg_file_inst.registry\[3\]\[24\]
+ sky130_fd_sc_hd__dfrtp_1
X_3527_ _1457_ VGND VGND VPWR VPWR _1458_ sky130_fd_sc_hd__inv_2
XFILLER_89_548 VGND VGND VPWR VPWR sky130_fd_sc_hd__fill_2
X_3458_ _1384_ _1386_ _1391_ _1118_ reg_file_inst.registry\[0\]\[16\] VGND VGND VPWR
+ VPWR net80 sky130_fd_sc_hd__o32a_2
XFILLER_89_559 VGND VGND VPWR VPWR sky130_fd_sc_hd__fill_1
X_6246_ clknet_leaf_0_clk _0654_ _0179_ VGND VGND VPWR VPWR reg_file_inst.registry\[4\]\[11\]
+ sky130_fd_sc_hd__dfrtp_1
XFILLER_103_369 VGND VGND VPWR VPWR sky130_fd_sc_hd__fill_1
X_3389_ reg_file_inst.registry\[7\]\[19\] _1086_ _1092_ reg_file_inst.registry\[4\]\[19\]
+ _1324_ VGND VGND VPWR VPWR _1325_ sky130_fd_sc_hd__a221o_1
X_6177_ clknet_leaf_26_clk _0585_ _0110_ VGND VGND VPWR VPWR JMPOFF\[26\] sky130_fd_sc_hd__dfrtp_4
XFILLER_76_209 VGND VGND VPWR VPWR sky130_fd_sc_hd__decap_8
XFILLER_57_401 VGND VGND VPWR VPWR sky130_fd_sc_hd__fill_2
XFILLER_111_391 VGND VGND VPWR VPWR sky130_fd_sc_hd__fill_1
X_5128_ net137 _2295_ _2497_ _2296_ VGND VGND VPWR VPWR _2953_ sky130_fd_sc_hd__a31o_1
XFILLER_84_253 VPWR VGND VPWR VGND sky130_ef_sc_hd__decap_12
XFILLER_55_15 VPWR VGND VPWR VGND sky130_ef_sc_hd__decap_12
XFILLER_17_309 VGND VGND VPWR VPWR sky130_fd_sc_hd__decap_3
XFILLER_29_147 VPWR VGND VPWR VGND sky130_ef_sc_hd__decap_12
XFILLER_29_169 VGND VGND VPWR VPWR sky130_fd_sc_hd__decap_6
X_5059_ net137 _2247_ _2892_ _2191_ VGND VGND VPWR VPWR _2894_ sky130_fd_sc_hd__o22a_1
XFILLER_45_629 VPWR VGND VPWR VGND sky130_ef_sc_hd__decap_12
XFILLER_53_673 VGND VGND VPWR VPWR sky130_fd_sc_hd__fill_1
XFILLER_52_183 VPWR VGND VPWR VGND sky130_ef_sc_hd__decap_12
XFILLER_13_537 VGND VGND VPWR VPWR sky130_fd_sc_hd__fill_2
XFILLER_13_559 VGND VGND VPWR VPWR sky130_fd_sc_hd__fill_1
XTAP_TAPCELL_ROW_23_554 VGND VPWR sky130_fd_sc_hd__tapvpwrvgnd_1
XPHY_EDGE_ROW_109_Right_109 VGND VGND VPWR VPWR sky130_fd_sc_hd__decap_3
XTAP_TAPCELL_ROW_51_896 VGND VPWR sky130_fd_sc_hd__tapvpwrvgnd_1
XFILLER_5_725 VGND VGND VPWR VPWR sky130_fd_sc_hd__fill_1
XFILLER_107_653 VPWR VGND VPWR VGND sky130_ef_sc_hd__decap_12
XFILLER_106_141 VPWR VGND VPWR VGND sky130_ef_sc_hd__decap_12
XFILLER_122_601 VPWR VGND VPWR VGND sky130_ef_sc_hd__decap_12
XFILLER_107_697 VPWR VGND VPWR VGND sky130_ef_sc_hd__decap_12
XFILLER_122_645 VPWR VGND VPWR VGND sky130_ef_sc_hd__decap_12
XFILLER_121_111 VGND VGND VPWR VPWR sky130_fd_sc_hd__fill_1
XFILLER_95_529 VGND VGND VPWR VPWR sky130_fd_sc_hd__fill_1
XFILLER_76_721 VGND VGND VPWR VPWR sky130_fd_sc_hd__decap_4
XFILLER_0_474 VGND VGND VPWR VPWR sky130_fd_sc_hd__fill_2
XFILLER_29_60 VPWR VGND VPWR VGND sky130_ef_sc_hd__decap_12
XFILLER_48_445 VGND VGND VPWR VPWR sky130_fd_sc_hd__fill_1
XFILLER_63_404 VGND VGND VPWR VPWR sky130_fd_sc_hd__fill_2
XFILLER_63_415 VGND VGND VPWR VPWR sky130_fd_sc_hd__decap_6
XTAP_TAPCELL_ROW_59_996 VGND VPWR sky130_fd_sc_hd__tapvpwrvgnd_1
XFILLER_29_692 VPWR VGND VPWR VGND sky130_ef_sc_hd__decap_12
XFILLER_35_106 VGND VGND VPWR VPWR sky130_fd_sc_hd__decap_6
XFILLER_90_245 VGND VGND VPWR VPWR sky130_fd_sc_hd__decap_6
XPHY_EDGE_ROW_11_Left_134 VGND VGND VPWR VPWR sky130_fd_sc_hd__decap_3
XFILLER_90_278 VGND VGND VPWR VPWR sky130_fd_sc_hd__decap_8
XFILLER_45_92 VGND VGND VPWR VPWR sky130_fd_sc_hd__decap_8
XFILLER_31_334 VGND VGND VPWR VPWR sky130_fd_sc_hd__fill_2
XFILLER_8_530 VGND VGND VPWR VPWR sky130_fd_sc_hd__fill_2
XFILLER_117_417 VPWR VGND VPWR VGND sky130_ef_sc_hd__decap_12
XPHY_EDGE_ROW_20_Left_143 VGND VGND VPWR VPWR sky130_fd_sc_hd__decap_3
XANTENNA_2 JMPOFF\[6\] VGND VGND VPWR VPWR sky130_fd_sc_hd__diode_2
X_4430_ _1802_ _2203_ _2314_ VGND VGND VPWR VPWR _2315_ sky130_fd_sc_hd__a21bo_1
XFILLER_6_53 VPWR VGND VPWR VGND sky130_ef_sc_hd__decap_12
X_6100_ clknet_leaf_41_clk _0508_ _0033_ VGND VGND VPWR VPWR reg_file_inst.registry\[9\]\[5\]
+ sky130_fd_sc_hd__dfrtp_1
X_4361_ _1709_ _1735_ VGND VGND VPWR VPWR _2249_ sky130_fd_sc_hd__or2_4
XFILLER_112_133 VGND VGND VPWR VPWR sky130_fd_sc_hd__decap_6
X_3312_ JMPOFF\[22\] _1095_ _1097_ reg_file_inst.registry\[5\]\[22\] VGND VGND VPWR
+ VPWR _1251_ sky130_fd_sc_hd__a22o_1
X_4292_ _1281_ _1307_ _1334_ VGND VGND VPWR VPWR _2180_ sky130_fd_sc_hd__and3_1
XFILLER_112_177 VPWR VGND VPWR VGND sky130_ef_sc_hd__decap_12
X_3243_ reg_file_inst.registry\[0\]\[25\] _1076_ _1177_ _1184_ VGND VGND VPWR VPWR
+ _1185_ sky130_fd_sc_hd__o22ai_4
XFILLER_86_507 VGND VGND VPWR VPWR sky130_fd_sc_hd__decap_8
XFILLER_79_570 VGND VGND VPWR VPWR sky130_fd_sc_hd__decap_3
X_6031_ net149 VGND VGND VPWR VPWR _0439_ sky130_fd_sc_hd__inv_2
XFILLER_58_209 VPWR VGND VPWR VGND sky130_ef_sc_hd__decap_12
XFILLER_67_721 VGND VGND VPWR VPWR sky130_fd_sc_hd__fill_2
X_3174_ _1114_ net145 VGND VGND VPWR VPWR _1118_ sky130_fd_sc_hd__nand2_8
XFILLER_66_253 VPWR VGND VPWR VGND sky130_ef_sc_hd__decap_12
XFILLER_82_713 VPWR VGND VPWR VGND sky130_ef_sc_hd__decap_12
XFILLER_66_286 VGND VGND VPWR VPWR sky130_fd_sc_hd__decap_6
XFILLER_54_415 VGND VGND VPWR VPWR sky130_fd_sc_hd__decap_4
XFILLER_81_234 VPWR VGND VPWR VGND sky130_ef_sc_hd__decap_12
XFILLER_54_459 VGND VGND VPWR VPWR sky130_fd_sc_hd__decap_6
XFILLER_26_139 VGND VGND VPWR VPWR sky130_fd_sc_hd__fill_1
XFILLER_81_267 VPWR VGND VPWR VGND sky130_ef_sc_hd__decap_12
XFILLER_35_673 VGND VGND VPWR VPWR sky130_fd_sc_hd__decap_8
X_5815_ net44 VGND VGND VPWR VPWR _0223_ sky130_fd_sc_hd__inv_2
XFILLER_62_481 VGND VGND VPWR VPWR sky130_fd_sc_hd__fill_1
XFILLER_50_621 VGND VGND VPWR VPWR sky130_fd_sc_hd__decap_8
XFILLER_22_312 VPWR VGND VPWR VGND sky130_ef_sc_hd__decap_12
X_5746_ net147 VGND VGND VPWR VPWR _0154_ sky130_fd_sc_hd__inv_2
XTAP_TAPCELL_ROW_20_513 VGND VPWR sky130_fd_sc_hd__tapvpwrvgnd_1
X_5677_ net149 VGND VGND VPWR VPWR _0085_ sky130_fd_sc_hd__inv_2
X_4628_ _1790_ _2379_ VGND VGND VPWR VPWR _2503_ sky130_fd_sc_hd__and2_1
XFILLER_104_601 VPWR VGND VPWR VGND sky130_ef_sc_hd__decap_12
X_4559_ _1790_ net135 _2316_ VGND VGND VPWR VPWR _2440_ sky130_fd_sc_hd__and3_1
XFILLER_104_645 VPWR VGND VPWR VGND sky130_ef_sc_hd__decap_12
XFILLER_103_111 VGND VGND VPWR VPWR sky130_fd_sc_hd__fill_1
XFILLER_89_389 VGND VGND VPWR VPWR sky130_fd_sc_hd__decap_3
X_6229_ clknet_leaf_34_clk _0637_ _0162_ VGND VGND VPWR VPWR reg_file_inst.registry\[10\]\[22\]
+ sky130_fd_sc_hd__dfrtp_1
XFILLER_106_65 VPWR VGND VPWR VGND sky130_ef_sc_hd__decap_12
XFILLER_58_721 VGND VGND VPWR VPWR sky130_fd_sc_hd__fill_2
XFILLER_66_69 VGND VGND VPWR VPWR sky130_fd_sc_hd__fill_2
XFILLER_57_264 VPWR VGND VPWR VGND sky130_ef_sc_hd__decap_12
XFILLER_18_629 VPWR VGND VPWR VGND sky130_ef_sc_hd__decap_12
XTAP_TAPCELL_ROW_28_613 VGND VPWR sky130_fd_sc_hd__tapvpwrvgnd_1
XFILLER_122_53 VGND VGND VPWR VPWR sky130_fd_sc_hd__decap_3
XTAP_TAPCELL_ROW_86_1338 VGND VPWR sky130_fd_sc_hd__tapvpwrvgnd_1
XTAP_TAPCELL_ROW_56_966 VGND VPWR sky130_fd_sc_hd__tapvpwrvgnd_1
XFILLER_26_640 VGND VGND VPWR VPWR sky130_fd_sc_hd__decap_4
XFILLER_122_97 VPWR VGND VPWR VGND sky130_ef_sc_hd__decap_12
XFILLER_60_418 VGND VGND VPWR VPWR sky130_fd_sc_hd__fill_2
XTAP_TAPCELL_ROW_0_260 VGND VPWR sky130_fd_sc_hd__tapvpwrvgnd_1
XFILLER_25_150 VPWR VGND VPWR VGND sky130_ef_sc_hd__decap_12
XFILLER_82_79 VGND VGND VPWR VPWR sky130_fd_sc_hd__decap_4
XFILLER_53_481 VGND VGND VPWR VPWR sky130_fd_sc_hd__fill_1
XFILLER_13_356 VPWR VGND VPWR VGND sky130_ef_sc_hd__decap_12
XFILLER_9_349 VGND VGND VPWR VPWR sky130_fd_sc_hd__decap_3
XFILLER_9_327 VGND VGND VPWR VPWR sky130_fd_sc_hd__fill_2
XFILLER_40_197 VGND VGND VPWR VPWR sky130_fd_sc_hd__decap_8
XTAP_TAPCELL_ROW_97_1478 VGND VPWR sky130_fd_sc_hd__tapvpwrvgnd_1
XFILLER_107_461 VPWR VGND VPWR VGND sky130_ef_sc_hd__decap_12
Xoutput50 net50 VGND VGND VPWR VPWR DataAddress[14] sky130_fd_sc_hd__buf_1
Xoutput61 net61 VGND VGND VPWR VPWR DataAddress[24] sky130_fd_sc_hd__buf_1
Xoutput83 net83 VGND VGND VPWR VPWR DataMemoryWrite[19] sky130_fd_sc_hd__buf_1
XTAP_TAPCELL_ROW_8_360 VGND VPWR sky130_fd_sc_hd__tapvpwrvgnd_1
Xoutput72 net72 VGND VGND VPWR VPWR DataAddress[9] sky130_fd_sc_hd__buf_1
Xoutput94 net94 VGND VGND VPWR VPWR DataMemoryWrite[3] sky130_fd_sc_hd__buf_1
XFILLER_110_637 VGND VGND VPWR VPWR sky130_fd_sc_hd__decap_6
XFILLER_95_337 VPWR VGND VPWR VGND sky130_ef_sc_hd__decap_12
XFILLER_0_271 VGND VGND VPWR VPWR sky130_fd_sc_hd__decap_8
XFILLER_48_286 VGND VGND VPWR VPWR sky130_fd_sc_hd__fill_2
XFILLER_91_532 VPWR VGND VPWR VGND sky130_ef_sc_hd__decap_12
XFILLER_63_223 VGND VGND VPWR VPWR sky130_fd_sc_hd__fill_1
XFILLER_56_80 VGND VGND VPWR VPWR sky130_fd_sc_hd__decap_4
XFILLER_17_673 VGND VGND VPWR VPWR sky130_fd_sc_hd__decap_6
X_3930_ MEMOFF\[0\] _1129_ _1130_ JMPOFF\[0\] _1846_ VGND VGND VPWR VPWR _1847_ sky130_fd_sc_hd__a221o_1
XTAP_TAPCELL_ROW_106_1585 VGND VPWR sky130_fd_sc_hd__tapvpwrvgnd_1
XFILLER_32_621 VPWR VGND VPWR VGND sky130_ef_sc_hd__decap_12
X_3861_ reg_file_inst.registry\[14\]\[2\] _1081_ _1087_ reg_file_inst.registry\[1\]\[2\]
+ VGND VGND VPWR VPWR _1780_ sky130_fd_sc_hd__a22o_1
X_5600_ net149 VGND VGND VPWR VPWR _0008_ sky130_fd_sc_hd__inv_2
X_3792_ reg_file_inst.registry\[6\]\[4\] _1123_ _1132_ VGND VGND VPWR VPWR _1714_
+ sky130_fd_sc_hd__and3_1
X_5531_ reg_file_inst.registry\[6\]\[3\] _2478_ _3001_ VGND VGND VPWR VPWR _0534_
+ sky130_fd_sc_hd__mux2_1
XFILLER_117_225 VPWR VGND VPWR VGND sky130_ef_sc_hd__decap_12
X_5462_ reg_file_inst.registry\[5\]\[14\] _2909_ _2999_ VGND VGND VPWR VPWR _0601_
+ sky130_fd_sc_hd__mux2_1
X_5393_ reg_file_inst.registry\[4\]\[25\] _2767_ _2997_ VGND VGND VPWR VPWR _0668_
+ sky130_fd_sc_hd__mux2_1
X_4413_ _1765_ _2295_ VGND VGND VPWR VPWR _2301_ sky130_fd_sc_hd__nand2_1
X_4344_ _2202_ _2231_ _1841_ VGND VGND VPWR VPWR _2232_ sky130_fd_sc_hd__mux2_1
XFILLER_101_615 VGND VGND VPWR VPWR sky130_fd_sc_hd__fill_1
XFILLER_99_665 VGND VGND VPWR VPWR sky130_fd_sc_hd__decap_6
XFILLER_113_497 VGND VGND VPWR VPWR sky130_fd_sc_hd__decap_6
X_6014_ net146 VGND VGND VPWR VPWR _0422_ sky130_fd_sc_hd__inv_2
XTAP_TAPCELL_ROW_70_1139 VGND VPWR sky130_fd_sc_hd__tapvpwrvgnd_1
X_4275_ _1867_ _2161_ _2160_ VGND VGND VPWR VPWR _2163_ sky130_fd_sc_hd__a21boi_1
X_3226_ reg_file_inst.registry\[10\]\[26\] _1126_ _1136_ reg_file_inst.registry\[8\]\[26\]
+ _1168_ VGND VGND VPWR VPWR _1169_ sky130_fd_sc_hd__a221o_1
XFILLER_55_702 VGND VGND VPWR VPWR sky130_fd_sc_hd__fill_1
X_3157_ reg_file_inst.registry\[3\]\[27\] _1091_ _1093_ reg_file_inst.registry\[15\]\[27\]
+ VGND VGND VPWR VPWR _1101_ sky130_fd_sc_hd__a22o_1
XFILLER_67_573 VPWR VGND VPWR VGND sky130_ef_sc_hd__decap_12
XFILLER_54_223 VGND VGND VPWR VPWR sky130_fd_sc_hd__fill_2
XFILLER_82_587 VGND VGND VPWR VPWR sky130_fd_sc_hd__fill_1
XFILLER_70_705 VGND VGND VPWR VPWR sky130_fd_sc_hd__fill_1
XTAP_TAPCELL_ROW_53_925 VGND VPWR sky130_fd_sc_hd__tapvpwrvgnd_1
X_3088_ _1031_ VGND VGND VPWR VPWR _1032_ sky130_fd_sc_hd__inv_2
XFILLER_42_418 VGND VGND VPWR VPWR sky130_fd_sc_hd__fill_2
XFILLER_52_27 VGND VGND VPWR VPWR sky130_fd_sc_hd__fill_1
XFILLER_22_120 VGND VGND VPWR VPWR sky130_fd_sc_hd__decap_3
XTAP_TAPCELL_ROW_81_1279 VGND VPWR sky130_fd_sc_hd__tapvpwrvgnd_1
XTAP_TAPCELL_ROW_33_671 VGND VPWR sky130_fd_sc_hd__tapvpwrvgnd_1
XTAP_TAPCELL_ROW_33_682 VGND VPWR sky130_fd_sc_hd__tapvpwrvgnd_1
X_5729_ net44 VGND VGND VPWR VPWR _0137_ sky130_fd_sc_hd__inv_2
XFILLER_104_431 VGND VGND VPWR VPWR sky130_fd_sc_hd__decap_8
XFILLER_2_569 VPWR VGND VPWR VGND sky130_ef_sc_hd__decap_12
XFILLER_104_475 VGND VGND VPWR VPWR sky130_fd_sc_hd__fill_1
XFILLER_77_337 VGND VGND VPWR VPWR sky130_fd_sc_hd__decap_6
XFILLER_77_57 VGND VGND VPWR VPWR sky130_fd_sc_hd__decap_6
XTAP_TAPCELL_ROW_5_330 VGND VPWR sky130_fd_sc_hd__tapvpwrvgnd_1
XFILLER_92_307 VGND VGND VPWR VPWR sky130_fd_sc_hd__fill_1
XFILLER_100_681 VPWR VGND VPWR VGND sky130_ef_sc_hd__decap_12
XFILLER_18_437 VPWR VGND VPWR VGND sky130_ef_sc_hd__decap_12
XFILLER_45_223 VGND VGND VPWR VPWR sky130_fd_sc_hd__fill_1
XFILLER_61_716 VGND VGND VPWR VPWR sky130_fd_sc_hd__fill_1
XFILLER_26_83 VGND VGND VPWR VPWR sky130_fd_sc_hd__fill_1
XFILLER_14_643 VGND VGND VPWR VPWR sky130_fd_sc_hd__fill_1
XTAP_TAPCELL_ROW_99_1507 VGND VPWR sky130_fd_sc_hd__tapvpwrvgnd_1
XFILLER_9_113 VGND VGND VPWR VPWR sky130_fd_sc_hd__decap_3
XFILLER_9_102 VGND VGND VPWR VPWR sky130_fd_sc_hd__decap_8
XFILLER_13_153 VPWR VGND VPWR VGND sky130_ef_sc_hd__decap_12
XFILLER_9_157 VGND VGND VPWR VPWR sky130_fd_sc_hd__fill_1
XFILLER_9_135 VGND VGND VPWR VPWR sky130_fd_sc_hd__decap_8
XTAP_TAPCELL_ROW_11_398 VGND VPWR sky130_fd_sc_hd__tapvpwrvgnd_1
XFILLER_5_396 VPWR VGND VPWR VGND sky130_ef_sc_hd__decap_12
XFILLER_96_613 VPWR VGND VPWR VGND sky130_ef_sc_hd__decap_12
XFILLER_110_401 VPWR VGND VPWR VGND sky130_ef_sc_hd__decap_12
XFILLER_110_445 VPWR VGND VPWR VGND sky130_ef_sc_hd__decap_12
XFILLER_96_657 VPWR VGND VPWR VGND sky130_ef_sc_hd__decap_12
X_4060_ _1974_ _1975_ VGND VGND VPWR VPWR _1976_ sky130_fd_sc_hd__and2_1
XFILLER_110_489 VPWR VGND VPWR VGND sky130_ef_sc_hd__decap_12
XTAP_TAPCELL_ROW_108_1614 VGND VPWR sky130_fd_sc_hd__tapvpwrvgnd_1
XFILLER_64_510 VGND VGND VPWR VPWR sky130_fd_sc_hd__decap_8
X_3011_ net35 VGND VGND VPWR VPWR _0957_ sky130_fd_sc_hd__inv_2
XFILLER_36_212 VPWR VGND VPWR VGND sky130_ef_sc_hd__decap_12
XTAP_TAPCELL_ROW_19_498 VGND VPWR sky130_fd_sc_hd__tapvpwrvgnd_1
X_4962_ _2725_ _2744_ _1790_ VGND VGND VPWR VPWR _2811_ sky130_fd_sc_hd__mux2_1
X_4893_ _2572_ _2574_ _2675_ VGND VGND VPWR VPWR _2748_ sky130_fd_sc_hd__and3_1
X_3913_ reg_file_inst.registry\[10\]\[0\] _1080_ _1088_ VGND VGND VPWR VPWR _1830_
+ sky130_fd_sc_hd__and3_1
XFILLER_32_462 VGND VGND VPWR VPWR sky130_fd_sc_hd__fill_2
XFILLER_32_473 VGND VGND VPWR VPWR sky130_fd_sc_hd__decap_3
X_3844_ reg_file_inst.registry\[0\]\[3\] net138 _1757_ _1763_ VGND VGND VPWR VPWR
+ _1764_ sky130_fd_sc_hd__o22a_4
XFILLER_118_501 VPWR VGND VPWR VGND sky130_ef_sc_hd__decap_12
XTAP_TAPCELL_ROW_30_641 VGND VPWR sky130_fd_sc_hd__tapvpwrvgnd_1
X_3775_ reg_file_inst.registry\[6\]\[4\] _1080_ _1084_ VGND VGND VPWR VPWR _1697_
+ sky130_fd_sc_hd__and3_1
XFILLER_118_545 VPWR VGND VPWR VGND sky130_ef_sc_hd__decap_12
XTAP_TAPCELL_ROW_119_1754 VGND VPWR sky130_fd_sc_hd__tapvpwrvgnd_1
X_6494_ clknet_leaf_18_clk _0902_ _0427_ VGND VGND VPWR VPWR reg_file_inst.registry\[7\]\[27\]
+ sky130_fd_sc_hd__dfrtp_1
X_5514_ reg_file_inst.registry\[6\]\[20\] _2842_ _3001_ VGND VGND VPWR VPWR _0551_
+ sky130_fd_sc_hd__mux2_1
XFILLER_118_589 VPWR VGND VPWR VGND sky130_ef_sc_hd__decap_12
XFILLER_105_217 VGND VGND VPWR VPWR sky130_fd_sc_hd__decap_6
X_5445_ _2501_ reg_file_inst.registry\[10\]\[2\] _2998_ VGND VGND VPWR VPWR _0617_
+ sky130_fd_sc_hd__mux2_1
XFILLER_120_209 VPWR VGND VPWR VGND sky130_ef_sc_hd__decap_12
XFILLER_87_602 VPWR VGND VPWR VGND sky130_ef_sc_hd__decap_12
X_5376_ MEMOFF\[13\] _2922_ _2996_ VGND VGND VPWR VPWR _0684_ sky130_fd_sc_hd__mux2_1
XFILLER_113_261 VPWR VGND VPWR VGND sky130_ef_sc_hd__decap_12
X_4327_ _1540_ _2190_ VGND VGND VPWR VPWR _2215_ sky130_fd_sc_hd__and2_1
X_4258_ _1751_ _2144_ VGND VGND VPWR VPWR _2146_ sky130_fd_sc_hd__nand2_1
XFILLER_47_27 VPWR VGND VPWR VGND sky130_ef_sc_hd__decap_12
X_3209_ _1109_ _1151_ VGND VGND VPWR VPWR _1152_ sky130_fd_sc_hd__xnor2_2
XFILLER_28_713 VGND VGND VPWR VPWR sky130_fd_sc_hd__decap_8
XFILLER_27_223 VGND VGND VPWR VPWR sky130_fd_sc_hd__fill_1
X_4189_ _2091_ net107 net130 VGND VGND VPWR VPWR _0936_ sky130_fd_sc_hd__mux2_1
XFILLER_103_55 VGND VGND VPWR VPWR sky130_fd_sc_hd__fill_1
XFILLER_82_362 VGND VGND VPWR VPWR sky130_fd_sc_hd__fill_2
XFILLER_27_267 VPWR VGND VPWR VGND sky130_ef_sc_hd__decap_12
XTAP_TAPCELL_ROW_38_741 VGND VPWR sky130_fd_sc_hd__tapvpwrvgnd_1
XFILLER_23_440 VGND VGND VPWR VPWR sky130_fd_sc_hd__decap_8
XFILLER_23_473 VGND VGND VPWR VPWR sky130_fd_sc_hd__fill_1
XFILLER_7_617 VPWR VGND VPWR VGND sky130_ef_sc_hd__decap_12
XFILLER_12_41 VPWR VGND VPWR VGND sky130_ef_sc_hd__decap_12
XTAP_TAPCELL_ROW_94_1437 VGND VPWR sky130_fd_sc_hd__tapvpwrvgnd_1
XFILLER_12_74 VGND VGND VPWR VPWR sky130_fd_sc_hd__fill_1
XFILLER_78_613 VPWR VGND VPWR VGND sky130_ef_sc_hd__decap_12
XFILLER_78_657 VPWR VGND VPWR VGND sky130_ef_sc_hd__decap_12
XFILLER_77_189 VGND VGND VPWR VPWR sky130_fd_sc_hd__decap_8
XFILLER_77_167 VGND VGND VPWR VPWR sky130_fd_sc_hd__fill_1
XFILLER_65_329 VGND VGND VPWR VPWR sky130_fd_sc_hd__decap_6
XPHY_EDGE_ROW_16_Right_16 VGND VGND VPWR VPWR sky130_fd_sc_hd__decap_3
XFILLER_18_289 VPWR VGND VPWR VGND sky130_ef_sc_hd__decap_12
XTAP_TAPCELL_ROW_103_1555 VGND VPWR sky130_fd_sc_hd__tapvpwrvgnd_1
XTAP_TAPCELL_ROW_16_468 VGND VPWR sky130_fd_sc_hd__tapvpwrvgnd_1
X_3560_ _1486_ _1487_ _1488_ _1489_ VGND VGND VPWR VPWR _1490_ sky130_fd_sc_hd__or4_1
XPHY_EDGE_ROW_25_Right_25 VGND VGND VPWR VPWR sky130_fd_sc_hd__decap_3
XFILLER_115_559 VGND VGND VPWR VPWR sky130_fd_sc_hd__fill_1
X_5230_ _2922_ reg_file_inst.registry\[1\]\[13\] _2990_ VGND VGND VPWR VPWR _0824_
+ sky130_fd_sc_hd__mux2_1
XFILLER_5_182 VGND VGND VPWR VPWR sky130_fd_sc_hd__fill_1
X_3491_ reg_file_inst.registry\[1\]\[12\] _1087_ VGND VGND VPWR VPWR _1423_ sky130_fd_sc_hd__nand2_1
XFILLER_69_602 VGND VGND VPWR VPWR sky130_fd_sc_hd__decap_3
XFILLER_45_3 VGND VGND VPWR VPWR sky130_fd_sc_hd__decap_8
XTAP_TAPCELL_ROW_114_1695 VGND VPWR sky130_fd_sc_hd__tapvpwrvgnd_1
XTAP_TAPCELL_ROW_114_1684 VGND VPWR sky130_fd_sc_hd__tapvpwrvgnd_1
XFILLER_111_721 VGND VGND VPWR VPWR sky130_fd_sc_hd__decap_4
X_5161_ _1607_ _1620_ _2981_ VGND VGND VPWR VPWR _2982_ sky130_fd_sc_hd__o21ai_1
XFILLER_69_646 VGND VGND VPWR VPWR sky130_fd_sc_hd__fill_2
X_4112_ _2027_ VGND VGND VPWR VPWR _2028_ sky130_fd_sc_hd__inv_2
X_5092_ net5 net101 net49 _2308_ VGND VGND VPWR VPWR _2922_ sky130_fd_sc_hd__a22o_4
XFILLER_110_253 VPWR VGND VPWR VGND sky130_ef_sc_hd__decap_12
XPHY_EDGE_ROW_3_Left_126 VGND VGND VPWR VPWR sky130_fd_sc_hd__decap_3
X_4043_ _1878_ _1954_ net122 VGND VGND VPWR VPWR _1959_ sky130_fd_sc_hd__a21o_1
XFILLER_83_148 VGND VGND VPWR VPWR sky130_fd_sc_hd__decap_6
XFILLER_83_126 VGND VGND VPWR VPWR sky130_fd_sc_hd__fill_2
XTAP_TAPCELL_ROW_69_1130 VGND VPWR sky130_fd_sc_hd__tapvpwrvgnd_1
XPHY_EDGE_ROW_34_Right_34 VGND VGND VPWR VPWR sky130_fd_sc_hd__decap_3
XFILLER_92_693 VGND VGND VPWR VPWR sky130_fd_sc_hd__decap_6
X_5994_ net147 VGND VGND VPWR VPWR _0402_ sky130_fd_sc_hd__inv_2
XTAP_TAPCELL_ROW_35_700 VGND VPWR sky130_fd_sc_hd__tapvpwrvgnd_1
XFILLER_91_192 VGND VGND VPWR VPWR sky130_fd_sc_hd__decap_6
X_4945_ _1242_ _2282_ _2285_ _1243_ _2795_ VGND VGND VPWR VPWR _2796_ sky130_fd_sc_hd__o221a_1
X_4876_ _2202_ _2231_ _1840_ VGND VGND VPWR VPWR _2733_ sky130_fd_sc_hd__mux2_1
XFILLER_20_421 VPWR VGND VPWR VGND sky130_ef_sc_hd__decap_12
X_3827_ reg_file_inst.registry\[11\]\[5\] _1141_ _1740_ _1743_ _1745_ VGND VGND VPWR
+ VPWR _1748_ sky130_fd_sc_hd__a2111o_1
XFILLER_20_454 VGND VGND VPWR VPWR sky130_fd_sc_hd__fill_1
XPHY_EDGE_ROW_43_Right_43 VGND VGND VPWR VPWR sky130_fd_sc_hd__decap_3
X_3758_ JMPOFF\[6\] _1130_ _1138_ reg_file_inst.registry\[14\]\[6\] _1117_ VGND VGND
+ VPWR VPWR _1681_ sky130_fd_sc_hd__a221o_1
X_6477_ clknet_leaf_28_clk _0885_ _0410_ VGND VGND VPWR VPWR reg_file_inst.registry\[7\]\[10\]
+ sky130_fd_sc_hd__dfrtp_1
X_3689_ reg_file_inst.registry\[3\]\[8\] _1140_ _1142_ reg_file_inst.registry\[1\]\[8\]
+ VGND VGND VPWR VPWR _1614_ sky130_fd_sc_hd__a22o_1
X_5428_ _2854_ reg_file_inst.registry\[10\]\[19\] _2998_ VGND VGND VPWR VPWR _0634_
+ sky130_fd_sc_hd__mux2_1
XFILLER_121_529 VPWR VGND VPWR VGND sky130_ef_sc_hd__decap_12
XFILLER_114_581 VGND VGND VPWR VPWR sky130_fd_sc_hd__decap_6
XFILLER_87_421 VPWR VGND VPWR VGND sky130_ef_sc_hd__decap_12
X_5359_ _2528_ reg_file_inst.registry\[3\]\[1\] _2995_ VGND VGND VPWR VPWR _0700_
+ sky130_fd_sc_hd__mux2_1
XFILLER_59_145 VGND VGND VPWR VPWR sky130_fd_sc_hd__decap_6
XPHY_EDGE_ROW_52_Right_52 VGND VGND VPWR VPWR sky130_fd_sc_hd__decap_3
XFILLER_114_65 VPWR VGND VPWR VGND sky130_ef_sc_hd__decap_12
XFILLER_16_705 VGND VGND VPWR VPWR sky130_fd_sc_hd__fill_1
XFILLER_70_354 VGND VGND VPWR VPWR sky130_fd_sc_hd__decap_8
XFILLER_15_237 VGND VGND VPWR VPWR sky130_fd_sc_hd__decap_8
XFILLER_43_557 VGND VGND VPWR VPWR sky130_fd_sc_hd__decap_3
XFILLER_90_79 VGND VGND VPWR VPWR sky130_fd_sc_hd__decap_4
XFILLER_90_57 VGND VGND VPWR VPWR sky130_fd_sc_hd__decap_3
XPHY_EDGE_ROW_61_Right_61 VGND VGND VPWR VPWR sky130_fd_sc_hd__decap_3
XFILLER_11_432 VGND VGND VPWR VPWR sky130_fd_sc_hd__decap_6
XTAP_TAPCELL_ROW_13_427 VGND VPWR sky130_fd_sc_hd__tapvpwrvgnd_1
XFILLER_23_281 VGND VGND VPWR VPWR sky130_fd_sc_hd__fill_2
XFILLER_99_55 VGND VGND VPWR VPWR sky130_fd_sc_hd__fill_1
XFILLER_99_77 VGND VGND VPWR VPWR sky130_fd_sc_hd__decap_8
XFILLER_98_719 VGND VGND VPWR VPWR sky130_fd_sc_hd__fill_1
XFILLER_3_653 VPWR VGND VPWR VGND sky130_ef_sc_hd__decap_12
XFILLER_78_410 VGND VGND VPWR VPWR sky130_fd_sc_hd__fill_1
XPHY_EDGE_ROW_70_Right_70 VGND VGND VPWR VPWR sky130_fd_sc_hd__decap_3
XFILLER_3_697 VPWR VGND VPWR VGND sky130_ef_sc_hd__decap_12
XFILLER_2_141 VGND VGND VPWR VPWR sky130_fd_sc_hd__decap_3
XFILLER_78_454 VGND VGND VPWR VPWR sky130_fd_sc_hd__decap_6
XPHY_EDGE_ROW_76_Left_199 VGND VGND VPWR VPWR sky130_fd_sc_hd__decap_3
XFILLER_93_413 VPWR VGND VPWR VGND sky130_ef_sc_hd__decap_12
XFILLER_24_8 VPWR VGND VPWR VGND sky130_ef_sc_hd__decap_12
XFILLER_38_307 VGND VGND VPWR VPWR sky130_fd_sc_hd__fill_1
XFILLER_59_690 VGND VGND VPWR VPWR sky130_fd_sc_hd__fill_2
XFILLER_0_11 VGND VGND VPWR VPWR sky130_fd_sc_hd__decap_8
XFILLER_74_693 VGND VGND VPWR VPWR sky130_fd_sc_hd__fill_1
XTAP_TAPCELL_ROW_64_1060 VGND VPWR sky130_fd_sc_hd__tapvpwrvgnd_1
X_4730_ _1294_ _2588_ VGND VGND VPWR VPWR _2589_ sky130_fd_sc_hd__nor2_1
X_4661_ _1852_ _2284_ _2437_ VGND VGND VPWR VPWR _2534_ sky130_fd_sc_hd__a21oi_1
X_6400_ clknet_leaf_32_clk _0808_ _0333_ VGND VGND VPWR VPWR reg_file_inst.registry\[14\]\[25\]
+ sky130_fd_sc_hd__dfrtp_1
X_3612_ _1535_ _1536_ _1539_ _1118_ reg_file_inst.registry\[0\]\[11\] VGND VGND VPWR
+ VPWR net75 sky130_fd_sc_hd__o32a_1
XTAP_TAPCELL_ROW_116_1713 VGND VPWR sky130_fd_sc_hd__tapvpwrvgnd_1
X_6331_ clknet_leaf_2_clk _0739_ _0264_ VGND VGND VPWR VPWR reg_file_inst.registry\[8\]\[12\]
+ sky130_fd_sc_hd__dfrtp_1
X_4592_ _2167_ _2176_ _2466_ _2470_ VGND VGND VPWR VPWR _2471_ sky130_fd_sc_hd__a31o_1
X_3543_ reg_file_inst.registry\[7\]\[15\] _1086_ _1087_ reg_file_inst.registry\[1\]\[15\]
+ _1471_ VGND VGND VPWR VPWR _1473_ sky130_fd_sc_hd__a221o_1
X_6262_ clknet_leaf_18_clk _0670_ _0195_ VGND VGND VPWR VPWR reg_file_inst.registry\[4\]\[27\]
+ sky130_fd_sc_hd__dfrtp_1
X_3474_ reg_file_inst.registry\[9\]\[17\] net143 _1127_ VGND VGND VPWR VPWR _1407_
+ sky130_fd_sc_hd__and3_1
XFILLER_6_491 VPWR VGND VPWR VGND sky130_ef_sc_hd__decap_12
XFILLER_103_529 VPWR VGND VPWR VGND sky130_ef_sc_hd__decap_12
X_5213_ reg_file_inst.registry\[11\]\[17\] _2528_ _2989_ VGND VGND VPWR VPWR _0840_
+ sky130_fd_sc_hd__mux2_1
X_6193_ clknet_leaf_11_clk _0601_ _0126_ VGND VGND VPWR VPWR reg_file_inst.registry\[5\]\[14\]
+ sky130_fd_sc_hd__dfrtp_1
X_5144_ _1594_ _2284_ _2437_ VGND VGND VPWR VPWR _2967_ sky130_fd_sc_hd__a21o_1
XFILLER_111_573 VPWR VGND VPWR VGND sky130_ef_sc_hd__decap_12
XFILLER_96_273 VPWR VGND VPWR VGND sky130_ef_sc_hd__decap_12
XFILLER_84_413 VGND VGND VPWR VPWR sky130_fd_sc_hd__decap_6
XFILLER_69_476 VGND VGND VPWR VPWR sky130_fd_sc_hd__decap_4
XFILLER_56_104 VGND VGND VPWR VPWR sky130_fd_sc_hd__decap_4
XFILLER_28_29 VPWR VGND VPWR VGND sky130_ef_sc_hd__decap_12
XFILLER_56_137 VGND VGND VPWR VPWR sky130_fd_sc_hd__decap_3
X_5075_ _2296_ _2899_ _2902_ _2907_ VGND VGND VPWR VPWR _2908_ sky130_fd_sc_hd__a31o_1
XFILLER_65_660 VGND VGND VPWR VPWR sky130_fd_sc_hd__decap_4
X_4026_ _1021_ _1878_ _1941_ VGND VGND VPWR VPWR _1942_ sky130_fd_sc_hd__nand3b_2
XFILLER_71_107 VGND VGND VPWR VPWR sky130_fd_sc_hd__decap_4
XFILLER_25_524 VGND VGND VPWR VPWR sky130_fd_sc_hd__fill_1
XFILLER_80_652 VPWR VGND VPWR VGND sky130_ef_sc_hd__decap_12
XFILLER_80_696 VGND VGND VPWR VPWR sky130_fd_sc_hd__decap_4
XFILLER_80_685 VGND VGND VPWR VPWR sky130_fd_sc_hd__fill_2
X_5977_ net147 VGND VGND VPWR VPWR _0385_ sky130_fd_sc_hd__inv_2
X_4928_ _1220_ _2286_ _2532_ _2698_ _2780_ VGND VGND VPWR VPWR _2781_ sky130_fd_sc_hd__a221o_1
XFILLER_60_27 VGND VGND VPWR VPWR sky130_fd_sc_hd__fill_1
XFILLER_20_240 VPWR VGND VPWR VGND sky130_ef_sc_hd__decap_12
X_4859_ _2570_ _2676_ _2678_ VGND VGND VPWR VPWR _2716_ sky130_fd_sc_hd__or3_1
XFILLER_119_673 VPWR VGND VPWR VGND sky130_ef_sc_hd__decap_12
Xclkbuf_3_0__f_clk clknet_0_clk VGND VGND VPWR VPWR clknet_3_0__leaf_clk sky130_fd_sc_hd__clkbuf_16
XFILLER_106_301 VGND VGND VPWR VPWR sky130_fd_sc_hd__decap_6
XFILLER_4_439 VPWR VGND VPWR VGND sky130_ef_sc_hd__decap_12
X_6529_ clknet_leaf_48_clk _0937_ _0462_ VGND VGND VPWR VPWR net108 sky130_fd_sc_hd__dfrtp_1
XFILLER_106_345 VPWR VGND VPWR VGND sky130_ef_sc_hd__decap_12
XTAP_TAPCELL_ROW_91_1407 VGND VPWR sky130_fd_sc_hd__tapvpwrvgnd_1
XFILLER_69_47 VGND VGND VPWR VPWR sky130_fd_sc_hd__decap_3
XFILLER_106_389 VPWR VGND VPWR VGND sky130_ef_sc_hd__decap_12
XFILLER_121_337 VPWR VGND VPWR VGND sky130_ef_sc_hd__decap_12
XFILLER_0_623 VGND VGND VPWR VPWR sky130_fd_sc_hd__decap_8
XFILLER_0_656 VGND VGND VPWR VPWR sky130_fd_sc_hd__fill_2
XFILLER_87_262 VPWR VGND VPWR VGND sky130_ef_sc_hd__decap_12
XFILLER_87_240 VGND VGND VPWR VPWR sky130_fd_sc_hd__fill_1
XFILLER_48_638 VGND VGND VPWR VPWR sky130_fd_sc_hd__fill_1
XFILLER_90_405 VPWR VGND VPWR VGND sky130_ef_sc_hd__decap_12
XFILLER_28_351 VGND VGND VPWR VPWR sky130_fd_sc_hd__decap_6
XFILLER_90_438 VPWR VGND VPWR VGND sky130_ef_sc_hd__decap_12
XFILLER_56_671 VPWR VGND VPWR VGND sky130_ef_sc_hd__decap_12
XTAP_TAPCELL_ROW_46_839 VGND VPWR sky130_fd_sc_hd__tapvpwrvgnd_1
XFILLER_71_641 VGND VGND VPWR VPWR sky130_fd_sc_hd__decap_6
XFILLER_55_181 VGND VGND VPWR VPWR sky130_fd_sc_hd__fill_2
XTAP_TAPCELL_ROW_100_1514 VGND VPWR sky130_fd_sc_hd__tapvpwrvgnd_1
XTAP_TAPCELL_ROW_26_585 VGND VPWR sky130_fd_sc_hd__tapvpwrvgnd_1
XFILLER_8_701 VPWR VGND VPWR VGND sky130_ef_sc_hd__decap_12
XFILLER_116_109 VPWR VGND VPWR VGND sky130_ef_sc_hd__decap_12
XFILLER_50_60 VGND VGND VPWR VPWR sky130_fd_sc_hd__decap_8
XFILLER_109_161 VGND VGND VPWR VPWR sky130_fd_sc_hd__decap_6
XPHY_EDGE_ROW_84_Left_207 VGND VGND VPWR VPWR sky130_fd_sc_hd__decap_3
XTAP_TAPCELL_ROW_111_1654 VGND VPWR sky130_fd_sc_hd__tapvpwrvgnd_1
XFILLER_3_494 VGND VGND VPWR VPWR sky130_fd_sc_hd__decap_8
X_3190_ _1114_ net142 VGND VGND VPWR VPWR _1134_ sky130_fd_sc_hd__and2_4
XFILLER_66_435 VGND VGND VPWR VPWR sky130_fd_sc_hd__decap_4
XFILLER_39_649 VPWR VGND VPWR VGND sky130_ef_sc_hd__decap_12
XFILLER_38_148 VGND VGND VPWR VPWR sky130_fd_sc_hd__decap_8
XFILLER_19_362 VPWR VGND VPWR VGND sky130_ef_sc_hd__decap_12
X_5900_ net146 VGND VGND VPWR VPWR _0308_ sky130_fd_sc_hd__inv_2
XPHY_EDGE_ROW_93_Left_216 VGND VGND VPWR VPWR sky130_fd_sc_hd__decap_3
XFILLER_34_321 VGND VGND VPWR VPWR sky130_fd_sc_hd__fill_1
X_5831_ net147 VGND VGND VPWR VPWR _0239_ sky130_fd_sc_hd__inv_2
XFILLER_34_365 VGND VGND VPWR VPWR sky130_fd_sc_hd__decap_6
XTAP_TAPCELL_ROW_122_1783 VGND VPWR sky130_fd_sc_hd__tapvpwrvgnd_1
X_5762_ net147 VGND VGND VPWR VPWR _0170_ sky130_fd_sc_hd__inv_2
XTAP_TAPCELL_ROW_122_1794 VGND VPWR sky130_fd_sc_hd__tapvpwrvgnd_1
X_4713_ _2570_ _2571_ VGND VGND VPWR VPWR _2572_ sky130_fd_sc_hd__or2_1
X_5693_ net148 VGND VGND VPWR VPWR _0101_ sky130_fd_sc_hd__inv_2
X_4644_ _2383_ _2394_ _1790_ VGND VGND VPWR VPWR _2519_ sky130_fd_sc_hd__mux2_1
X_4575_ net23 _2309_ _2454_ VGND VGND VPWR VPWR _2455_ sky130_fd_sc_hd__o21a_4
XFILLER_116_643 VGND VGND VPWR VPWR sky130_fd_sc_hd__fill_1
X_6314_ clknet_leaf_33_clk _0722_ _0247_ VGND VGND VPWR VPWR reg_file_inst.registry\[3\]\[23\]
+ sky130_fd_sc_hd__dfrtp_1
X_3526_ reg_file_inst.registry\[0\]\[13\] net138 _1450_ _1456_ VGND VGND VPWR VPWR
+ _1457_ sky130_fd_sc_hd__o22ai_4
X_6245_ clknet_leaf_26_clk _0653_ _0178_ VGND VGND VPWR VPWR reg_file_inst.registry\[4\]\[10\]
+ sky130_fd_sc_hd__dfrtp_1
XFILLER_103_337 VPWR VGND VPWR VGND sky130_ef_sc_hd__decap_12
X_3457_ reg_file_inst.registry\[10\]\[16\] _1126_ _1388_ _1389_ _1390_ VGND VGND VPWR
+ VPWR _1391_ sky130_fd_sc_hd__a2111o_1
X_3388_ reg_file_inst.registry\[9\]\[19\] _1089_ _1098_ reg_file_inst.registry\[10\]\[19\]
+ VGND VGND VPWR VPWR _1324_ sky130_fd_sc_hd__a22o_1
X_6176_ clknet_leaf_31_clk _0584_ _0109_ VGND VGND VPWR VPWR JMPOFF\[25\] sky130_fd_sc_hd__dfrtp_4
X_5127_ _2951_ VGND VGND VPWR VPWR _2952_ sky130_fd_sc_hd__inv_2
X_5058_ net137 _2304_ _2892_ _2296_ VGND VGND VPWR VPWR _2893_ sky130_fd_sc_hd__o211a_1
XPHY_EDGE_ROW_2_Right_2 VGND VGND VPWR VPWR sky130_fd_sc_hd__decap_3
XFILLER_29_159 VGND VGND VPWR VPWR sky130_fd_sc_hd__decap_8
XFILLER_84_298 VGND VGND VPWR VPWR sky130_fd_sc_hd__decap_8
XFILLER_84_265 VPWR VGND VPWR VGND sky130_ef_sc_hd__decap_12
XFILLER_55_27 VPWR VGND VPWR VGND sky130_ef_sc_hd__decap_12
XFILLER_44_107 VPWR VGND VPWR VGND sky130_ef_sc_hd__decap_12
X_4009_ _1892_ _1896_ _1891_ VGND VGND VPWR VPWR _1925_ sky130_fd_sc_hd__a21boi_1
XFILLER_53_641 VGND VGND VPWR VPWR sky130_fd_sc_hd__decap_6
XFILLER_111_55 VGND VGND VPWR VPWR sky130_fd_sc_hd__fill_1
XFILLER_52_162 VPWR VGND VPWR VGND sky130_ef_sc_hd__decap_12
XFILLER_52_195 VGND VGND VPWR VPWR sky130_fd_sc_hd__fill_1
XFILLER_25_387 VGND VGND VPWR VPWR sky130_fd_sc_hd__decap_4
XTAP_TAPCELL_ROW_23_555 VGND VPWR sky130_fd_sc_hd__tapvpwrvgnd_1
XTAP_TAPCELL_ROW_51_897 VGND VPWR sky130_fd_sc_hd__tapvpwrvgnd_1
XFILLER_107_665 VGND VGND VPWR VPWR sky130_fd_sc_hd__decap_6
XFILLER_122_613 VGND VGND VPWR VPWR sky130_fd_sc_hd__decap_3
XFILLER_106_153 VPWR VGND VPWR VGND sky130_ef_sc_hd__decap_12
XFILLER_122_657 VPWR VGND VPWR VGND sky130_ef_sc_hd__decap_12
XFILLER_106_197 VPWR VGND VPWR VGND sky130_ef_sc_hd__decap_12
XFILLER_121_167 VGND VGND VPWR VPWR sky130_fd_sc_hd__fill_1
XFILLER_0_453 VGND VGND VPWR VPWR sky130_fd_sc_hd__decap_8
XFILLER_29_72 VGND VGND VPWR VPWR sky130_fd_sc_hd__decap_3
XFILLER_91_725 VGND VGND VPWR VPWR sky130_fd_sc_hd__fill_1
XTAP_TAPCELL_ROW_59_997 VGND VPWR sky130_fd_sc_hd__tapvpwrvgnd_1
XFILLER_29_671 VGND VGND VPWR VPWR sky130_fd_sc_hd__fill_1
XFILLER_63_449 VGND VGND VPWR VPWR sky130_fd_sc_hd__fill_2
Xclkbuf_leaf_55_clk clknet_3_4__leaf_clk VGND VGND VPWR VPWR clknet_leaf_55_clk sky130_fd_sc_hd__clkbuf_8
XFILLER_71_460 VPWR VGND VPWR VGND sky130_ef_sc_hd__decap_12
XFILLER_16_365 VPWR VGND VPWR VGND sky130_ef_sc_hd__decap_12
XFILLER_43_162 VGND VGND VPWR VPWR sky130_fd_sc_hd__decap_6
XFILLER_43_173 VGND VGND VPWR VPWR sky130_fd_sc_hd__fill_1
XTAP_TAPCELL_ROW_61_1030 VGND VPWR sky130_fd_sc_hd__tapvpwrvgnd_1
XFILLER_12_593 VGND VGND VPWR VPWR sky130_fd_sc_hd__decap_8
XFILLER_117_429 VPWR VGND VPWR VGND sky130_ef_sc_hd__decap_12
XANTENNA_3 JMPOFF\[6\] VGND VGND VPWR VPWR sky130_fd_sc_hd__diode_2
XFILLER_6_65 VPWR VGND VPWR VGND sky130_ef_sc_hd__decap_12
X_4360_ _1764_ _2247_ _2237_ VGND VGND VPWR VPWR _2248_ sky130_fd_sc_hd__o21a_1
X_3311_ reg_file_inst.registry\[15\]\[22\] _1093_ _1075_ VGND VGND VPWR VPWR _1250_
+ sky130_fd_sc_hd__a21o_1
X_4291_ _2177_ _2178_ _2174_ VGND VGND VPWR VPWR _2179_ sky130_fd_sc_hd__nor3b_1
XFILLER_100_307 VGND VGND VPWR VPWR sky130_fd_sc_hd__fill_1
XFILLER_98_368 VPWR VGND VPWR VGND sky130_ef_sc_hd__decap_12
X_3242_ _1075_ _1179_ _1180_ _1183_ VGND VGND VPWR VPWR _1184_ sky130_fd_sc_hd__or4_1
XTAP_TAPCELL_ROW_72_1170 VGND VPWR sky130_fd_sc_hd__tapvpwrvgnd_1
X_6030_ net147 VGND VGND VPWR VPWR _0438_ sky130_fd_sc_hd__inv_2
XFILLER_39_402 VGND VGND VPWR VPWR sky130_fd_sc_hd__decap_4
XFILLER_112_189 VGND VGND VPWR VPWR sky130_fd_sc_hd__decap_6
XFILLER_100_329 VGND VGND VPWR VPWR sky130_fd_sc_hd__fill_1
XFILLER_79_593 VGND VGND VPWR VPWR sky130_fd_sc_hd__fill_1
X_3173_ _1114_ net145 VGND VGND VPWR VPWR _1117_ sky130_fd_sc_hd__and2_4
XFILLER_94_530 VGND VGND VPWR VPWR sky130_fd_sc_hd__fill_2
XFILLER_39_457 VGND VGND VPWR VPWR sky130_fd_sc_hd__decap_3
XFILLER_82_725 VGND VGND VPWR VPWR sky130_fd_sc_hd__fill_1
XFILLER_81_246 VGND VGND VPWR VPWR sky130_fd_sc_hd__fill_1
XFILLER_35_641 VGND VGND VPWR VPWR sky130_fd_sc_hd__fill_1
Xclkbuf_leaf_46_clk clknet_3_5__leaf_clk VGND VGND VPWR VPWR clknet_leaf_46_clk sky130_fd_sc_hd__clkbuf_8
XFILLER_81_279 VGND VGND VPWR VPWR sky130_fd_sc_hd__fill_1
X_5814_ net148 VGND VGND VPWR VPWR _0222_ sky130_fd_sc_hd__inv_2
XFILLER_22_324 VGND VGND VPWR VPWR sky130_fd_sc_hd__fill_1
XFILLER_34_162 VGND VGND VPWR VPWR sky130_fd_sc_hd__decap_8
XFILLER_22_368 VPWR VGND VPWR VGND sky130_ef_sc_hd__decap_12
X_5745_ net147 VGND VGND VPWR VPWR _0153_ sky130_fd_sc_hd__inv_2
XFILLER_50_699 VGND VGND VPWR VPWR sky130_fd_sc_hd__fill_1
XTAP_TAPCELL_ROW_20_514 VGND VPWR sky130_fd_sc_hd__tapvpwrvgnd_1
X_5676_ net146 VGND VGND VPWR VPWR _0084_ sky130_fd_sc_hd__inv_2
X_4627_ _2258_ _2263_ VGND VGND VPWR VPWR _2502_ sky130_fd_sc_hd__nor2_1
XFILLER_104_613 VPWR VGND VPWR VGND sky130_ef_sc_hd__decap_12
X_4558_ _1723_ _2287_ _2438_ _1709_ _2436_ VGND VGND VPWR VPWR _2439_ sky130_fd_sc_hd__o221a_1
XFILLER_104_657 VPWR VGND VPWR VGND sky130_ef_sc_hd__decap_12
XFILLER_89_335 VGND VGND VPWR VPWR sky130_fd_sc_hd__fill_1
X_3509_ MEMOFF\[12\] _1129_ _1130_ JMPOFF\[12\] _1440_ VGND VGND VPWR VPWR _1441_
+ sky130_fd_sc_hd__a221o_1
X_4489_ _2372_ _2373_ VGND VGND VPWR VPWR net69 sky130_fd_sc_hd__or2_2
X_6228_ clknet_leaf_36_clk _0636_ _0161_ VGND VGND VPWR VPWR reg_file_inst.registry\[10\]\[21\]
+ sky130_fd_sc_hd__dfrtp_1
XFILLER_106_77 VGND VGND VPWR VPWR sky130_fd_sc_hd__decap_6
XFILLER_103_189 VPWR VGND VPWR VGND sky130_ef_sc_hd__decap_12
X_6159_ clknet_leaf_50_clk _0567_ _0092_ VGND VGND VPWR VPWR JMPOFF\[8\] sky130_fd_sc_hd__dfrtp_4
XFILLER_85_541 VPWR VGND VPWR VGND sky130_ef_sc_hd__decap_12
XFILLER_73_714 VGND VGND VPWR VPWR sky130_fd_sc_hd__decap_3
XFILLER_57_276 VGND VGND VPWR VPWR sky130_fd_sc_hd__decap_4
XTAP_TAPCELL_ROW_28_614 VGND VPWR sky130_fd_sc_hd__tapvpwrvgnd_1
XFILLER_45_405 VGND VGND VPWR VPWR sky130_fd_sc_hd__fill_2
XTAP_TAPCELL_ROW_86_1339 VGND VPWR sky130_fd_sc_hd__tapvpwrvgnd_1
Xclkbuf_leaf_37_clk clknet_3_7__leaf_clk VGND VGND VPWR VPWR clknet_leaf_37_clk sky130_fd_sc_hd__clkbuf_8
XTAP_TAPCELL_ROW_56_967 VGND VPWR sky130_fd_sc_hd__tapvpwrvgnd_1
XTAP_TAPCELL_ROW_0_250 VGND VPWR sky130_fd_sc_hd__tapvpwrvgnd_1
XTAP_TAPCELL_ROW_0_261 VGND VPWR sky130_fd_sc_hd__tapvpwrvgnd_1
XFILLER_26_663 VGND VGND VPWR VPWR sky130_fd_sc_hd__fill_1
XFILLER_26_674 VPWR VGND VPWR VGND sky130_ef_sc_hd__decap_12
XFILLER_25_162 VGND VGND VPWR VPWR sky130_fd_sc_hd__decap_6
XFILLER_13_335 VGND VGND VPWR VPWR sky130_fd_sc_hd__fill_1
XFILLER_13_346 VGND VGND VPWR VPWR sky130_fd_sc_hd__decap_6
XFILLER_13_368 VGND VGND VPWR VPWR sky130_fd_sc_hd__decap_8
XFILLER_41_655 VPWR VGND VPWR VGND sky130_ef_sc_hd__decap_12
XTAP_TAPCELL_ROW_97_1479 VGND VPWR sky130_fd_sc_hd__tapvpwrvgnd_1
XFILLER_107_473 VPWR VGND VPWR VGND sky130_ef_sc_hd__decap_12
XFILLER_122_421 VPWR VGND VPWR VGND sky130_ef_sc_hd__decap_12
Xoutput51 net51 VGND VGND VPWR VPWR DataAddress[15] sky130_fd_sc_hd__buf_1
XTAP_TAPCELL_ROW_8_361 VGND VPWR sky130_fd_sc_hd__tapvpwrvgnd_1
Xoutput84 net84 VGND VGND VPWR VPWR DataMemoryWrite[1] sky130_fd_sc_hd__buf_1
Xoutput73 net73 VGND VGND VPWR VPWR DataMemoryWrite[0] sky130_fd_sc_hd__buf_1
Xoutput62 net62 VGND VGND VPWR VPWR DataAddress[25] sky130_fd_sc_hd__buf_1
Xoutput95 net95 VGND VGND VPWR VPWR DataMemoryWrite[4] sky130_fd_sc_hd__buf_1
XFILLER_49_711 VPWR VGND VPWR VGND sky130_ef_sc_hd__decap_12
XFILLER_91_500 VGND VGND VPWR VPWR sky130_fd_sc_hd__decap_4
XFILLER_91_544 VPWR VGND VPWR VGND sky130_ef_sc_hd__decap_12
Xclkbuf_leaf_28_clk clknet_3_6__leaf_clk VGND VGND VPWR VPWR clknet_leaf_28_clk sky130_fd_sc_hd__clkbuf_8
XFILLER_56_92 VGND VGND VPWR VPWR sky130_fd_sc_hd__decap_3
XFILLER_36_438 VPWR VGND VPWR VGND sky130_ef_sc_hd__decap_12
XFILLER_91_577 VGND VGND VPWR VPWR sky130_fd_sc_hd__fill_1
XTAP_TAPCELL_ROW_106_1586 VGND VPWR sky130_fd_sc_hd__tapvpwrvgnd_1
XFILLER_17_685 VGND VGND VPWR VPWR sky130_fd_sc_hd__decap_8
XFILLER_32_633 VGND VGND VPWR VPWR sky130_fd_sc_hd__decap_8
X_3860_ _1765_ _1778_ VGND VGND VPWR VPWR _1779_ sky130_fd_sc_hd__xnor2_1
X_3791_ reg_file_inst.registry\[9\]\[4\] _1125_ _1127_ VGND VGND VPWR VPWR _1713_
+ sky130_fd_sc_hd__and3_1
X_5530_ reg_file_inst.registry\[6\]\[4\] _2455_ _3001_ VGND VGND VPWR VPWR _0535_
+ sky130_fd_sc_hd__mux2_1
X_5461_ reg_file_inst.registry\[5\]\[15\] _2897_ _2999_ VGND VGND VPWR VPWR _0602_
+ sky130_fd_sc_hd__mux2_1
XFILLER_117_237 VPWR VGND VPWR VGND sky130_ef_sc_hd__decap_12
X_4412_ net136 _2242_ _2299_ VGND VGND VPWR VPWR _2300_ sky130_fd_sc_hd__a21oi_1
X_5392_ reg_file_inst.registry\[4\]\[26\] _2747_ _2997_ VGND VGND VPWR VPWR _0669_
+ sky130_fd_sc_hd__mux2_1
XPHY_EDGE_ROW_99_Right_99 VGND VGND VPWR VPWR sky130_fd_sc_hd__decap_3
XFILLER_98_121 VGND VGND VPWR VPWR sky130_fd_sc_hd__decap_6
X_4343_ _1294_ _2190_ VGND VGND VPWR VPWR _2231_ sky130_fd_sc_hd__and2_1
XFILLER_59_508 VPWR VGND VPWR VGND sky130_ef_sc_hd__decap_12
X_4274_ _1867_ _2161_ VGND VGND VPWR VPWR _2162_ sky130_fd_sc_hd__nand2_1
XFILLER_98_176 VPWR VGND VPWR VGND sky130_ef_sc_hd__decap_12
X_3225_ reg_file_inst.registry\[9\]\[26\] _1131_ _1140_ reg_file_inst.registry\[3\]\[26\]
+ VGND VGND VPWR VPWR _1168_ sky130_fd_sc_hd__a22o_1
X_6013_ net146 VGND VGND VPWR VPWR _0421_ sky130_fd_sc_hd__inv_2
X_3156_ reg_file_inst.registry\[14\]\[27\] _1081_ _1090_ reg_file_inst.registry\[8\]\[27\]
+ _1099_ VGND VGND VPWR VPWR _1100_ sky130_fd_sc_hd__a221o_1
XFILLER_67_585 VPWR VGND VPWR VGND sky130_ef_sc_hd__decap_12
Xclkbuf_leaf_19_clk clknet_3_2__leaf_clk VGND VGND VPWR VPWR clknet_leaf_19_clk sky130_fd_sc_hd__clkbuf_8
XFILLER_82_533 VPWR VGND VPWR VGND sky130_ef_sc_hd__decap_12
XFILLER_27_449 VGND VGND VPWR VPWR sky130_fd_sc_hd__decap_3
X_3087_ JMPOFF\[9\] _0967_ _1030_ VGND VGND VPWR VPWR _1031_ sky130_fd_sc_hd__a21bo_1
XFILLER_36_29 VPWR VGND VPWR VGND sky130_ef_sc_hd__decap_12
XTAP_TAPCELL_ROW_53_926 VGND VPWR sky130_fd_sc_hd__tapvpwrvgnd_1
XFILLER_23_633 VGND VGND VPWR VPWR sky130_fd_sc_hd__decap_6
XFILLER_23_644 VGND VGND VPWR VPWR sky130_fd_sc_hd__decap_8
XTAP_TAPCELL_ROW_33_672 VGND VPWR sky130_fd_sc_hd__tapvpwrvgnd_1
X_5728_ net149 VGND VGND VPWR VPWR _0136_ sky130_fd_sc_hd__inv_2
XFILLER_10_338 VPWR VGND VPWR VGND sky130_ef_sc_hd__decap_12
XFILLER_10_327 VGND VGND VPWR VPWR sky130_fd_sc_hd__decap_8
X_3989_ _1886_ _1904_ VGND VGND VPWR VPWR _1905_ sky130_fd_sc_hd__and2_1
X_5659_ net147 VGND VGND VPWR VPWR _0067_ sky130_fd_sc_hd__inv_2
XFILLER_104_421 VGND VGND VPWR VPWR sky130_fd_sc_hd__fill_1
XTAP_TAPCELL_ROW_5_331 VGND VPWR sky130_fd_sc_hd__tapvpwrvgnd_1
XFILLER_85_360 VPWR VGND VPWR VGND sky130_ef_sc_hd__decap_12
XFILLER_100_693 VGND VGND VPWR VPWR sky130_fd_sc_hd__decap_6
XFILLER_93_57 VGND VGND VPWR VPWR sky130_fd_sc_hd__decap_6
XFILLER_93_46 VGND VGND VPWR VPWR sky130_fd_sc_hd__decap_3
XFILLER_18_449 VGND VGND VPWR VPWR sky130_fd_sc_hd__decap_4
XFILLER_93_79 VGND VGND VPWR VPWR sky130_fd_sc_hd__decap_6
XFILLER_73_555 VGND VGND VPWR VPWR sky130_fd_sc_hd__decap_4
XFILLER_26_51 VPWR VGND VPWR VGND sky130_ef_sc_hd__decap_12
XFILLER_13_132 VGND VGND VPWR VPWR sky130_fd_sc_hd__fill_1
XFILLER_14_699 VGND VGND VPWR VPWR sky130_fd_sc_hd__fill_1
XFILLER_41_452 VGND VGND VPWR VPWR sky130_fd_sc_hd__decap_4
XFILLER_42_61 VGND VGND VPWR VPWR sky130_fd_sc_hd__fill_1
XFILLER_9_169 VGND VGND VPWR VPWR sky130_fd_sc_hd__fill_2
XFILLER_42_83 VGND VGND VPWR VPWR sky130_fd_sc_hd__fill_1
XTAP_TAPCELL_ROW_11_399 VGND VPWR sky130_fd_sc_hd__tapvpwrvgnd_1
XFILLER_107_281 VPWR VGND VPWR VGND sky130_ef_sc_hd__decap_12
XFILLER_110_413 VGND VGND VPWR VPWR sky130_fd_sc_hd__decap_6
XFILLER_96_625 VPWR VGND VPWR VGND sky130_ef_sc_hd__decap_12
XFILLER_3_55 VGND VGND VPWR VPWR sky130_fd_sc_hd__fill_1
XFILLER_110_457 VPWR VGND VPWR VGND sky130_ef_sc_hd__decap_12
XFILLER_96_669 VPWR VGND VPWR VGND sky130_ef_sc_hd__decap_12
XFILLER_95_157 VGND VGND VPWR VPWR sky130_fd_sc_hd__decap_8
XFILLER_95_124 VGND VGND VPWR VPWR sky130_fd_sc_hd__decap_3
XFILLER_49_530 VGND VGND VPWR VPWR sky130_fd_sc_hd__fill_1
XFILLER_67_91 VPWR VGND VPWR VGND sky130_ef_sc_hd__decap_12
X_3010_ net34 VGND VGND VPWR VPWR _0956_ sky130_fd_sc_hd__inv_2
XFILLER_37_725 VGND VGND VPWR VPWR sky130_fd_sc_hd__fill_1
XTAP_TAPCELL_ROW_108_1615 VGND VPWR sky130_fd_sc_hd__tapvpwrvgnd_1
XFILLER_64_533 VGND VGND VPWR VPWR sky130_fd_sc_hd__decap_4
XFILLER_36_224 VGND VGND VPWR VPWR sky130_fd_sc_hd__decap_3
XTAP_TAPCELL_ROW_19_499 VGND VPWR sky130_fd_sc_hd__tapvpwrvgnd_1
X_4961_ _1267_ _2282_ _2285_ _1268_ _2809_ VGND VGND VPWR VPWR _2810_ sky130_fd_sc_hd__o221ai_4
X_4892_ reg_file_inst.registry\[7\]\[26\] _2747_ _2553_ VGND VGND VPWR VPWR _0901_
+ sky130_fd_sc_hd__mux2_1
XFILLER_44_290 VPWR VGND VPWR VGND sky130_ef_sc_hd__decap_12
X_3912_ reg_file_inst.registry\[6\]\[0\] _1080_ _1084_ VGND VGND VPWR VPWR _1829_
+ sky130_fd_sc_hd__and3_1
X_3843_ _1759_ _1760_ _1761_ _1762_ VGND VGND VPWR VPWR _1763_ sky130_fd_sc_hd__or4_2
XFILLER_118_513 VPWR VGND VPWR VGND sky130_ef_sc_hd__decap_12
XTAP_TAPCELL_ROW_30_642 VGND VPWR sky130_fd_sc_hd__tapvpwrvgnd_1
X_3774_ MEMOFF\[4\] _1079_ _1097_ reg_file_inst.registry\[5\]\[4\] VGND VGND VPWR
+ VPWR _1696_ sky130_fd_sc_hd__a22o_1
XTAP_TAPCELL_ROW_119_1755 VGND VPWR sky130_fd_sc_hd__tapvpwrvgnd_1
XFILLER_118_557 VPWR VGND VPWR VGND sky130_ef_sc_hd__decap_12
X_6493_ clknet_leaf_21_clk _0901_ _0426_ VGND VGND VPWR VPWR reg_file_inst.registry\[7\]\[26\]
+ sky130_fd_sc_hd__dfrtp_1
X_5513_ reg_file_inst.registry\[6\]\[21\] _2829_ _3001_ VGND VGND VPWR VPWR _0552_
+ sky130_fd_sc_hd__mux2_1
Xclkbuf_leaf_8_clk clknet_3_3__leaf_clk VGND VGND VPWR VPWR clknet_leaf_8_clk sky130_fd_sc_hd__clkbuf_8
X_5444_ _2478_ reg_file_inst.registry\[10\]\[3\] _2998_ VGND VGND VPWR VPWR _0618_
+ sky130_fd_sc_hd__mux2_1
X_5375_ MEMOFF\[14\] _2909_ _2996_ VGND VGND VPWR VPWR _0685_ sky130_fd_sc_hd__mux2_1
XFILLER_113_273 VGND VGND VPWR VPWR sky130_fd_sc_hd__decap_6
XFILLER_101_413 VGND VGND VPWR VPWR sky130_fd_sc_hd__decap_8
XFILLER_87_614 VGND VGND VPWR VPWR sky130_fd_sc_hd__fill_2
X_4326_ net132 _2213_ VGND VGND VPWR VPWR _2214_ sky130_fd_sc_hd__nor2_1
X_4257_ _1751_ _2144_ VGND VGND VPWR VPWR _2145_ sky130_fd_sc_hd__or2_1
X_3208_ MEMOFF\[27\] net92 _1113_ VGND VGND VPWR VPWR _1151_ sky130_fd_sc_hd__mux2_8
XFILLER_55_500 VGND VGND VPWR VPWR sky130_fd_sc_hd__decap_4
X_4188_ _1902_ _2090_ VGND VGND VPWR VPWR _2091_ sky130_fd_sc_hd__xnor2_1
XFILLER_47_39 VPWR VGND VPWR VGND sky130_ef_sc_hd__decap_12
XFILLER_67_393 VGND VGND VPWR VPWR sky130_fd_sc_hd__decap_8
X_3139_ _1080_ _1082_ VGND VGND VPWR VPWR _1083_ sky130_fd_sc_hd__and2_4
XFILLER_82_330 VPWR VGND VPWR VGND sky130_ef_sc_hd__decap_12
XTAP_TAPCELL_ROW_38_742 VGND VPWR sky130_fd_sc_hd__tapvpwrvgnd_1
XFILLER_55_599 VPWR VGND VPWR VGND sky130_ef_sc_hd__decap_12
XFILLER_27_279 VGND VGND VPWR VPWR sky130_fd_sc_hd__fill_1
XFILLER_7_629 VPWR VGND VPWR VGND sky130_ef_sc_hd__decap_12
XFILLER_6_106 VPWR VGND VPWR VGND sky130_ef_sc_hd__decap_12
XFILLER_12_53 VGND VGND VPWR VPWR sky130_fd_sc_hd__decap_4
XTAP_TAPCELL_ROW_94_1438 VGND VPWR sky130_fd_sc_hd__tapvpwrvgnd_1
XFILLER_5_3 VPWR VGND VPWR VGND sky130_ef_sc_hd__decap_12
XFILLER_2_334 VGND VGND VPWR VPWR sky130_fd_sc_hd__decap_4
XFILLER_2_345 VGND VGND VPWR VPWR sky130_fd_sc_hd__decap_4
XFILLER_104_273 VGND VGND VPWR VPWR sky130_fd_sc_hd__fill_2
XFILLER_104_251 VGND VGND VPWR VPWR sky130_fd_sc_hd__fill_1
XFILLER_78_625 VPWR VGND VPWR VGND sky130_ef_sc_hd__decap_12
XFILLER_77_113 VGND VGND VPWR VPWR sky130_fd_sc_hd__fill_2
XFILLER_104_295 VGND VGND VPWR VPWR sky130_fd_sc_hd__decap_3
XFILLER_78_669 VPWR VGND VPWR VGND sky130_ef_sc_hd__decap_12
XFILLER_93_617 VPWR VGND VPWR VGND sky130_ef_sc_hd__decap_12
XFILLER_58_360 VGND VGND VPWR VPWR sky130_fd_sc_hd__decap_4
XFILLER_46_533 VGND VGND VPWR VPWR sky130_fd_sc_hd__fill_1
XFILLER_61_503 VGND VGND VPWR VPWR sky130_fd_sc_hd__fill_1
XFILLER_37_94 VGND VGND VPWR VPWR sky130_fd_sc_hd__fill_1
XFILLER_61_514 VGND VGND VPWR VPWR sky130_fd_sc_hd__decap_4
XFILLER_33_216 VGND VGND VPWR VPWR sky130_fd_sc_hd__fill_1
XTAP_TAPCELL_ROW_103_1556 VGND VPWR sky130_fd_sc_hd__tapvpwrvgnd_1
XTAP_TAPCELL_ROW_16_458 VGND VPWR sky130_fd_sc_hd__tapvpwrvgnd_1
XTAP_TAPCELL_ROW_16_469 VGND VPWR sky130_fd_sc_hd__tapvpwrvgnd_1
XFILLER_115_505 VPWR VGND VPWR VGND sky130_ef_sc_hd__decap_12
X_3490_ reg_file_inst.registry\[2\]\[12\] _1080_ _1082_ VGND VGND VPWR VPWR _1422_
+ sky130_fd_sc_hd__and3_1
XFILLER_5_150 VGND VGND VPWR VPWR sky130_fd_sc_hd__fill_1
XTAP_TAPCELL_ROW_114_1685 VGND VPWR sky130_fd_sc_hd__tapvpwrvgnd_1
XFILLER_69_614 VGND VGND VPWR VPWR sky130_fd_sc_hd__fill_2
X_5160_ _1607_ _2123_ _2286_ _1639_ _2288_ VGND VGND VPWR VPWR _2981_ sky130_fd_sc_hd__a221o_1
XFILLER_38_3 VPWR VGND VPWR VGND sky130_ef_sc_hd__decap_12
XFILLER_110_221 VPWR VGND VPWR VGND sky130_ef_sc_hd__decap_12
X_4111_ net131 _2024_ _2025_ net116 VGND VGND VPWR VPWR _2027_ sky130_fd_sc_hd__a31oi_2
X_5091_ _2176_ _2910_ _2911_ _2919_ _2921_ VGND VGND VPWR VPWR net49 sky130_fd_sc_hd__a311o_1
XFILLER_110_265 VPWR VGND VPWR VGND sky130_ef_sc_hd__decap_12
XFILLER_96_477 VGND VGND VPWR VPWR sky130_fd_sc_hd__decap_8
X_4042_ _1878_ _1957_ net113 VGND VGND VPWR VPWR _1958_ sky130_fd_sc_hd__a21boi_1
XFILLER_49_393 VGND VGND VPWR VPWR sky130_fd_sc_hd__decap_6
XTAP_TAPCELL_ROW_69_1131 VGND VPWR sky130_fd_sc_hd__tapvpwrvgnd_1
XFILLER_52_503 VGND VGND VPWR VPWR sky130_fd_sc_hd__decap_4
XTAP_TAPCELL_ROW_35_701 VGND VPWR sky130_fd_sc_hd__tapvpwrvgnd_1
X_5993_ net149 VGND VGND VPWR VPWR _0401_ sky130_fd_sc_hd__inv_2
X_4944_ _1231_ _1242_ _2794_ VGND VGND VPWR VPWR _2795_ sky130_fd_sc_hd__o21ai_1
X_4875_ _2205_ _2206_ _1840_ VGND VGND VPWR VPWR _2732_ sky130_fd_sc_hd__mux2_1
XFILLER_20_433 VGND VGND VPWR VPWR sky130_fd_sc_hd__fill_2
X_3826_ reg_file_inst.registry\[6\]\[5\] _1135_ _1137_ reg_file_inst.registry\[2\]\[5\]
+ VGND VGND VPWR VPWR _1747_ sky130_fd_sc_hd__a22o_1
XFILLER_118_321 VPWR VGND VPWR VGND sky130_ef_sc_hd__decap_12
XPHY_EDGE_ROW_104_Left_227 VGND VGND VPWR VPWR sky130_fd_sc_hd__decap_3
XFILLER_20_477 VGND VGND VPWR VPWR sky130_fd_sc_hd__fill_2
X_3757_ _1679_ VGND VGND VPWR VPWR _1680_ sky130_fd_sc_hd__inv_2
XFILLER_118_365 VPWR VGND VPWR VGND sky130_ef_sc_hd__decap_12
X_6476_ clknet_leaf_6_clk _0884_ _0409_ VGND VGND VPWR VPWR reg_file_inst.registry\[7\]\[9\]
+ sky130_fd_sc_hd__dfrtp_1
XFILLER_3_109 VGND VGND VPWR VPWR sky130_fd_sc_hd__decap_3
X_3688_ reg_file_inst.registry\[10\]\[8\] _1126_ _1133_ reg_file_inst.registry\[7\]\[8\]
+ VGND VGND VPWR VPWR _1613_ sky130_fd_sc_hd__a22o_1
X_5427_ _2842_ reg_file_inst.registry\[10\]\[20\] _2998_ VGND VGND VPWR VPWR _0635_
+ sky130_fd_sc_hd__mux2_1
XFILLER_58_16 VPWR VGND VPWR VGND sky130_ef_sc_hd__decap_12
X_5358_ _2501_ reg_file_inst.registry\[3\]\[2\] _2995_ VGND VGND VPWR VPWR _0701_
+ sky130_fd_sc_hd__mux2_1
XFILLER_101_221 VGND VGND VPWR VPWR sky130_fd_sc_hd__decap_3
XFILLER_87_433 VPWR VGND VPWR VGND sky130_ef_sc_hd__decap_12
XFILLER_59_113 VGND VGND VPWR VPWR sky130_fd_sc_hd__decap_8
X_4309_ _1392_ _2190_ net132 VGND VGND VPWR VPWR _2197_ sky130_fd_sc_hd__a21oi_1
XPHY_EDGE_ROW_113_Left_236 VGND VGND VPWR VPWR sky130_fd_sc_hd__decap_3
XFILLER_75_617 VPWR VGND VPWR VGND sky130_ef_sc_hd__decap_12
X_5289_ _2922_ reg_file_inst.registry\[2\]\[13\] _2993_ VGND VGND VPWR VPWR _0768_
+ sky130_fd_sc_hd__mux2_1
XFILLER_74_15 VPWR VGND VPWR VGND sky130_ef_sc_hd__decap_12
XFILLER_28_511 VGND VGND VPWR VPWR sky130_fd_sc_hd__decap_3
XFILLER_114_77 VGND VGND VPWR VPWR sky130_fd_sc_hd__decap_6
XFILLER_83_650 VPWR VGND VPWR VGND sky130_ef_sc_hd__decap_12
XFILLER_43_536 VGND VGND VPWR VPWR sky130_fd_sc_hd__decap_3
XFILLER_43_569 VGND VGND VPWR VPWR sky130_fd_sc_hd__decap_3
XTAP_TAPCELL_ROW_13_428 VGND VPWR sky130_fd_sc_hd__tapvpwrvgnd_1
XPHY_EDGE_ROW_122_Left_245 VGND VGND VPWR VPWR sky130_fd_sc_hd__decap_3
XFILLER_11_455 VPWR VGND VPWR VGND sky130_ef_sc_hd__decap_12
XFILLER_23_63 VPWR VGND VPWR VGND sky130_ef_sc_hd__decap_12
XFILLER_11_488 VGND VGND VPWR VPWR sky130_fd_sc_hd__decap_6
XFILLER_7_437 VGND VGND VPWR VPWR sky130_fd_sc_hd__decap_8
XFILLER_97_208 VPWR VGND VPWR VGND sky130_ef_sc_hd__decap_12
XFILLER_3_665 VGND VGND VPWR VPWR sky130_fd_sc_hd__decap_6
XFILLER_78_477 VGND VGND VPWR VPWR sky130_fd_sc_hd__decap_6
XFILLER_66_606 VGND VGND VPWR VPWR sky130_fd_sc_hd__fill_2
XFILLER_93_425 VGND VGND VPWR VPWR sky130_fd_sc_hd__decap_4
XFILLER_74_661 VGND VGND VPWR VPWR sky130_fd_sc_hd__decap_4
XFILLER_0_45 VGND VGND VPWR VPWR sky130_fd_sc_hd__fill_2
XFILLER_46_374 VGND VGND VPWR VPWR sky130_fd_sc_hd__decap_6
XFILLER_64_92 VPWR VGND VPWR VGND sky130_ef_sc_hd__decap_12
XFILLER_61_366 VGND VGND VPWR VPWR sky130_fd_sc_hd__fill_1
XTAP_TAPCELL_ROW_64_1061 VGND VPWR sky130_fd_sc_hd__tapvpwrvgnd_1
XFILLER_14_260 VGND VGND VPWR VPWR sky130_fd_sc_hd__decap_4
X_4660_ _2530_ _2531_ _1764_ VGND VGND VPWR VPWR _2533_ sky130_fd_sc_hd__mux2_1
XFILLER_80_80 VGND VGND VPWR VPWR sky130_fd_sc_hd__decap_4
X_3611_ reg_file_inst.registry\[3\]\[11\] _1140_ _1533_ _1537_ _1538_ VGND VGND VPWR
+ VPWR _1539_ sky130_fd_sc_hd__a2111o_1
XTAP_TAPCELL_ROW_40_770 VGND VPWR sky130_fd_sc_hd__tapvpwrvgnd_1
XTAP_TAPCELL_ROW_116_1714 VGND VPWR sky130_fd_sc_hd__tapvpwrvgnd_1
X_6330_ clknet_leaf_62_clk _0738_ _0263_ VGND VGND VPWR VPWR reg_file_inst.registry\[8\]\[11\]
+ sky130_fd_sc_hd__dfrtp_1
X_4591_ _1779_ _2286_ _2467_ _1764_ _2469_ VGND VGND VPWR VPWR _2470_ sky130_fd_sc_hd__a221o_1
X_3542_ reg_file_inst.registry\[3\]\[15\] _1091_ _1096_ reg_file_inst.registry\[11\]\[15\]
+ VGND VGND VPWR VPWR _1472_ sky130_fd_sc_hd__a22o_1
XFILLER_115_335 VGND VGND VPWR VPWR sky130_fd_sc_hd__fill_1
X_6261_ clknet_leaf_22_clk _0669_ _0194_ VGND VGND VPWR VPWR reg_file_inst.registry\[4\]\[26\]
+ sky130_fd_sc_hd__dfrtp_1
XFILLER_89_709 VPWR VGND VPWR VGND sky130_ef_sc_hd__decap_12
X_3473_ reg_file_inst.registry\[11\]\[17\] _1119_ net143 VGND VGND VPWR VPWR _1406_
+ sky130_fd_sc_hd__and3_1
X_5212_ reg_file_inst.registry\[11\]\[18\] _2501_ _2989_ VGND VGND VPWR VPWR _0841_
+ sky130_fd_sc_hd__mux2_1
X_6192_ clknet_leaf_1_clk _0600_ _0125_ VGND VGND VPWR VPWR reg_file_inst.registry\[5\]\[13\]
+ sky130_fd_sc_hd__dfrtp_1
X_5143_ net137 _2295_ _2518_ _2296_ VGND VGND VPWR VPWR _2966_ sky130_fd_sc_hd__a31o_1
XFILLER_111_541 VPWR VGND VPWR VGND sky130_ef_sc_hd__decap_12
XFILLER_57_617 VPWR VGND VPWR VGND sky130_ef_sc_hd__decap_12
XFILLER_29_308 VGND VGND VPWR VPWR sky130_fd_sc_hd__fill_1
XFILLER_111_585 VPWR VGND VPWR VGND sky130_ef_sc_hd__decap_12
XFILLER_96_285 VGND VGND VPWR VPWR sky130_fd_sc_hd__fill_1
X_5074_ _2323_ _2711_ _2811_ _2279_ _2906_ VGND VGND VPWR VPWR _2907_ sky130_fd_sc_hd__a221o_1
X_4025_ _1002_ _1018_ _1020_ VGND VGND VPWR VPWR _1941_ sky130_fd_sc_hd__or3b_1
XFILLER_25_503 VGND VGND VPWR VPWR sky130_fd_sc_hd__fill_1
XTAP_TAPCELL_ROW_48_870 VGND VPWR sky130_fd_sc_hd__tapvpwrvgnd_1
XFILLER_92_491 VGND VGND VPWR VPWR sky130_fd_sc_hd__decap_4
XFILLER_64_193 VGND VGND VPWR VPWR sky130_fd_sc_hd__decap_3
XFILLER_44_29 VGND VGND VPWR VPWR sky130_fd_sc_hd__fill_2
XFILLER_80_664 VGND VGND VPWR VPWR sky130_fd_sc_hd__decap_6
XFILLER_25_569 VGND VGND VPWR VPWR sky130_fd_sc_hd__fill_2
X_5976_ net148 VGND VGND VPWR VPWR _0384_ sky130_fd_sc_hd__inv_2
X_4927_ _1207_ _2123_ _2288_ _1219_ _2779_ VGND VGND VPWR VPWR _2780_ sky130_fd_sc_hd__a221o_1
X_4858_ reg_file_inst.registry\[7\]\[27\] _2715_ _2553_ VGND VGND VPWR VPWR _0902_
+ sky130_fd_sc_hd__mux2_1
X_3809_ reg_file_inst.registry\[1\]\[5\] _1087_ _1724_ _1726_ _1075_ VGND VGND VPWR
+ VPWR _1730_ sky130_fd_sc_hd__a2111o_1
XFILLER_119_641 VPWR VGND VPWR VGND sky130_ef_sc_hd__decap_12
X_4789_ _2646_ _2647_ VGND VGND VPWR VPWR _2648_ sky130_fd_sc_hd__nand2_1
XFILLER_20_285 VPWR VGND VPWR VGND sky130_ef_sc_hd__decap_12
XFILLER_119_685 VPWR VGND VPWR VGND sky130_ef_sc_hd__decap_12
XFILLER_109_55 VGND VGND VPWR VPWR sky130_fd_sc_hd__fill_1
X_6528_ clknet_leaf_48_clk _0936_ _0461_ VGND VGND VPWR VPWR net107 sky130_fd_sc_hd__dfrtp_1
XFILLER_118_195 VGND VGND VPWR VPWR sky130_fd_sc_hd__fill_1
XFILLER_106_357 VGND VGND VPWR VPWR sky130_fd_sc_hd__decap_6
X_6459_ clknet_leaf_43_clk _0867_ _0392_ VGND VGND VPWR VPWR reg_file_inst.registry\[0\]\[20\]
+ sky130_fd_sc_hd__dfrtp_2
XFILLER_121_305 VPWR VGND VPWR VGND sky130_ef_sc_hd__decap_12
XFILLER_121_349 VPWR VGND VPWR VGND sky130_ef_sc_hd__decap_12
XFILLER_0_635 VGND VGND VPWR VPWR sky130_fd_sc_hd__decap_8
XFILLER_87_274 VGND VGND VPWR VPWR sky130_fd_sc_hd__decap_6
XFILLER_75_447 VGND VGND VPWR VPWR sky130_fd_sc_hd__fill_1
XFILLER_63_609 VGND VGND VPWR VPWR sky130_fd_sc_hd__decap_6
XFILLER_90_428 VGND VGND VPWR VPWR sky130_fd_sc_hd__fill_2
XFILLER_90_417 VGND VGND VPWR VPWR sky130_fd_sc_hd__decap_3
XFILLER_56_683 VGND VGND VPWR VPWR sky130_fd_sc_hd__decap_4
XFILLER_55_160 VGND VGND VPWR VPWR sky130_fd_sc_hd__fill_1
XFILLER_16_514 VGND VGND VPWR VPWR sky130_fd_sc_hd__decap_6
XFILLER_18_74 VGND VGND VPWR VPWR sky130_fd_sc_hd__decap_6
XFILLER_28_363 VGND VGND VPWR VPWR sky130_fd_sc_hd__fill_1
XFILLER_83_480 VGND VGND VPWR VPWR sky130_fd_sc_hd__decap_4
XFILLER_70_141 VPWR VGND VPWR VGND sky130_ef_sc_hd__decap_12
XFILLER_31_517 VGND VGND VPWR VPWR sky130_fd_sc_hd__fill_2
XTAP_TAPCELL_ROW_100_1515 VGND VPWR sky130_fd_sc_hd__tapvpwrvgnd_1
XFILLER_70_185 VGND VGND VPWR VPWR sky130_fd_sc_hd__decap_8
XTAP_TAPCELL_ROW_26_586 VGND VPWR sky130_fd_sc_hd__tapvpwrvgnd_1
XFILLER_8_713 VGND VGND VPWR VPWR sky130_fd_sc_hd__decap_8
XFILLER_7_223 VGND VGND VPWR VPWR sky130_fd_sc_hd__fill_1
XFILLER_7_245 VGND VGND VPWR VPWR sky130_fd_sc_hd__fill_1
XFILLER_50_83 VGND VGND VPWR VPWR sky130_fd_sc_hd__fill_1
XFILLER_98_517 VPWR VGND VPWR VGND sky130_ef_sc_hd__decap_12
XTAP_TAPCELL_ROW_111_1655 VGND VPWR sky130_fd_sc_hd__tapvpwrvgnd_1
XFILLER_3_473 VPWR VGND VPWR VGND sky130_ef_sc_hd__decap_12
Xload_slew148 net44 VGND VGND VPWR VPWR net148 sky130_fd_sc_hd__clkbuf_16
XFILLER_94_701 VPWR VGND VPWR VGND sky130_ef_sc_hd__decap_12
XFILLER_66_403 VGND VGND VPWR VPWR sky130_fd_sc_hd__decap_6
XFILLER_39_617 VPWR VGND VPWR VGND sky130_ef_sc_hd__decap_12
XFILLER_93_200 VGND VGND VPWR VPWR sky130_fd_sc_hd__fill_1
XFILLER_66_425 VGND VGND VPWR VPWR sky130_fd_sc_hd__fill_1
XFILLER_93_233 VGND VGND VPWR VPWR sky130_fd_sc_hd__decap_3
XFILLER_81_428 VPWR VGND VPWR VGND sky130_ef_sc_hd__decap_12
XFILLER_81_417 VGND VGND VPWR VPWR sky130_fd_sc_hd__fill_2
XFILLER_19_374 VGND VGND VPWR VPWR sky130_fd_sc_hd__decap_3
XFILLER_62_642 VGND VGND VPWR VPWR sky130_fd_sc_hd__fill_2
X_5830_ net147 VGND VGND VPWR VPWR _0238_ sky130_fd_sc_hd__inv_2
XFILLER_34_344 VGND VGND VPWR VPWR sky130_fd_sc_hd__decap_8
XTAP_TAPCELL_ROW_122_1784 VGND VPWR sky130_fd_sc_hd__tapvpwrvgnd_1
XFILLER_62_697 VGND VGND VPWR VPWR sky130_fd_sc_hd__decap_3
X_5761_ net149 VGND VGND VPWR VPWR _0169_ sky130_fd_sc_hd__inv_2
XTAP_TAPCELL_ROW_122_1795 VGND VPWR sky130_fd_sc_hd__tapvpwrvgnd_1
XFILLER_91_90 VGND VGND VPWR VPWR sky130_fd_sc_hd__fill_2
X_4712_ _1195_ _2569_ VGND VGND VPWR VPWR _2571_ sky130_fd_sc_hd__and2_1
X_5692_ net44 VGND VGND VPWR VPWR _0100_ sky130_fd_sc_hd__inv_2
X_4643_ _1790_ _2395_ VGND VGND VPWR VPWR _2518_ sky130_fd_sc_hd__nor2_1
XTAP_TAPCELL_ROW_77_1230 VGND VPWR sky130_fd_sc_hd__tapvpwrvgnd_1
X_4574_ net38 _2117_ _2308_ net67 net101 VGND VGND VPWR VPWR _2454_ sky130_fd_sc_hd__a221o_1
X_6313_ clknet_leaf_35_clk _0721_ _0246_ VGND VGND VPWR VPWR reg_file_inst.registry\[3\]\[22\]
+ sky130_fd_sc_hd__dfrtp_1
X_3525_ _1451_ _1453_ _1454_ _1455_ VGND VGND VPWR VPWR _1456_ sky130_fd_sc_hd__or4_1
XFILLER_116_699 VGND VGND VPWR VPWR sky130_fd_sc_hd__fill_1
X_6244_ clknet_leaf_4_clk _0652_ _0177_ VGND VGND VPWR VPWR reg_file_inst.registry\[4\]\[9\]
+ sky130_fd_sc_hd__dfrtp_1
XFILLER_103_349 VPWR VGND VPWR VGND sky130_ef_sc_hd__decap_12
X_3456_ reg_file_inst.registry\[4\]\[16\] _1134_ _1136_ reg_file_inst.registry\[8\]\[16\]
+ VGND VGND VPWR VPWR _1390_ sky130_fd_sc_hd__a22o_1
X_6175_ clknet_leaf_29_clk _0583_ _0108_ VGND VGND VPWR VPWR JMPOFF\[24\] sky130_fd_sc_hd__dfrtp_4
X_3387_ _1244_ _1269_ _1296_ _1322_ VGND VGND VPWR VPWR _1323_ sky130_fd_sc_hd__or4_4
X_5126_ _1708_ _2950_ VGND VGND VPWR VPWR _2951_ sky130_fd_sc_hd__nor2_1
XFILLER_111_393 VPWR VGND VPWR VGND sky130_ef_sc_hd__decap_12
XFILLER_57_447 VGND VGND VPWR VPWR sky130_fd_sc_hd__fill_1
X_5057_ _1764_ _2234_ VGND VGND VPWR VPWR _2892_ sky130_fd_sc_hd__or2_1
XFILLER_38_650 VPWR VGND VPWR VGND sky130_ef_sc_hd__decap_12
XTAP_TAPCELL_ROW_88_1370 VGND VPWR sky130_fd_sc_hd__tapvpwrvgnd_1
XFILLER_84_277 VPWR VGND VPWR VGND sky130_ef_sc_hd__decap_12
XFILLER_72_417 VGND VGND VPWR VPWR sky130_fd_sc_hd__decap_3
XFILLER_55_39 VGND VGND VPWR VPWR sky130_fd_sc_hd__decap_4
XFILLER_44_119 VGND VGND VPWR VPWR sky130_fd_sc_hd__fill_2
X_4008_ _1893_ _1897_ _1923_ VGND VGND VPWR VPWR _1924_ sky130_fd_sc_hd__or3b_1
XFILLER_52_152 VGND VGND VPWR VPWR sky130_fd_sc_hd__decap_3
XFILLER_52_141 VGND VGND VPWR VPWR sky130_fd_sc_hd__fill_2
XFILLER_25_344 VPWR VGND VPWR VGND sky130_ef_sc_hd__decap_12
X_5959_ net147 VGND VGND VPWR VPWR _0367_ sky130_fd_sc_hd__inv_2
XFILLER_80_472 VGND VGND VPWR VPWR sky130_fd_sc_hd__decap_4
XFILLER_52_174 VGND VGND VPWR VPWR sky130_fd_sc_hd__decap_6
XFILLER_40_303 VGND VGND VPWR VPWR sky130_fd_sc_hd__decap_4
XTAP_TAPCELL_ROW_23_556 VGND VPWR sky130_fd_sc_hd__tapvpwrvgnd_1
XTAP_TAPCELL_ROW_51_898 VGND VPWR sky130_fd_sc_hd__tapvpwrvgnd_1
XFILLER_106_121 VPWR VGND VPWR VGND sky130_ef_sc_hd__decap_12
XFILLER_105_3 VPWR VGND VPWR VGND sky130_ef_sc_hd__decap_12
XFILLER_20_20 VGND VGND VPWR VPWR sky130_fd_sc_hd__decap_8
XFILLER_106_165 VPWR VGND VPWR VGND sky130_ef_sc_hd__decap_12
XFILLER_121_113 VPWR VGND VPWR VGND sky130_ef_sc_hd__decap_12
XFILLER_0_421 VGND VGND VPWR VPWR sky130_fd_sc_hd__decap_3
XFILLER_122_669 VGND VGND VPWR VPWR sky130_fd_sc_hd__decap_3
XFILLER_88_550 VGND VGND VPWR VPWR sky130_fd_sc_hd__fill_2
XFILLER_76_701 VPWR VGND VPWR VGND sky130_ef_sc_hd__decap_12
XFILLER_75_211 VGND VGND VPWR VPWR sky130_fd_sc_hd__fill_1
XFILLER_75_266 VPWR VGND VPWR VGND sky130_ef_sc_hd__decap_12
XTAP_TAPCELL_ROW_59_998 VGND VPWR sky130_fd_sc_hd__tapvpwrvgnd_1
XFILLER_28_160 VGND VGND VPWR VPWR sky130_fd_sc_hd__fill_1
XFILLER_71_472 VGND VGND VPWR VPWR sky130_fd_sc_hd__fill_1
XFILLER_16_377 VGND VGND VPWR VPWR sky130_fd_sc_hd__decap_8
XTAP_TAPCELL_ROW_61_1031 VGND VPWR sky130_fd_sc_hd__tapvpwrvgnd_1
XFILLER_84_8 VPWR VGND VPWR VGND sky130_ef_sc_hd__decap_12
XFILLER_8_510 VPWR VGND VPWR VGND sky130_ef_sc_hd__decap_12
XFILLER_8_587 VGND VGND VPWR VPWR sky130_fd_sc_hd__fill_1
XANTENNA_4 _1109_ VGND VGND VPWR VPWR sky130_fd_sc_hd__diode_2
X_3310_ MEMOFF\[22\] _1079_ _1083_ reg_file_inst.registry\[2\]\[22\] VGND VGND VPWR
+ VPWR _1249_ sky130_fd_sc_hd__a22o_1
XFILLER_6_77 VGND VGND VPWR VPWR sky130_fd_sc_hd__fill_1
X_4290_ _2140_ _2173_ _2137_ VGND VGND VPWR VPWR _2178_ sky130_fd_sc_hd__a21boi_2
X_3241_ reg_file_inst.registry\[7\]\[25\] _1086_ _1181_ _1182_ VGND VGND VPWR VPWR
+ _1183_ sky130_fd_sc_hd__a211o_1
XTAP_TAPCELL_ROW_72_1160 VGND VPWR sky130_fd_sc_hd__tapvpwrvgnd_1
X_3172_ net34 net36 net37 VGND VGND VPWR VPWR _1116_ sky130_fd_sc_hd__nor3_4
XFILLER_67_712 VGND VGND VPWR VPWR sky130_fd_sc_hd__decap_6
XFILLER_66_211 VPWR VGND VPWR VGND sky130_ef_sc_hd__decap_12
XFILLER_39_436 VPWR VGND VPWR VGND sky130_ef_sc_hd__decap_12
XFILLER_19_193 VGND VGND VPWR VPWR sky130_fd_sc_hd__fill_1
XFILLER_34_141 VPWR VGND VPWR VGND sky130_ef_sc_hd__decap_12
XFILLER_35_664 VGND VGND VPWR VPWR sky130_fd_sc_hd__fill_1
X_5813_ net149 VGND VGND VPWR VPWR _0221_ sky130_fd_sc_hd__inv_2
XFILLER_22_303 VGND VGND VPWR VPWR sky130_fd_sc_hd__decap_4
XFILLER_50_645 VPWR VGND VPWR VGND sky130_ef_sc_hd__decap_12
X_5744_ net147 VGND VGND VPWR VPWR _0152_ sky130_fd_sc_hd__inv_2
XTAP_TAPCELL_ROW_20_515 VGND VPWR sky130_fd_sc_hd__tapvpwrvgnd_1
X_5675_ net44 VGND VGND VPWR VPWR _0083_ sky130_fd_sc_hd__inv_2
XFILLER_30_380 VPWR VGND VPWR VGND sky130_ef_sc_hd__decap_12
XFILLER_108_419 VGND VGND VPWR VPWR sky130_fd_sc_hd__fill_1
X_4626_ reg_file_inst.registry\[11\]\[2\] _2501_ _2122_ VGND VGND VPWR VPWR _0917_
+ sky130_fd_sc_hd__mux2_1
X_4557_ _1721_ _2284_ _2437_ VGND VGND VPWR VPWR _2438_ sky130_fd_sc_hd__a21oi_1
XFILLER_104_625 VPWR VGND VPWR VGND sky130_ef_sc_hd__decap_12
XFILLER_103_113 VPWR VGND VPWR VGND sky130_ef_sc_hd__decap_12
X_3508_ reg_file_inst.registry\[15\]\[12\] _1122_ _1142_ reg_file_inst.registry\[1\]\[12\]
+ _1117_ VGND VGND VPWR VPWR _1440_ sky130_fd_sc_hd__a221o_1
X_4488_ _2352_ _2366_ _2313_ _2327_ VGND VGND VPWR VPWR _2373_ sky130_fd_sc_hd__a211o_1
XFILLER_104_669 VPWR VGND VPWR VGND sky130_ef_sc_hd__decap_12
X_3439_ reg_file_inst.registry\[9\]\[16\] _1089_ _1090_ reg_file_inst.registry\[8\]\[16\]
+ VGND VGND VPWR VPWR _1373_ sky130_fd_sc_hd__a22o_1
X_6227_ clknet_leaf_42_clk _0635_ _0160_ VGND VGND VPWR VPWR reg_file_inst.registry\[10\]\[20\]
+ sky130_fd_sc_hd__dfrtp_1
XFILLER_58_701 VGND VGND VPWR VPWR sky130_fd_sc_hd__decap_3
XFILLER_66_27 VGND VGND VPWR VPWR sky130_fd_sc_hd__fill_1
X_6158_ clknet_leaf_47_clk _0566_ _0091_ VGND VGND VPWR VPWR JMPOFF\[7\] sky130_fd_sc_hd__dfrtp_2
XFILLER_97_391 VGND VGND VPWR VPWR sky130_fd_sc_hd__fill_1
XFILLER_85_553 VGND VGND VPWR VPWR sky130_fd_sc_hd__decap_6
X_5109_ _2603_ _2604_ _2608_ _2624_ VGND VGND VPWR VPWR _2936_ sky130_fd_sc_hd__and4b_1
X_6089_ clknet_leaf_34_clk _0497_ _0022_ VGND VGND VPWR VPWR reg_file_inst.registry\[15\]\[22\]
+ sky130_fd_sc_hd__dfrtp_1
XTAP_TAPCELL_ROW_28_615 VGND VPWR sky130_fd_sc_hd__tapvpwrvgnd_1
XFILLER_72_236 VGND VGND VPWR VPWR sky130_fd_sc_hd__fill_2
XTAP_TAPCELL_ROW_56_968 VGND VPWR sky130_fd_sc_hd__tapvpwrvgnd_1
XTAP_TAPCELL_ROW_0_251 VGND VPWR sky130_fd_sc_hd__tapvpwrvgnd_1
XTAP_TAPCELL_ROW_0_262 VGND VPWR sky130_fd_sc_hd__tapvpwrvgnd_1
XFILLER_25_141 VGND VGND VPWR VPWR sky130_fd_sc_hd__decap_6
XFILLER_53_461 VPWR VGND VPWR VGND sky130_ef_sc_hd__decap_12
XFILLER_26_686 VPWR VGND VPWR VGND sky130_ef_sc_hd__decap_12
XFILLER_15_53 VGND VGND VPWR VPWR sky130_fd_sc_hd__decap_3
XFILLER_40_144 VPWR VGND VPWR VGND sky130_ef_sc_hd__decap_12
XFILLER_41_667 VGND VGND VPWR VPWR sky130_fd_sc_hd__decap_4
XFILLER_41_689 VGND VGND VPWR VPWR sky130_fd_sc_hd__fill_1
XFILLER_5_502 VGND VGND VPWR VPWR sky130_fd_sc_hd__fill_2
XFILLER_107_441 VGND VGND VPWR VPWR sky130_fd_sc_hd__decap_6
XFILLER_122_433 VPWR VGND VPWR VGND sky130_ef_sc_hd__decap_12
XFILLER_107_485 VPWR VGND VPWR VGND sky130_ef_sc_hd__decap_12
Xoutput52 net52 VGND VGND VPWR VPWR DataAddress[16] sky130_fd_sc_hd__buf_1
Xoutput85 net85 VGND VGND VPWR VPWR DataMemoryWrite[20] sky130_fd_sc_hd__buf_1
XTAP_TAPCELL_ROW_8_362 VGND VPWR sky130_fd_sc_hd__tapvpwrvgnd_1
Xoutput63 net63 VGND VGND VPWR VPWR DataAddress[26] sky130_fd_sc_hd__buf_1
Xoutput74 net74 VGND VGND VPWR VPWR DataMemoryWrite[10] sky130_fd_sc_hd__buf_1
XFILLER_122_477 VPWR VGND VPWR VGND sky130_ef_sc_hd__decap_12
XFILLER_0_251 VGND VGND VPWR VPWR sky130_fd_sc_hd__fill_1
Xoutput96 net96 VGND VGND VPWR VPWR DataMemoryWrite[5] sky130_fd_sc_hd__buf_1
XFILLER_49_723 VGND VGND VPWR VPWR sky130_fd_sc_hd__decap_3
XFILLER_76_531 VGND VGND VPWR VPWR sky130_fd_sc_hd__fill_1
XFILLER_0_284 VGND VGND VPWR VPWR sky130_fd_sc_hd__decap_8
XFILLER_48_222 VPWR VGND VPWR VGND sky130_ef_sc_hd__decap_12
XFILLER_76_586 VGND VGND VPWR VPWR sky130_fd_sc_hd__fill_2
XFILLER_64_715 VGND VGND VPWR VPWR sky130_fd_sc_hd__fill_1
XFILLER_91_556 VGND VGND VPWR VPWR sky130_fd_sc_hd__decap_4
XTAP_TAPCELL_ROW_106_1587 VGND VPWR sky130_fd_sc_hd__tapvpwrvgnd_1
XFILLER_16_163 VGND VGND VPWR VPWR sky130_fd_sc_hd__fill_2
XFILLER_44_461 VGND VGND VPWR VPWR sky130_fd_sc_hd__fill_1
X_3790_ reg_file_inst.registry\[7\]\[4\] _1119_ _1132_ VGND VGND VPWR VPWR _1712_
+ sky130_fd_sc_hd__and3_1
XFILLER_12_380 VPWR VGND VPWR VGND sky130_ef_sc_hd__decap_12
XFILLER_117_205 VPWR VGND VPWR VGND sky130_ef_sc_hd__decap_12
X_5460_ reg_file_inst.registry\[5\]\[16\] _2883_ _2999_ VGND VGND VPWR VPWR _0603_
+ sky130_fd_sc_hd__mux2_1
XFILLER_117_249 VPWR VGND VPWR VGND sky130_ef_sc_hd__decap_12
X_4411_ _1790_ net134 _2298_ VGND VGND VPWR VPWR _2299_ sky130_fd_sc_hd__and3_1
X_5391_ reg_file_inst.registry\[4\]\[27\] _2715_ _2997_ VGND VGND VPWR VPWR _0670_
+ sky130_fd_sc_hd__mux2_1
X_4342_ _2205_ _2206_ _1841_ VGND VGND VPWR VPWR _2230_ sky130_fd_sc_hd__mux2_1
X_4273_ _1826_ _2159_ VGND VGND VPWR VPWR _2161_ sky130_fd_sc_hd__xnor2_1
XFILLER_101_617 VPWR VGND VPWR VGND sky130_ef_sc_hd__decap_12
XFILLER_100_105 VPWR VGND VPWR VGND sky130_ef_sc_hd__decap_12
XFILLER_98_188 VGND VGND VPWR VPWR sky130_fd_sc_hd__decap_8
X_3224_ reg_file_inst.registry\[2\]\[26\] _1137_ _1142_ reg_file_inst.registry\[1\]\[26\]
+ VGND VGND VPWR VPWR _1167_ sky130_fd_sc_hd__a22o_1
X_6012_ net146 VGND VGND VPWR VPWR _0420_ sky130_fd_sc_hd__inv_2
.ends
